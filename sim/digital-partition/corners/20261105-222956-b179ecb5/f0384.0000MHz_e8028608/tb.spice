* digital-partition characterization deck body, f_clk = 384.0000 MHz (issue #619)
* DUT = design/sar_sequencer subckt + the top-level sky130_fd_sc_hd glue,
* both copied verbatim from the committed design/sar_adc_top.spice.
* one solver thread per unit: concurrent units on a shared runner must not oversubscribe it
.options num_threads=1
.global VPWR VGND
.include $PDK_ROOT/sky130A/libs.ref/sky130_fd_sc_hd/spice/sky130_fd_sc_hd.spice

* --- rails: Vdig is the digital-rail ammeter (positive current = into the + pin) ---
Vdig VPWR 0 DC 1.8
Vgnd VGND 0 DC 0

* --- stimulus (ideal; energy outside the DUT boundary) ---
VCLKU CLKU 0 PULSE(0 1 1.302083e-09 1.302083e-10 1.302083e-10 1.171875e-09 2.604167e-09)
BCLK CLK 0 V = v(CLKU)*v(VPWR)
VRSTU RSTU 0 PWL(0.000000e+00 0.000000e+00 1.093750e-08 0.000000e+00 1.106771e-08 1.000000e+00 1.391927e-07 1.000000e+00)
BRST RST_B 0 V = v(RSTU)*v(VPWR)
VCMPU CMPU 0 PWL(0.000000e+00 0.000000e+00 1.236979e-08 0.000000e+00 1.250000e-08 1.000000e+00 1.757813e-08 1.000000e+00 1.770833e-08 0.000000e+00 2.278646e-08 0.000000e+00 2.291667e-08 1.000000e+00 2.539062e-08 1.000000e+00 2.552083e-08 0.000000e+00 2.799479e-08 0.000000e+00 2.812500e-08 1.000000e+00 3.059896e-08 1.000000e+00 3.072917e-08 0.000000e+00 3.320312e-08 0.000000e+00 3.333333e-08 1.000000e+00 4.361979e-08 1.000000e+00 4.375000e-08 0.000000e+00 4.622396e-08 0.000000e+00 4.635417e-08 1.000000e+00 4.882812e-08 1.000000e+00 4.895833e-08 0.000000e+00 5.403646e-08 0.000000e+00 5.416667e-08 1.000000e+00 5.664062e-08 1.000000e+00 5.677083e-08 0.000000e+00 5.924479e-08 0.000000e+00 5.937500e-08 1.000000e+00 6.184896e-08 1.000000e+00 6.197917e-08 0.000000e+00 6.445312e-08 0.000000e+00 6.458333e-08 1.000000e+00 7.747396e-08 1.000000e+00 7.760417e-08 0.000000e+00 8.007812e-08 0.000000e+00 8.020833e-08 1.000000e+00 8.268229e-08 1.000000e+00 8.281250e-08 0.000000e+00 8.528646e-08 0.000000e+00 8.541667e-08 1.000000e+00 8.789062e-08 1.000000e+00 8.802083e-08 0.000000e+00 9.049479e-08 0.000000e+00 9.062500e-08 1.000000e+00 9.309896e-08 1.000000e+00 9.322917e-08 0.000000e+00 9.570312e-08 0.000000e+00 9.583333e-08 1.000000e+00 9.830729e-08 1.000000e+00 9.843750e-08 0.000000e+00 1.113281e-07 0.000000e+00 1.114583e-07 1.000000e+00 1.139323e-07 1.000000e+00 1.140625e-07 0.000000e+00 1.165365e-07 0.000000e+00 1.166667e-07 1.000000e+00 1.191406e-07 1.000000e+00 1.192708e-07 0.000000e+00 1.217448e-07 0.000000e+00 1.218750e-07 1.000000e+00 1.243490e-07 1.000000e+00 1.244792e-07 0.000000e+00 1.269531e-07 0.000000e+00 1.270833e-07 1.000000e+00 1.295573e-07 1.000000e+00 1.296875e-07 0.000000e+00 1.391927e-07 0.000000e+00)
BCMP COMP_OUT 0 V = v(CMPU)*v(VPWR)
* OUTN_NC is the comparator's OUTN output in the integrated ADC; here a fixed DC 0.
VOUTN OUTN_NC 0 DC 0

* --- DUT ---
xseq DOUT9 PH_B9 CLK PH_B8 DOUT8 RST_B PH_B7 DOUT7 COMP_OUT DOUT6 PH_B6 PH_B5 DOUT5 DOUT4 PH_B4 DOUT3 PH_B3 DOUT2 PH_B2 PH_B1 DOUT1 PH_B0 DOUT0 PH_EOC PH_SAMPLE BUSY sar_sequencer
.subckt sar_sequencer DOUT9 PH_B9 CLK PH_B8 DOUT8 RST_B PH_B7 DOUT7 COMP_OUT DOUT6 PH_B6 PH_B5 DOUT5 DOUT4 PH_B4 DOUT3 PH_B3 DOUT2 PH_B2 PH_B1 DOUT1 PH_B0 DOUT0 PH_EOC PH_SAMPLE BUSY
*.ipin CLK
*.ipin RST_B
*.ipin COMP_OUT
*.opin PH_B9
*.opin PH_B8
*.opin PH_B7
*.opin PH_B6
*.opin PH_B5
*.opin PH_B4
*.opin PH_B3
*.opin PH_B2
*.opin PH_B1
*.opin PH_B0
*.opin PH_EOC
*.opin PH_SAMPLE
*.opin BUSY
*.opin DOUT9
*.opin DOUT8
*.opin DOUT7
*.opin DOUT6
*.opin DOUT5
*.opin DOUT4
*.opin DOUT3
*.opin DOUT2
*.opin DOUT1
*.opin DOUT0
xringb9 CLK PH_SAMPLE RST_B VGND VGND VPWR VPWR PH_B9 sky130_fd_sc_hd__dfrtp_1
xringb8 CLK PH_B9 RST_B VGND VGND VPWR VPWR PH_B8 sky130_fd_sc_hd__dfrtp_1
xringb7 CLK PH_B8 RST_B VGND VGND VPWR VPWR PH_B7 sky130_fd_sc_hd__dfrtp_1
xringb6 CLK PH_B7 RST_B VGND VGND VPWR VPWR PH_B6 sky130_fd_sc_hd__dfrtp_1
xringb5 CLK PH_B6 RST_B VGND VGND VPWR VPWR PH_B5 sky130_fd_sc_hd__dfrtp_1
xringb4 CLK PH_B5 RST_B VGND VGND VPWR VPWR PH_B4 sky130_fd_sc_hd__dfrtp_1
xringb3 CLK PH_B4 RST_B VGND VGND VPWR VPWR PH_B3 sky130_fd_sc_hd__dfrtp_1
xringb2 CLK PH_B3 RST_B VGND VGND VPWR VPWR PH_B2 sky130_fd_sc_hd__dfrtp_1
xringb1 CLK PH_B2 RST_B VGND VGND VPWR VPWR PH_B1 sky130_fd_sc_hd__dfrtp_1
xringb0 CLK PH_B1 RST_B VGND VGND VPWR VPWR PH_B0 sky130_fd_sc_hd__dfrtp_1
xringeoc CLK PH_B0 RST_B VGND VGND VPWR VPWR PH_EOC sky130_fd_sc_hd__dfrtp_1
xor_g1 PH_B9 PH_B8 PH_B7 PH_B6 VGND VGND VPWR VPWR ORG1 sky130_fd_sc_hd__or4_1
xor_g2 PH_B5 PH_B4 PH_B3 PH_B2 VGND VGND VPWR VPWR ORG2 sky130_fd_sc_hd__or4_1
xor_g3 PH_B1 PH_B0 PH_EOC VGND VGND VPWR VPWR ORG3 sky130_fd_sc_hd__or3_1
xor_busy ORG1 ORG2 ORG3 VGND VGND VPWR VPWR BUSY sky130_fd_sc_hd__or3_1
xinv_sample BUSY VGND VGND VPWR VPWR PH_SAMPLE sky130_fd_sc_hd__inv_1
xor_g4 PH_B1 PH_B0 VGND VGND VPWR VPWR ORG4 sky130_fd_sc_hd__or2_1
xor_busybits ORG1 ORG2 ORG4 VGND VGND VPWR VPWR BUSY_BITS sky130_fd_sc_hd__or3_1
xmux9 DOUT9 COMP_OUT PH_B9 VGND VGND VPWR VPWR MUXOUT9 sky130_fd_sc_hd__mux2_1
xbreg9 CLK MUXOUT9 RST_B VGND VGND VPWR VPWR DOUT9 sky130_fd_sc_hd__dfrtp_1
xmux8 DOUT8 COMP_EFF PH_B8 VGND VGND VPWR VPWR MUXOUT8 sky130_fd_sc_hd__mux2_1
xbreg8 CLK DFEED8 RST_B VGND VGND VPWR VPWR DOUT8 sky130_fd_sc_hd__dfrtp_1
xmux7 DOUT7 COMP_EFF PH_B7 VGND VGND VPWR VPWR MUXOUT7 sky130_fd_sc_hd__mux2_1
xbreg7 CLK DFEED7 RST_B VGND VGND VPWR VPWR DOUT7 sky130_fd_sc_hd__dfrtp_1
xmux6 DOUT6 COMP_EFF PH_B6 VGND VGND VPWR VPWR MUXOUT6 sky130_fd_sc_hd__mux2_1
xbreg6 CLK DFEED6 RST_B VGND VGND VPWR VPWR DOUT6 sky130_fd_sc_hd__dfrtp_1
xmux5 DOUT5 COMP_EFF PH_B5 VGND VGND VPWR VPWR MUXOUT5 sky130_fd_sc_hd__mux2_1
xbreg5 CLK DFEED5 RST_B VGND VGND VPWR VPWR DOUT5 sky130_fd_sc_hd__dfrtp_1
xmux4 DOUT4 COMP_EFF PH_B4 VGND VGND VPWR VPWR MUXOUT4 sky130_fd_sc_hd__mux2_1
xbreg4 CLK DFEED4 RST_B VGND VGND VPWR VPWR DOUT4 sky130_fd_sc_hd__dfrtp_1
xmux3 DOUT3 COMP_EFF PH_B3 VGND VGND VPWR VPWR MUXOUT3 sky130_fd_sc_hd__mux2_1
xbreg3 CLK DFEED3 RST_B VGND VGND VPWR VPWR DOUT3 sky130_fd_sc_hd__dfrtp_1
xmux2 DOUT2 COMP_EFF PH_B2 VGND VGND VPWR VPWR MUXOUT2 sky130_fd_sc_hd__mux2_1
xbreg2 CLK DFEED2 RST_B VGND VGND VPWR VPWR DOUT2 sky130_fd_sc_hd__dfrtp_1
xmux1 DOUT1 COMP_EFF PH_B1 VGND VGND VPWR VPWR MUXOUT1 sky130_fd_sc_hd__mux2_1
xbreg1 CLK DFEED1 RST_B VGND VGND VPWR VPWR DOUT1 sky130_fd_sc_hd__dfrtp_1
xmux0 DOUT0 COMP_EFF PH_B0 VGND VGND VPWR VPWR MUXOUT0 sky130_fd_sc_hd__mux2_1
xbreg0 CLK DFEED0 RST_B VGND VGND VPWR VPWR DOUT0 sky130_fd_sc_hd__dfrtp_1
xxnor_compeff COMP_OUT DOUT9 VGND VGND VPWR VPWR COMP_EFF sky130_fd_sc_hd__xnor2_1
xpre8 MUXOUT8 PH_B9 VGND VGND VPWR VPWR PRESET8 sky130_fd_sc_hd__or2_1
xclr8 PRESET8 BUSY_BITS VGND VGND VPWR VPWR DFEED8 sky130_fd_sc_hd__and2_1
xpre7 MUXOUT7 PH_B8 VGND VGND VPWR VPWR PRESET7 sky130_fd_sc_hd__or2_1
xclr7 PRESET7 BUSY_BITS VGND VGND VPWR VPWR DFEED7 sky130_fd_sc_hd__and2_1
xpre6 MUXOUT6 PH_B7 VGND VGND VPWR VPWR PRESET6 sky130_fd_sc_hd__or2_1
xclr6 PRESET6 BUSY_BITS VGND VGND VPWR VPWR DFEED6 sky130_fd_sc_hd__and2_1
xpre5 MUXOUT5 PH_B6 VGND VGND VPWR VPWR PRESET5 sky130_fd_sc_hd__or2_1
xclr5 PRESET5 BUSY_BITS VGND VGND VPWR VPWR DFEED5 sky130_fd_sc_hd__and2_1
xpre4 MUXOUT4 PH_B5 VGND VGND VPWR VPWR PRESET4 sky130_fd_sc_hd__or2_1
xclr4 PRESET4 BUSY_BITS VGND VGND VPWR VPWR DFEED4 sky130_fd_sc_hd__and2_1
xpre3 MUXOUT3 PH_B4 VGND VGND VPWR VPWR PRESET3 sky130_fd_sc_hd__or2_1
xclr3 PRESET3 BUSY_BITS VGND VGND VPWR VPWR DFEED3 sky130_fd_sc_hd__and2_1
xpre2 MUXOUT2 PH_B3 VGND VGND VPWR VPWR PRESET2 sky130_fd_sc_hd__or2_1
xclr2 PRESET2 BUSY_BITS VGND VGND VPWR VPWR DFEED2 sky130_fd_sc_hd__and2_1
xpre1 MUXOUT1 PH_B2 VGND VGND VPWR VPWR PRESET1 sky130_fd_sc_hd__or2_1
xclr1 PRESET1 BUSY_BITS VGND VGND VPWR VPWR DFEED1 sky130_fd_sc_hd__and2_1
xpre0 MUXOUT0 PH_B1 VGND VGND VPWR VPWR PRESET0 sky130_fd_sc_hd__or2_1
xclr0 PRESET0 BUSY_BITS VGND VGND VPWR VPWR DFEED0 sky130_fd_sc_hd__and2_1
.ends
xinv_clkcap CLK VGND VGND VPWR VPWR CLKN sky130_fd_sc_hd__inv_1
xinv_dout9n DOUT9 VGND VGND VPWR VPWR DOUT9N sky130_fd_sc_hd__inv_1
xand_seln0 DOUT0 DOUT9N VGND VGND VPWR VPWR SELn0 sky130_fd_sc_hd__and2_1
xand_selp0 DOUT9 DOUT0 VGND VGND VPWR VPWR SELp0 sky130_fd_sc_hd__and2_1
xand_seln1 DOUT1 DOUT9N VGND VGND VPWR VPWR SELn1 sky130_fd_sc_hd__and2_1
xand_selp1 DOUT9 DOUT1 VGND VGND VPWR VPWR SELp1 sky130_fd_sc_hd__and2_1
xand_seln2 DOUT2 DOUT9N VGND VGND VPWR VPWR SELn2 sky130_fd_sc_hd__and2_1
xand_selp2 DOUT9 DOUT2 VGND VGND VPWR VPWR SELp2 sky130_fd_sc_hd__and2_1
xand_seln3 DOUT3 DOUT9N VGND VGND VPWR VPWR SELn3 sky130_fd_sc_hd__and2_1
xand_selp3 DOUT9 DOUT3 VGND VGND VPWR VPWR SELp3 sky130_fd_sc_hd__and2_1
xand_seln4 DOUT4 DOUT9N VGND VGND VPWR VPWR SELn4 sky130_fd_sc_hd__and2_1
xand_selp4 DOUT9 DOUT4 VGND VGND VPWR VPWR SELp4 sky130_fd_sc_hd__and2_1
xand_seln5 DOUT5 DOUT9N VGND VGND VPWR VPWR SELn5 sky130_fd_sc_hd__and2_1
xand_selp5 DOUT9 DOUT5 VGND VGND VPWR VPWR SELp5 sky130_fd_sc_hd__and2_1
xand_seln6 DOUT6 DOUT9N VGND VGND VPWR VPWR SELn6 sky130_fd_sc_hd__and2_1
xand_selp6 DOUT9 DOUT6 VGND VGND VPWR VPWR SELp6 sky130_fd_sc_hd__and2_1
xand_seln7 DOUT7 DOUT9N VGND VGND VPWR VPWR SELn7 sky130_fd_sc_hd__and2_1
xand_selp7 DOUT9 DOUT7 VGND VGND VPWR VPWR SELp7 sky130_fd_sc_hd__and2_1
xand_seln8 DOUT8 DOUT9N VGND VGND VPWR VPWR SELn8 sky130_fd_sc_hd__and2_1
xand_selp8 DOUT9 DOUT8 VGND VGND VPWR VPWR SELp8 sky130_fd_sc_hd__and2_1
xxor_code0 DOUT0 DOUT9N VGND VGND VPWR VPWR ADCOUT0 sky130_fd_sc_hd__xor2_1
xxor_code1 DOUT1 DOUT9N VGND VGND VPWR VPWR ADCOUT1 sky130_fd_sc_hd__xor2_1
xxor_code2 DOUT2 DOUT9N VGND VGND VPWR VPWR ADCOUT2 sky130_fd_sc_hd__xor2_1
xxor_code3 DOUT3 DOUT9N VGND VGND VPWR VPWR ADCOUT3 sky130_fd_sc_hd__xor2_1
xxor_code4 DOUT4 DOUT9N VGND VGND VPWR VPWR ADCOUT4 sky130_fd_sc_hd__xor2_1
xxor_code5 DOUT5 DOUT9N VGND VGND VPWR VPWR ADCOUT5 sky130_fd_sc_hd__xor2_1
xxor_code6 DOUT6 DOUT9N VGND VGND VPWR VPWR ADCOUT6 sky130_fd_sc_hd__xor2_1
xxor_code7 DOUT7 DOUT9N VGND VGND VPWR VPWR ADCOUT7 sky130_fd_sc_hd__xor2_1
xxor_code8 DOUT8 DOUT9N VGND VGND VPWR VPWR ADCOUT8 sky130_fd_sc_hd__xor2_1
xdum_mux_n DOUT9 OUTN_NC PH_B9 VGND VGND VPWR VPWR DUMLOAD_MUX_NC sky130_fd_sc_hd__mux2_1
xdum_xnor_n OUTN_NC DOUT9 VGND VGND VPWR VPWR DUMLOAD_XNOR_NC sky130_fd_sc_hd__xnor2_1
xand_halflsb PH_B9 BUSY VGND VGND VPWR VPWR HALF_LSB_EN sky130_fd_sc_hd__and2b_1
xinv_halflsb HALF_LSB_EN VGND VGND VPWR VPWR HALF_LSB_ENN sky130_fd_sc_hd__inv_1

* --- declared interface loads (experiment assumptions, see digital_char.LOADS_F) ---
Cld1 PH_SAMPLE 0 2.0000e-14
Cld2 PH_B9 0 5.0000e-15
Cld3 PH_B8 0 5.0000e-15
Cld4 PH_B7 0 5.0000e-15
Cld5 PH_B6 0 5.0000e-15
Cld6 PH_B5 0 5.0000e-15
Cld7 PH_B4 0 5.0000e-15
Cld8 PH_B3 0 5.0000e-15
Cld9 PH_B2 0 5.0000e-15
Cld10 PH_B1 0 5.0000e-15
Cld11 PH_B0 0 5.0000e-15
Cld12 PH_EOC 0 5.0000e-15
Cld13 BUSY 0 5.0000e-15
Cld14 DOUT0 0 5.0000e-15
Cld15 DOUT1 0 5.0000e-15
Cld16 DOUT2 0 5.0000e-15
Cld17 DOUT3 0 5.0000e-15
Cld18 DOUT4 0 5.0000e-15
Cld19 DOUT5 0 5.0000e-15
Cld20 DOUT6 0 5.0000e-15
Cld21 DOUT7 0 5.0000e-15
Cld22 DOUT8 0 5.0000e-15
Cld23 DOUT9 0 5.0000e-15
Cld24 SELn0 0 2.0000e-14
Cld25 SELp0 0 2.0000e-14
Cld26 ADCOUT0 0 1.0000e-14
Cld27 SELn1 0 2.0000e-14
Cld28 SELp1 0 2.0000e-14
Cld29 ADCOUT1 0 1.0000e-14
Cld30 SELn2 0 2.0000e-14
Cld31 SELp2 0 2.0000e-14
Cld32 ADCOUT2 0 1.0000e-14
Cld33 SELn3 0 2.0000e-14
Cld34 SELp3 0 2.0000e-14
Cld35 ADCOUT3 0 1.0000e-14
Cld36 SELn4 0 2.0000e-14
Cld37 SELp4 0 2.0000e-14
Cld38 ADCOUT4 0 1.0000e-14
Cld39 SELn5 0 2.0000e-14
Cld40 SELp5 0 2.0000e-14
Cld41 ADCOUT5 0 1.0000e-14
Cld42 SELn6 0 2.0000e-14
Cld43 SELp6 0 2.0000e-14
Cld44 ADCOUT6 0 1.0000e-14
Cld45 SELn7 0 2.0000e-14
Cld46 SELp7 0 2.0000e-14
Cld47 ADCOUT7 0 1.0000e-14
Cld48 SELn8 0 2.0000e-14
Cld49 SELp8 0 2.0000e-14
Cld50 ADCOUT8 0 1.0000e-14
Cld51 CLKN 0 5.0000e-14
Cld52 HALF_LSB_EN 0 2.0000e-14
Cld53 HALF_LSB_ENN 0 2.0000e-14

* --- behavioural monitors (high impedance; they load nothing) ---
.func h(x) '0.5*(1+tanh(((x)-0.5*v(VPWR))/0.05))'
BPCODE PCODE 0 V = 1*h(v(PH_SAMPLE)) + 2*h(v(PH_B9)) + 4*h(v(PH_B8)) + 8*h(v(PH_B7)) + 16*h(v(PH_B6)) + 32*h(v(PH_B5)) + 64*h(v(PH_B4)) + 128*h(v(PH_B3)) + 256*h(v(PH_B2)) + 512*h(v(PH_B1)) + 1024*h(v(PH_B0)) + 2048*h(v(PH_EOC))
BCTL CTLCODE 0 V = 1*h(v(BUSY)) + 2*h(v(HALF_LSB_EN)) + 4*h(v(HALF_LSB_ENN))
BDCODE DCODE 0 V = 1*h(v(DOUT0)) + 2*h(v(DOUT1)) + 4*h(v(DOUT2)) + 8*h(v(DOUT3)) + 16*h(v(DOUT4)) + 32*h(v(DOUT5)) + 64*h(v(DOUT6)) + 128*h(v(DOUT7)) + 256*h(v(DOUT8)) + 512*h(v(DOUT9))
BADC ADCCODE 0 V = 1*h(v(ADCOUT0)) + 2*h(v(ADCOUT1)) + 4*h(v(ADCOUT2)) + 8*h(v(ADCOUT3)) + 16*h(v(ADCOUT4)) + 32*h(v(ADCOUT5)) + 64*h(v(ADCOUT6)) + 128*h(v(ADCOUT7)) + 256*h(v(ADCOUT8))
BSELN SELNCODE 0 V = 1*h(v(SELn0)) + 2*h(v(SELn1)) + 4*h(v(SELn2)) + 8*h(v(SELn3)) + 16*h(v(SELn4)) + 32*h(v(SELn5)) + 64*h(v(SELn6)) + 128*h(v(SELn7)) + 256*h(v(SELn8))
BSELP SELPCODE 0 V = 1*h(v(SELp0)) + 2*h(v(SELp1)) + 4*h(v(SELp2)) + 8*h(v(SELp3)) + 16*h(v(SELp4)) + 32*h(v(SELp5)) + 64*h(v(SELp6)) + 128*h(v(SELp7)) + 256*h(v(SELp8))
