* sim/sar-sequencer-behavioral -- `klt sim` row-evidence deck body
* (issue #1023). Assembled by
* sim/sar-sequencer-behavioral/run_testbench.py --klt-row-evidence.
* Circuit body only: klt sim supplies the .lib corner section, .temp,
* the .meas cards, the .tran analysis and the .control wrapper. The DUT
* and stimulus are this campaign's own (design/sar_sequencer.sch
* netlisted fresh; testbench/sar_sequencer_tb_fragment.spice devices
* verbatim), plus the margin helpers named below.
* One solver thread per unit: concurrent units on a shared runner must
* not oversubscribe it (the same card sim/digital-partition/ carries).
.options num_threads=1
.param vdd_val = 1.8
.include $PDK_ROOT/sky130A/libs.ref/sky130_fd_sc_hd/spice/sky130_fd_sc_hd.spice

**.subckt sar_sequencer DOUT9 PH_B9 CLK PH_B8 DOUT8 RST_B PH_B7 DOUT7 COMP_OUT DOUT6 PH_B6 PH_B5 DOUT5 DOUT4 PH_B4 DOUT3 PH_B3
*+ DOUT2 PH_B2 PH_B1 DOUT1 PH_B0 DOUT0 PH_EOC PH_SAMPLE BUSY
*.ipin CLK
*.ipin RST_B
*.ipin COMP_OUT
*.opin PH_B9
*.opin PH_B8
*.opin PH_B7
*.opin PH_B6
*.opin PH_B5
*.opin PH_B4
*.opin PH_B3
*.opin PH_B2
*.opin PH_B1
*.opin PH_B0
*.opin PH_EOC
*.opin PH_SAMPLE
*.opin BUSY
*.opin DOUT9
*.opin DOUT8
*.opin DOUT7
*.opin DOUT6
*.opin DOUT5
*.opin DOUT4
*.opin DOUT3
*.opin DOUT2
*.opin DOUT1
*.opin DOUT0
xringb9 CLK PH_SAMPLE RST_B VGND VGND VPWR VPWR PH_B9 sky130_fd_sc_hd__dfrtp_1
xringb8 CLK PH_B9 RST_B VGND VGND VPWR VPWR PH_B8 sky130_fd_sc_hd__dfrtp_1
xringb7 CLK PH_B8 RST_B VGND VGND VPWR VPWR PH_B7 sky130_fd_sc_hd__dfrtp_1
xringb6 CLK PH_B7 RST_B VGND VGND VPWR VPWR PH_B6 sky130_fd_sc_hd__dfrtp_1
xringb5 CLK PH_B6 RST_B VGND VGND VPWR VPWR PH_B5 sky130_fd_sc_hd__dfrtp_1
xringb4 CLK PH_B5 RST_B VGND VGND VPWR VPWR PH_B4 sky130_fd_sc_hd__dfrtp_1
xringb3 CLK PH_B4 RST_B VGND VGND VPWR VPWR PH_B3 sky130_fd_sc_hd__dfrtp_1
xringb2 CLK PH_B3 RST_B VGND VGND VPWR VPWR PH_B2 sky130_fd_sc_hd__dfrtp_1
xringb1 CLK PH_B2 RST_B VGND VGND VPWR VPWR PH_B1 sky130_fd_sc_hd__dfrtp_1
xringb0 CLK PH_B1 RST_B VGND VGND VPWR VPWR PH_B0 sky130_fd_sc_hd__dfrtp_1
xringeoc CLK PH_B0 RST_B VGND VGND VPWR VPWR PH_EOC sky130_fd_sc_hd__dfrtp_1
xor_g1 PH_B9 PH_B8 PH_B7 PH_B6 VGND VGND VPWR VPWR ORG1 sky130_fd_sc_hd__or4_1
xor_g2 PH_B5 PH_B4 PH_B3 PH_B2 VGND VGND VPWR VPWR ORG2 sky130_fd_sc_hd__or4_1
xor_g3 PH_B1 PH_B0 PH_EOC VGND VGND VPWR VPWR ORG3 sky130_fd_sc_hd__or3_1
xor_busy ORG1 ORG2 ORG3 VGND VGND VPWR VPWR BUSY sky130_fd_sc_hd__or3_1
xinv_sample BUSY VGND VGND VPWR VPWR PH_SAMPLE sky130_fd_sc_hd__inv_1
xor_g4 PH_B1 PH_B0 VGND VGND VPWR VPWR ORG4 sky130_fd_sc_hd__or2_1
xor_busybits ORG1 ORG2 ORG4 VGND VGND VPWR VPWR BUSY_BITS sky130_fd_sc_hd__or3_1
xmux9 DOUT9 COMP_OUT PH_B9 VGND VGND VPWR VPWR MUXOUT9 sky130_fd_sc_hd__mux2_1
xbreg9 CLK MUXOUT9 RST_B VGND VGND VPWR VPWR DOUT9 sky130_fd_sc_hd__dfrtp_1
xmux8 DOUT8 COMP_EFF PH_B8 VGND VGND VPWR VPWR MUXOUT8 sky130_fd_sc_hd__mux2_1
xbreg8 CLK DFEED8 RST_B VGND VGND VPWR VPWR DOUT8 sky130_fd_sc_hd__dfrtp_1
xmux7 DOUT7 COMP_EFF PH_B7 VGND VGND VPWR VPWR MUXOUT7 sky130_fd_sc_hd__mux2_1
xbreg7 CLK DFEED7 RST_B VGND VGND VPWR VPWR DOUT7 sky130_fd_sc_hd__dfrtp_1
xmux6 DOUT6 COMP_EFF PH_B6 VGND VGND VPWR VPWR MUXOUT6 sky130_fd_sc_hd__mux2_1
xbreg6 CLK DFEED6 RST_B VGND VGND VPWR VPWR DOUT6 sky130_fd_sc_hd__dfrtp_1
xmux5 DOUT5 COMP_EFF PH_B5 VGND VGND VPWR VPWR MUXOUT5 sky130_fd_sc_hd__mux2_1
xbreg5 CLK DFEED5 RST_B VGND VGND VPWR VPWR DOUT5 sky130_fd_sc_hd__dfrtp_1
xmux4 DOUT4 COMP_EFF PH_B4 VGND VGND VPWR VPWR MUXOUT4 sky130_fd_sc_hd__mux2_1
xbreg4 CLK DFEED4 RST_B VGND VGND VPWR VPWR DOUT4 sky130_fd_sc_hd__dfrtp_1
xmux3 DOUT3 COMP_EFF PH_B3 VGND VGND VPWR VPWR MUXOUT3 sky130_fd_sc_hd__mux2_1
xbreg3 CLK DFEED3 RST_B VGND VGND VPWR VPWR DOUT3 sky130_fd_sc_hd__dfrtp_1
xmux2 DOUT2 COMP_EFF PH_B2 VGND VGND VPWR VPWR MUXOUT2 sky130_fd_sc_hd__mux2_1
xbreg2 CLK DFEED2 RST_B VGND VGND VPWR VPWR DOUT2 sky130_fd_sc_hd__dfrtp_1
xmux1 DOUT1 COMP_EFF PH_B1 VGND VGND VPWR VPWR MUXOUT1 sky130_fd_sc_hd__mux2_1
xbreg1 CLK DFEED1 RST_B VGND VGND VPWR VPWR DOUT1 sky130_fd_sc_hd__dfrtp_1
xmux0 DOUT0 COMP_EFF PH_B0 VGND VGND VPWR VPWR MUXOUT0 sky130_fd_sc_hd__mux2_1
xbreg0 CLK DFEED0 RST_B VGND VGND VPWR VPWR DOUT0 sky130_fd_sc_hd__dfrtp_1
xxnor_compeff COMP_OUT DOUT9 VGND VGND VPWR VPWR COMP_EFF sky130_fd_sc_hd__xnor2_1
xpre8 MUXOUT8 PH_B9 VGND VGND VPWR VPWR PRESET8 sky130_fd_sc_hd__or2_1
xclr8 PRESET8 BUSY_BITS VGND VGND VPWR VPWR DFEED8 sky130_fd_sc_hd__and2_1
xpre7 MUXOUT7 PH_B8 VGND VGND VPWR VPWR PRESET7 sky130_fd_sc_hd__or2_1
xclr7 PRESET7 BUSY_BITS VGND VGND VPWR VPWR DFEED7 sky130_fd_sc_hd__and2_1
xpre6 MUXOUT6 PH_B7 VGND VGND VPWR VPWR PRESET6 sky130_fd_sc_hd__or2_1
xclr6 PRESET6 BUSY_BITS VGND VGND VPWR VPWR DFEED6 sky130_fd_sc_hd__and2_1
xpre5 MUXOUT5 PH_B6 VGND VGND VPWR VPWR PRESET5 sky130_fd_sc_hd__or2_1
xclr5 PRESET5 BUSY_BITS VGND VGND VPWR VPWR DFEED5 sky130_fd_sc_hd__and2_1
xpre4 MUXOUT4 PH_B5 VGND VGND VPWR VPWR PRESET4 sky130_fd_sc_hd__or2_1
xclr4 PRESET4 BUSY_BITS VGND VGND VPWR VPWR DFEED4 sky130_fd_sc_hd__and2_1
xpre3 MUXOUT3 PH_B4 VGND VGND VPWR VPWR PRESET3 sky130_fd_sc_hd__or2_1
xclr3 PRESET3 BUSY_BITS VGND VGND VPWR VPWR DFEED3 sky130_fd_sc_hd__and2_1
xpre2 MUXOUT2 PH_B3 VGND VGND VPWR VPWR PRESET2 sky130_fd_sc_hd__or2_1
xclr2 PRESET2 BUSY_BITS VGND VGND VPWR VPWR DFEED2 sky130_fd_sc_hd__and2_1
xpre1 MUXOUT1 PH_B2 VGND VGND VPWR VPWR PRESET1 sky130_fd_sc_hd__or2_1
xclr1 PRESET1 BUSY_BITS VGND VGND VPWR VPWR DFEED1 sky130_fd_sc_hd__and2_1
xpre0 MUXOUT0 PH_B1 VGND VGND VPWR VPWR PRESET0 sky130_fd_sc_hd__or2_1
xclr0 PRESET0 BUSY_BITS VGND VGND VPWR VPWR DFEED0 sky130_fd_sc_hd__and2_1
**.ends

* sar_sequencer_tb_fragment.spice -- standalone behavioral testbench
* fragment for design/sar_sequencer.sch (issue #55). Devices/sources only;
* sim/sar-sequencer-behavioral/run_testbench.py supplies the model .lib,
* the sky130_fd_sc_hd combined-cell .include, the freshly-netlisted DUT
* body, and the closing .end -- see that script and sim/README.md
* 'Divergence from the shared PVT/MC harness' note in this experiment's
* own record for why this experiment does not go through
* sim/run_corners.py (that harness's .control block only supports .op
* analysis; this is a transient/digital sequencing check).
*
* Drives an IDEAL comparator-decision stimulus (COMP_OUT) against the
* DUT's CLK/RST_B inputs and exercises two full back-to-back conversions
* with two different fixed target codes, proving MSB-first bit-by-bit
* capture, phase timing, and the ring sequencer's auto-restart.
*
* CLK: 100 ns period (f_clk=10 MHz; DR-006's derived provisional range is
* 1.2-12 MHz). RST_B releases at t=220 ns (before the first rising edge
* at t=250 ns).
* Cycle 1 target code (b9..b0) = 1100101011b = 811 decimal
* Cycle 2 target code (b9..b0) = 0011010100b = 212 decimal
*
* UPDATE (#263): design/sar_sequencer.sch now derives each bit-8..0
* decision from COMP_EFF = XNOR(COMP_OUT, DOUT9), not raw COMP_OUT --
* DOUT9 (this design's free sign bit, decided first with no trial
* perturbation, unaffected by this change) selects which single CDAC side
* each subsequent bit's trial perturbation switches (design/sar_adc_top.sch),
* and the comparator's fixed polarity means "keep the trial" is COMP_OUT=1
* for the DOUT9=1 branch but COMP_OUT=0 for the DOUT9=0 branch -- see
* design/sar_sequencer.sch's own "COMP_EFF" header comment for the full
* derivation. Cycle 1's target code has b9=1, so COMP_EFF=COMP_OUT
* (passthrough) throughout cycle 1 and its stimulus below is UNCHANGED
* (bit i's driven COMP_OUT level already equals its target bit, exactly as
* before this issue). Cycle 2's target code has b9=0, so COMP_EFF=NOT
* (COMP_OUT) for its bit8..0 windows: the driven COMP_OUT level for each of
* those nine windows is the CODE2 target bit INVERTED (bit9's own window is
* unaffected, same direct-capture convention as cycle 1's). EXPECTED_BITS
* in run_testbench.py is unchanged by this -- it still asserts the CODE1/
* CODE2 TARGET values; only what COMP_OUT must be DRIVEN AT to produce that
* target under the new decision-directed logic changed here.
*
* Rail-referenced via the {vdd_val} .param (issue #28's PVT corner
* campaign): the caller (sim/sar-sequencer-behavioral/run_testbench.py)
* supplies `.param vdd_val = <supply_v>` ahead of this fragment so the
* supply axis of the ratified corner set (-40/27/125C, +-10% of 1.8V,
* sky130 process corners -- spec/target-spec.md) can be swept without
* editing this file per corner point.

VVPWR VPWR 0 DC {vdd_val}
VVGND VGND 0 DC 0

VCLK CLK 0 PULSE(0 {vdd_val} 50n 1n 1n 50n 100n)
VRSTB RST_B 0 PWL(0 0 219n 0 221n {vdd_val} 2700n {vdd_val})
VCOMP COMP_OUT 0 PWL(0.0n 0.00 269.9n 0.00 270.1n {vdd_val} 369.9n {vdd_val} 370.1n {vdd_val} 469.9n {vdd_val} 470.1n 0.00 569.9n 0.00 570.1n 0.00 669.9n 0.00 670.1n {vdd_val} 769.9n {vdd_val} 770.1n 0.00 869.9n 0.00 870.1n {vdd_val} 969.9n {vdd_val} 970.1n 0.00 1069.9n 0.00 1070.1n {vdd_val} 1169.9n {vdd_val} 1170.1n {vdd_val} 1469.9n {vdd_val} 1470.1n 0.00 1569.9n 0.00 1570.1n {vdd_val} 1669.9n {vdd_val} 1670.1n 0.00 1769.9n 0.00 1770.1n 0.00 1869.9n 0.00 1870.1n {vdd_val} 1969.9n {vdd_val} 1970.1n 0.00 2069.9n 0.00 2070.1n {vdd_val} 2169.9n {vdd_val} 2170.1n 0.00 2269.9n 0.00 2270.1n {vdd_val} 2369.9n {vdd_val} 2370.1n {vdd_val} 2700.0n {vdd_val})

* --- cycle 1: full phase-timing coverage + all 10 captured bits ---

* --- cycle 2: abbreviated phase coverage (proves auto-restart timing) ---
* --- + all 10 captured bits (proves a DIFFERENT code converts correctly) ---

* --- testbench-only half-rail margin helpers (issue #1023; NOT DUT
* devices): each node's signed distance from half the rail, so a
* static `klt sim` limit can express `sample > half the rail at this
* corner's own supply` as `margin > 0`. The runner's Python rule this
* mirrors is run_corner_campaign()'s digital_threshold_v comparison.
Bm_dout0 dout0_hf 0 V = v(dout0) - 0.5*v(VPWR)
Bm_dout1 dout1_hf 0 V = v(dout1) - 0.5*v(VPWR)
Bm_dout2 dout2_hf 0 V = v(dout2) - 0.5*v(VPWR)
Bm_dout3 dout3_hf 0 V = v(dout3) - 0.5*v(VPWR)
Bm_dout4 dout4_hf 0 V = v(dout4) - 0.5*v(VPWR)
Bm_dout5 dout5_hf 0 V = v(dout5) - 0.5*v(VPWR)
Bm_dout6 dout6_hf 0 V = v(dout6) - 0.5*v(VPWR)
Bm_dout7 dout7_hf 0 V = v(dout7) - 0.5*v(VPWR)
Bm_dout8 dout8_hf 0 V = v(dout8) - 0.5*v(VPWR)
Bm_dout9 dout9_hf 0 V = v(dout9) - 0.5*v(VPWR)
Bm_ph_b0 ph_b0_hf 0 V = v(ph_b0) - 0.5*v(VPWR)
Bm_ph_b1 ph_b1_hf 0 V = v(ph_b1) - 0.5*v(VPWR)
Bm_ph_b2 ph_b2_hf 0 V = v(ph_b2) - 0.5*v(VPWR)
Bm_ph_b3 ph_b3_hf 0 V = v(ph_b3) - 0.5*v(VPWR)
Bm_ph_b4 ph_b4_hf 0 V = v(ph_b4) - 0.5*v(VPWR)
Bm_ph_b5 ph_b5_hf 0 V = v(ph_b5) - 0.5*v(VPWR)
Bm_ph_b6 ph_b6_hf 0 V = v(ph_b6) - 0.5*v(VPWR)
Bm_ph_b7 ph_b7_hf 0 V = v(ph_b7) - 0.5*v(VPWR)
Bm_ph_b8 ph_b8_hf 0 V = v(ph_b8) - 0.5*v(VPWR)
Bm_ph_b9 ph_b9_hf 0 V = v(ph_b9) - 0.5*v(VPWR)
Bm_ph_eoc ph_eoc_hf 0 V = v(ph_eoc) - 0.5*v(VPWR)
Bm_ph_sample ph_sample_hf 0 V = v(ph_sample) - 0.5*v(VPWR)
