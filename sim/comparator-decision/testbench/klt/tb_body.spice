* comparator-decision input-referred noise -- klt sim deck BODY (issue #1014).
*
* Netlist FRAGMENT: `klt sim` supplies the .lib corner section, .temp, the
* per-corner .param vdd_val override, and the .control block that runs the
* .noise analysis and the measurements. This file carries only the circuit.
*
* METHOD: UNCHANGED from sim/comparator-decision/comparator_campaigns/noise.py
* (issue #28's campaign, record 20260827-212404-e13bc1e), which this deck
* transcribes device-for-device and value-for-value so the two routes run the
* same experiment:
*   - reduced sub-model of the INTEGRATION phase (DR-004 Amendment A, issue
*     #175): tail + input pair, with the DI-node precharge PMOS pair
*     diode-connected (self-biased) as the loads on the input pair's own
*     drain nodes DIP/DIN, and the cross-coupled latch pairs omitted because
*     they are off (Vgs ~ 0) until regeneration begins; CLK held at VDD
*     (steady evaluate bias, tail on); noise taken at v(DIP,DIN).
*   - AC stimulus single-ended on Vinp (AC 1); ngspice's input-referred
*     noise is therefore SINGLE-ENDED; the differential figure is
*     sqrt(2) x single-ended (the diff-pair noise-doubling identity, applied
*     as a named, flagged approximation per DR-003 Item 4's deferral).
*   - band 1 kHz .. 1 GHz (NOISE_FSTART_HZ/NOISE_FSTOP_HZ in
*     comparator_campaigns/common.py; the regeneration-time-constant order
*     of magnitude -- see run.py's module docstring for the derivation).
*   - ngspice's KLU solver does not support .noise analysis; the request's
*     options.ngspice_init selects `option sparse` for this run (the same
*     switch noise.py makes at runtime over the repo-wide `option klu`).
*
* The device lines below are the campaign's own five devices, verbatim
* (sky130_fd_pr__nfet_01v8 tail W=8, input pair W=4, diode-connected
* sky130_fd_pr__pfet_01v8 loads W=4, all L=0.5, nf=1), at the corner's own
* supply point: vdd_val is the per-corner .param klt sim injects (default
* 1.8 here is the nominal point only).

.param vdd_val = 1.8

Vdd    VDD 0 dc {vdd_val}
Vclkfix CLK 0 dc {vdd_val}
Vinp VINP 0 dc {vdd_val/2} AC 1
Vinn VINN 0 dc {vdd_val/2}

XM_TAIL    TAIL CLK GND GND sky130_fd_pr__nfet_01v8 L=0.5 W=8 nf=1
XM_INN     DIP  VINN TAIL GND sky130_fd_pr__nfet_01v8 L=0.5 W=4 nf=1
XM_INP     DIN  VINP TAIL GND sky130_fd_pr__nfet_01v8 L=0.5 W=4 nf=1
XM_RST_DIP DIP  DIP  VDD  VDD sky130_fd_pr__pfet_01v8 L=0.5 W=4 nf=1
XM_RST_DIN DIN  DIN  VDD  VDD sky130_fd_pr__pfet_01v8 L=0.5 W=4 nf=1
