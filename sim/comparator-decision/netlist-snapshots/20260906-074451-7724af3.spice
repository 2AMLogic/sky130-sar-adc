* comparator_core.spice -- DUT device fragment for the comparator-decision
* testbench (issue #54; re-netlisted for issue #175's reset-integrity
* topology fix, DR-004 Amendment A).
*
* Devices and sources only, per sim/README.md's netlist-fragment convention
* (see e.g. sim/harness-corner-smoke/testbench/harness_corner_smoke.spice).
* This fragment is generated byte-for-byte by netlisting
* design/comparator.sch via xschem (docs/environment-setup.md's flow:
* `xschem -x -n -s -q --rcfile sim/xschemrc -o <dir> design/comparator.sch`),
* then stripping the `** sch_path` comment, the `**.subckt`/`**.ends`
* markers, the inert `*.ipin`/`*.opin` port-annotation comments issue #56's
* port objects emit, and the trailing `.GLOBAL GND`/`.end` (this repo's
* driver -- sim/comparator-decision/run.py -- supplies its own .lib/.temp/
* sources/.control/.end around this fragment, exactly like the harness's
* testbench.py does for the other experiments under sim/). Re-generate by
* re-running that xschem command if design/comparator.sch changes -- this
* file is evidence of what was simulated, not hand-authored.
*
* Ports: VDD, GND (auto-tied to node 0 by ngspice's built-in gnd-name
* recognition, verified against sim/smoke_test.ngspice.out), CLK, VINP,
* VINN, OUTP, OUTN. Internal nodes: TAIL, DIP, DIN.
*
* TOPOLOGY (11 devices, issue #175 / DR-004 Amendment A). This is the
* textbook StrongARM arrangement: the NMOS input pair's drains land on their
* own internal nodes DIP/DIN rather than directly on OUTP/OUTN, and the
* cross-coupled NMOS latch pair's SOURCES return to those same DIP/DIN nodes
* instead of being hard-wired to GND. DIP/DIN carry their own CLK-gated PMOS
* precharge devices (XM_RST_DIP/XM_RST_DIN) alongside the existing output
* precharge pair (XM_RST_P/XM_RST_N).
*
* Why: with the latch NMOS sources at GND (the pre-#175 device set), those
* devices conducted throughout the CLK=0 reset phase in opposition to the
* reset PMOS pair, leaving a DC path VDD -> reset PMOS -> output node ->
* latch NMOS -> GND open the whole time and holding the outputs at an
* UNSTABLE mid-rail equilibrium with above-unity cross-coupled loop gain.
* Record sim/comparator-decision/records/20260906-052758-662a84d.md measured
* both consequences directly (0.78*VDD reset level; 0.52-1.25 mA static reset
* current) and its Vindiff = 0 mV reset-integrity control failed at 3 of the
* 9 ratified corner points. With the sources on DIP/DIN and DIP/DIN
* precharged to VDD, every latch device's Vgs is exactly 0 V during reset
* (gate at VDD from the opposite precharged output, source at VDD), so the
* loop gain is zero, the reset state is a stable equilibrium, and no DC path
* exists.
*
* Node convention is unchanged: Vin,diff = VINP - VINN > 0 => OUTP settles
* high. XM_INN (gate VINN) discharges DIP, which is the node XM_LATN_P
* (drain OUTP) sources from -- so a larger VINN pulls OUTP down, exactly as
* before the change.
*
* Every device is sky130_fd_pr__{n,p}fet_01v8 (ratified 1.8V core flavour,
* DR-001) -- zero _g5v0d10v5 or other non-ratified flavour instances.

XM_TAIL TAIL CLK GND GND sky130_fd_pr__nfet_01v8 L=0.5 W=8 nf=1 ad=2.32 as=2.32 pd=16.58 ps=16.58 nrd=0.03625 nrs=0.03625 sa=0
+ sb=0 sd=0 mult=1 m=1
XM_INN DIP VINN TAIL GND sky130_fd_pr__nfet_01v8 L=0.5 W=4 nf=1 ad=1.16 as=1.16 pd=8.58 ps=8.58 nrd=0.0725 nrs=0.0725 sa=0 sb=0
+ sd=0 mult=1 m=1
XM_INP DIN VINP TAIL GND sky130_fd_pr__nfet_01v8 L=0.5 W=4 nf=1 ad=1.16 as=1.16 pd=8.58 ps=8.58 nrd=0.0725 nrs=0.0725 sa=0 sb=0
+ sd=0 mult=1 m=1
XM_LATN_P OUTP OUTN DIP GND sky130_fd_pr__nfet_01v8 L=0.5 W=4 nf=1 ad=1.16 as=1.16 pd=8.58 ps=8.58 nrd=0.0725 nrs=0.0725 sa=0 sb=0
+ sd=0 mult=1 m=1
XM_LATN_N OUTN OUTP DIN GND sky130_fd_pr__nfet_01v8 L=0.5 W=4 nf=1 ad=1.16 as=1.16 pd=8.58 ps=8.58 nrd=0.0725 nrs=0.0725 sa=0 sb=0
+ sd=0 mult=1 m=1
XM_LATP_P OUTP OUTN VDD VDD sky130_fd_pr__pfet_01v8 L=0.5 W=8 nf=1 ad=2.32 as=2.32 pd=16.58 ps=16.58 nrd=0.03625 nrs=0.03625 sa=0
+ sb=0 sd=0 mult=1 m=1
XM_LATP_N OUTN OUTP VDD VDD sky130_fd_pr__pfet_01v8 L=0.5 W=8 nf=1 ad=2.32 as=2.32 pd=16.58 ps=16.58 nrd=0.03625 nrs=0.03625 sa=0
+ sb=0 sd=0 mult=1 m=1
XM_RST_P OUTP CLK VDD VDD sky130_fd_pr__pfet_01v8 L=0.5 W=16 nf=1 ad=4.64 as=4.64 pd=32.58 ps=32.58 nrd=0.018125 nrs=0.018125 sa=0
+ sb=0 sd=0 mult=1 m=1
XM_RST_N OUTN CLK VDD VDD sky130_fd_pr__pfet_01v8 L=0.5 W=16 nf=1 ad=4.64 as=4.64 pd=32.58 ps=32.58 nrd=0.018125 nrs=0.018125 sa=0
+ sb=0 sd=0 mult=1 m=1
XM_RST_DIP DIP CLK VDD VDD sky130_fd_pr__pfet_01v8 L=0.5 W=4 nf=1 ad=1.16 as=1.16 pd=8.58 ps=8.58 nrd=0.0725 nrs=0.0725 sa=0 sb=0
+ sd=0 mult=1 m=1
XM_RST_DIN DIN CLK VDD VDD sky130_fd_pr__pfet_01v8 L=0.5 W=4 nf=1 ad=1.16 as=1.16 pd=8.58 ps=8.58 nrd=0.0725 nrs=0.0725 sa=0 sb=0
+ sd=0 mult=1 m=1
