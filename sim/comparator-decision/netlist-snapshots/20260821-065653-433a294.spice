* comparator_core.spice -- DUT device fragment for the comparator-decision
* testbench (issue #54).
*
* Devices and sources only, per sim/README.md's netlist-fragment convention
* (see e.g. sim/harness-corner-smoke/testbench/harness_corner_smoke.spice).
* This fragment is generated byte-for-byte by netlisting
* design/comparator.sch via xschem (docs/environment-setup.md's flow:
* `xschem -x -n -s -q --rcfile sim/xschemrc -o <dir> design/comparator.sch`),
* then stripping the `** sch_path` comment, the `**.subckt`/`**.ends`
* markers, and the trailing `.GLOBAL GND`/`.end` (this repo's driver
* -- sim/comparator-decision/run.py -- supplies its own .lib/.temp/
* sources/.control/.end around this fragment, exactly like the harness's
* testbench.py does for the other experiments under sim/). Re-generate by
* re-running that xschem command if design/comparator.sch changes -- this
* file is evidence of what was simulated, not hand-authored.
*
* Ports: VDD, GND (auto-tied to node 0 by ngspice's built-in gnd-name
* recognition, verified against sim/smoke_test.ngspice.out), CLK, VINP,
* VINN, OUTP, OUTN. Internal node: TAIL.
*
* Every device is sky130_fd_pr__{n,p}fet_01v8 (ratified 1.8V core flavour,
* DR-001) -- zero _g5v0d10v5 or other non-ratified flavour instances.

XM_TAIL TAIL CLK GND GND sky130_fd_pr__nfet_01v8 L=0.5 W=8 nf=1 ad=2.32 as=2.32 pd=16.58 ps=16.58 nrd=0.03625 nrs=0.03625 sa=0
+ sb=0 sd=0 mult=1 m=1
XM_INN OUTP VINN TAIL GND sky130_fd_pr__nfet_01v8 L=0.5 W=4 nf=1 ad=1.16 as=1.16 pd=8.58 ps=8.58 nrd=0.0725 nrs=0.0725 sa=0 sb=0
+ sd=0 mult=1 m=1
XM_INP OUTN VINP TAIL GND sky130_fd_pr__nfet_01v8 L=0.5 W=4 nf=1 ad=1.16 as=1.16 pd=8.58 ps=8.58 nrd=0.0725 nrs=0.0725 sa=0 sb=0
+ sd=0 mult=1 m=1
XM_LATN_P OUTP OUTN GND GND sky130_fd_pr__nfet_01v8 L=0.5 W=4 nf=1 ad=1.16 as=1.16 pd=8.58 ps=8.58 nrd=0.0725 nrs=0.0725 sa=0 sb=0
+ sd=0 mult=1 m=1
XM_LATN_N OUTN OUTP GND GND sky130_fd_pr__nfet_01v8 L=0.5 W=4 nf=1 ad=1.16 as=1.16 pd=8.58 ps=8.58 nrd=0.0725 nrs=0.0725 sa=0 sb=0
+ sd=0 mult=1 m=1
XM_LATP_P OUTP OUTN VDD VDD sky130_fd_pr__pfet_01v8 L=0.5 W=8 nf=1 ad=2.32 as=2.32 pd=16.58 ps=16.58 nrd=0.03625 nrs=0.03625 sa=0
+ sb=0 sd=0 mult=1 m=1
XM_LATP_N OUTN OUTP VDD VDD sky130_fd_pr__pfet_01v8 L=0.5 W=8 nf=1 ad=2.32 as=2.32 pd=16.58 ps=16.58 nrd=0.03625 nrs=0.03625 sa=0
+ sb=0 sd=0 mult=1 m=1
XM_RST_P OUTP CLK VDD VDD sky130_fd_pr__pfet_01v8 L=0.5 W=16 nf=1 ad=4.64 as=4.64 pd=32.58 ps=32.58 nrd=0.018125 nrs=0.018125 sa=0
+ sb=0 sd=0 mult=1 m=1
XM_RST_N OUTN CLK VDD VDD sky130_fd_pr__pfet_01v8 L=0.5 W=16 nf=1 ad=4.64 as=4.64 pd=32.58 ps=32.58 nrd=0.018125 nrs=0.018125 sa=0
+ sb=0 sd=0 mult=1 m=1
