* full_conversion_tb_fragment.spice -- end-to-end full-conversion
* transient testbench for design/sar_adc_top.spice (issue #254).
*
* GENERATED by sim/full-conversion-transient/gen_full_conversion_tb.py -- do not
* edit by hand; sim/tests/test_full_conversion.py pins this file
* byte-for-byte against a fresh generation.
*
* Devices/sources/measurements only: sim/full-conversion-transient/
* run_conversion.py supplies the .lib corner section, .temp, the
* .param vdd_val supply point, the sky130_fd_sc_hd .include, the
* .global VPWR VGND tie (design/sar_adc_top.sch's own header names
* this tie as the assembling testbench's job -- VPWR/VGND are literal
* std-cell instance properties with no schematic-graph node), the DUT
* netlist body, and the closing .end.
*
* CLK: f_clk = 12 MHz (DR-006 worst case), period 83.3333 ns, 50% duty.
* First CLK rising edge (50%) at 200 ns; RST_B released at 20 ns.
* 6 back-to-back conversions of 12 CLK periods each (1000 ns per conversion);
* conversion 0 is a start-up conversion and is discarded, conversions 1..5 carry the five DC
* differential inputs below (as a fraction of V_REF = vdd_val):
*   conversion 1: Vd = -0.78*V_REF  (VINP = 0.110*vdd_val, VINN = 0.890*vdd_val)  -> ideal code 113
*   conversion 2: Vd = -0.25*V_REF  (VINP = 0.375*vdd_val, VINN = 0.625*vdd_val)  -> ideal code 384
*   conversion 3: Vd = +0.00*V_REF  (VINP = 0.500*vdd_val, VINN = 0.500*vdd_val)  -> ideal code 512
*   conversion 4: Vd = +0.25*V_REF  (VINP = 0.625*vdd_val, VINN = 0.375*vdd_val)  -> ideal code 640
*   conversion 5: Vd = +0.78*V_REF  (VINP = 0.890*vdd_val, VINN = 0.110*vdd_val)  -> ideal code 911
*
* Rail-referenced throughout ({vdd_val} expressions): one committed
* fragment serves every supply point of the ratified corner set, and
* V_REF = V_DD (spec/target-spec.md, RATIFIED DR-003) means the ideal
* code above is the same integer at every corner.

* --- supplies and references -----------------------------------------
VVDD VDD 0 DC {vdd_val}
VVPWR VPWR 0 DC {vdd_val}
VVGND VGND 0 DC 0
VVREFP VREFP 0 DC {vdd_val}
VVREFN VREFN 0 DC 0
VVCM VCM 0 DC {vdd_val*0.5}

* --- clock and reset --------------------------------------------------
VCLK CLK 0 PULSE(0 {vdd_val} 199.5000n 1n 1n 40.66667n 83.33333n)
VRSTB RST_B 0 PWL(0 0 20.0000n 0 21.0000n {vdd_val} 6283.3333n {vdd_val})

* --- DC differential input schedule -----------------------------------
VINP VINP 0 PWL(0.0000n {vdd_val*0.11} 1950.0000n {vdd_val*0.11} 1951.0000n {vdd_val*0.375} 2950.0000n {vdd_val*0.375} 2951.0000n {vdd_val*0.5} 3950.0000n {vdd_val*0.5} 3951.0000n {vdd_val*0.625} 4950.0000n {vdd_val*0.625} 4951.0000n {vdd_val*0.89} 6283.3333n {vdd_val*0.89})
VINN VINN 0 PWL(0.0000n {vdd_val*0.89} 1950.0000n {vdd_val*0.89} 1951.0000n {vdd_val*0.625} 2950.0000n {vdd_val*0.625} 2951.0000n {vdd_val*0.5} 3950.0000n {vdd_val*0.5} 3951.0000n {vdd_val*0.375} 4950.0000n {vdd_val*0.375} 4951.0000n {vdd_val*0.11} 6283.3333n {vdd_val*0.11})

.tran 0.5n 6283.3333n

* --- captured output code, read mid-SAMPLE of each conversion ---------
* conversion 1: Vd = -0.78*V_REF, read at 2158.3333 ns
.meas tran d9_c1 find v(dout9) at=2158.3333n
.meas tran d8_c1 find v(dout8) at=2158.3333n
.meas tran d7_c1 find v(dout7) at=2158.3333n
.meas tran d6_c1 find v(dout6) at=2158.3333n
.meas tran d5_c1 find v(dout5) at=2158.3333n
.meas tran d4_c1 find v(dout4) at=2158.3333n
.meas tran d3_c1 find v(dout3) at=2158.3333n
.meas tran d2_c1 find v(dout2) at=2158.3333n
.meas tran d1_c1 find v(dout1) at=2158.3333n
.meas tran d0_c1 find v(dout0) at=2158.3333n
* conversion 2: Vd = -0.25*V_REF, read at 3158.3333 ns
.meas tran d9_c2 find v(dout9) at=3158.3333n
.meas tran d8_c2 find v(dout8) at=3158.3333n
.meas tran d7_c2 find v(dout7) at=3158.3333n
.meas tran d6_c2 find v(dout6) at=3158.3333n
.meas tran d5_c2 find v(dout5) at=3158.3333n
.meas tran d4_c2 find v(dout4) at=3158.3333n
.meas tran d3_c2 find v(dout3) at=3158.3333n
.meas tran d2_c2 find v(dout2) at=3158.3333n
.meas tran d1_c2 find v(dout1) at=3158.3333n
.meas tran d0_c2 find v(dout0) at=3158.3333n
* conversion 3: Vd = +0.00*V_REF, read at 4158.3333 ns
.meas tran d9_c3 find v(dout9) at=4158.3333n
.meas tran d8_c3 find v(dout8) at=4158.3333n
.meas tran d7_c3 find v(dout7) at=4158.3333n
.meas tran d6_c3 find v(dout6) at=4158.3333n
.meas tran d5_c3 find v(dout5) at=4158.3333n
.meas tran d4_c3 find v(dout4) at=4158.3333n
.meas tran d3_c3 find v(dout3) at=4158.3333n
.meas tran d2_c3 find v(dout2) at=4158.3333n
.meas tran d1_c3 find v(dout1) at=4158.3333n
.meas tran d0_c3 find v(dout0) at=4158.3333n
* conversion 4: Vd = +0.25*V_REF, read at 5158.3333 ns
.meas tran d9_c4 find v(dout9) at=5158.3333n
.meas tran d8_c4 find v(dout8) at=5158.3333n
.meas tran d7_c4 find v(dout7) at=5158.3333n
.meas tran d6_c4 find v(dout6) at=5158.3333n
.meas tran d5_c4 find v(dout5) at=5158.3333n
.meas tran d4_c4 find v(dout4) at=5158.3333n
.meas tran d3_c4 find v(dout3) at=5158.3333n
.meas tran d2_c4 find v(dout2) at=5158.3333n
.meas tran d1_c4 find v(dout1) at=5158.3333n
.meas tran d0_c4 find v(dout0) at=5158.3333n
* conversion 5: Vd = +0.78*V_REF, read at 6158.3333 ns
.meas tran d9_c5 find v(dout9) at=6158.3333n
.meas tran d8_c5 find v(dout8) at=6158.3333n
.meas tran d7_c5 find v(dout7) at=6158.3333n
.meas tran d6_c5 find v(dout6) at=6158.3333n
.meas tran d5_c5 find v(dout5) at=6158.3333n
.meas tran d4_c5 find v(dout4) at=6158.3333n
.meas tran d3_c5 find v(dout3) at=6158.3333n
.meas tran d2_c5 find v(dout2) at=6158.3333n
.meas tran d1_c5 find v(dout1) at=6158.3333n
.meas tran d0_c5 find v(dout0) at=6158.3333n

* --- phase structure: BUSY and PH_SAMPLE (SAMPLE_INT) per CLK period --
* Expected per conversion: BUSY = 1 for periods 0..10 (10 bit trials +
* EOC) and 0 for period 11 (SAMPLE); SAMPLE_INT is its complement.
.meas tran busy_c1_p0 find v(busy) at=1241.6667n
.meas tran smpl_c1_p0 find v(sample_int) at=1241.6667n
.meas tran busy_c1_p1 find v(busy) at=1325.0000n
.meas tran smpl_c1_p1 find v(sample_int) at=1325.0000n
.meas tran busy_c1_p2 find v(busy) at=1408.3333n
.meas tran smpl_c1_p2 find v(sample_int) at=1408.3333n
.meas tran busy_c1_p3 find v(busy) at=1491.6667n
.meas tran smpl_c1_p3 find v(sample_int) at=1491.6667n
.meas tran busy_c1_p4 find v(busy) at=1575.0000n
.meas tran smpl_c1_p4 find v(sample_int) at=1575.0000n
.meas tran busy_c1_p5 find v(busy) at=1658.3333n
.meas tran smpl_c1_p5 find v(sample_int) at=1658.3333n
.meas tran busy_c1_p6 find v(busy) at=1741.6667n
.meas tran smpl_c1_p6 find v(sample_int) at=1741.6667n
.meas tran busy_c1_p7 find v(busy) at=1825.0000n
.meas tran smpl_c1_p7 find v(sample_int) at=1825.0000n
.meas tran busy_c1_p8 find v(busy) at=1908.3333n
.meas tran smpl_c1_p8 find v(sample_int) at=1908.3333n
.meas tran busy_c1_p9 find v(busy) at=1991.6667n
.meas tran smpl_c1_p9 find v(sample_int) at=1991.6667n
.meas tran busy_c1_p10 find v(busy) at=2075.0000n
.meas tran smpl_c1_p10 find v(sample_int) at=2075.0000n
.meas tran busy_c1_p11 find v(busy) at=2158.3333n
.meas tran smpl_c1_p11 find v(sample_int) at=2158.3333n
.meas tran busy_c2_p0 find v(busy) at=2241.6667n
.meas tran smpl_c2_p0 find v(sample_int) at=2241.6667n
.meas tran busy_c2_p1 find v(busy) at=2325.0000n
.meas tran smpl_c2_p1 find v(sample_int) at=2325.0000n
.meas tran busy_c2_p2 find v(busy) at=2408.3333n
.meas tran smpl_c2_p2 find v(sample_int) at=2408.3333n
.meas tran busy_c2_p3 find v(busy) at=2491.6667n
.meas tran smpl_c2_p3 find v(sample_int) at=2491.6667n
.meas tran busy_c2_p4 find v(busy) at=2575.0000n
.meas tran smpl_c2_p4 find v(sample_int) at=2575.0000n
.meas tran busy_c2_p5 find v(busy) at=2658.3333n
.meas tran smpl_c2_p5 find v(sample_int) at=2658.3333n
.meas tran busy_c2_p6 find v(busy) at=2741.6667n
.meas tran smpl_c2_p6 find v(sample_int) at=2741.6667n
.meas tran busy_c2_p7 find v(busy) at=2825.0000n
.meas tran smpl_c2_p7 find v(sample_int) at=2825.0000n
.meas tran busy_c2_p8 find v(busy) at=2908.3333n
.meas tran smpl_c2_p8 find v(sample_int) at=2908.3333n
.meas tran busy_c2_p9 find v(busy) at=2991.6667n
.meas tran smpl_c2_p9 find v(sample_int) at=2991.6667n
.meas tran busy_c2_p10 find v(busy) at=3075.0000n
.meas tran smpl_c2_p10 find v(sample_int) at=3075.0000n
.meas tran busy_c2_p11 find v(busy) at=3158.3333n
.meas tran smpl_c2_p11 find v(sample_int) at=3158.3333n
.meas tran busy_c3_p0 find v(busy) at=3241.6667n
.meas tran smpl_c3_p0 find v(sample_int) at=3241.6667n
.meas tran busy_c3_p1 find v(busy) at=3325.0000n
.meas tran smpl_c3_p1 find v(sample_int) at=3325.0000n
.meas tran busy_c3_p2 find v(busy) at=3408.3333n
.meas tran smpl_c3_p2 find v(sample_int) at=3408.3333n
.meas tran busy_c3_p3 find v(busy) at=3491.6667n
.meas tran smpl_c3_p3 find v(sample_int) at=3491.6667n
.meas tran busy_c3_p4 find v(busy) at=3575.0000n
.meas tran smpl_c3_p4 find v(sample_int) at=3575.0000n
.meas tran busy_c3_p5 find v(busy) at=3658.3333n
.meas tran smpl_c3_p5 find v(sample_int) at=3658.3333n
.meas tran busy_c3_p6 find v(busy) at=3741.6667n
.meas tran smpl_c3_p6 find v(sample_int) at=3741.6667n
.meas tran busy_c3_p7 find v(busy) at=3825.0000n
.meas tran smpl_c3_p7 find v(sample_int) at=3825.0000n
.meas tran busy_c3_p8 find v(busy) at=3908.3333n
.meas tran smpl_c3_p8 find v(sample_int) at=3908.3333n
.meas tran busy_c3_p9 find v(busy) at=3991.6667n
.meas tran smpl_c3_p9 find v(sample_int) at=3991.6667n
.meas tran busy_c3_p10 find v(busy) at=4075.0000n
.meas tran smpl_c3_p10 find v(sample_int) at=4075.0000n
.meas tran busy_c3_p11 find v(busy) at=4158.3333n
.meas tran smpl_c3_p11 find v(sample_int) at=4158.3333n
.meas tran busy_c4_p0 find v(busy) at=4241.6667n
.meas tran smpl_c4_p0 find v(sample_int) at=4241.6667n
.meas tran busy_c4_p1 find v(busy) at=4325.0000n
.meas tran smpl_c4_p1 find v(sample_int) at=4325.0000n
.meas tran busy_c4_p2 find v(busy) at=4408.3333n
.meas tran smpl_c4_p2 find v(sample_int) at=4408.3333n
.meas tran busy_c4_p3 find v(busy) at=4491.6667n
.meas tran smpl_c4_p3 find v(sample_int) at=4491.6667n
.meas tran busy_c4_p4 find v(busy) at=4575.0000n
.meas tran smpl_c4_p4 find v(sample_int) at=4575.0000n
.meas tran busy_c4_p5 find v(busy) at=4658.3333n
.meas tran smpl_c4_p5 find v(sample_int) at=4658.3333n
.meas tran busy_c4_p6 find v(busy) at=4741.6667n
.meas tran smpl_c4_p6 find v(sample_int) at=4741.6667n
.meas tran busy_c4_p7 find v(busy) at=4825.0000n
.meas tran smpl_c4_p7 find v(sample_int) at=4825.0000n
.meas tran busy_c4_p8 find v(busy) at=4908.3333n
.meas tran smpl_c4_p8 find v(sample_int) at=4908.3333n
.meas tran busy_c4_p9 find v(busy) at=4991.6667n
.meas tran smpl_c4_p9 find v(sample_int) at=4991.6667n
.meas tran busy_c4_p10 find v(busy) at=5075.0000n
.meas tran smpl_c4_p10 find v(sample_int) at=5075.0000n
.meas tran busy_c4_p11 find v(busy) at=5158.3333n
.meas tran smpl_c4_p11 find v(sample_int) at=5158.3333n
.meas tran busy_c5_p0 find v(busy) at=5241.6667n
.meas tran smpl_c5_p0 find v(sample_int) at=5241.6667n
.meas tran busy_c5_p1 find v(busy) at=5325.0000n
.meas tran smpl_c5_p1 find v(sample_int) at=5325.0000n
.meas tran busy_c5_p2 find v(busy) at=5408.3333n
.meas tran smpl_c5_p2 find v(sample_int) at=5408.3333n
.meas tran busy_c5_p3 find v(busy) at=5491.6667n
.meas tran smpl_c5_p3 find v(sample_int) at=5491.6667n
.meas tran busy_c5_p4 find v(busy) at=5575.0000n
.meas tran smpl_c5_p4 find v(sample_int) at=5575.0000n
.meas tran busy_c5_p5 find v(busy) at=5658.3333n
.meas tran smpl_c5_p5 find v(sample_int) at=5658.3333n
.meas tran busy_c5_p6 find v(busy) at=5741.6667n
.meas tran smpl_c5_p6 find v(sample_int) at=5741.6667n
.meas tran busy_c5_p7 find v(busy) at=5825.0000n
.meas tran smpl_c5_p7 find v(sample_int) at=5825.0000n
.meas tran busy_c5_p8 find v(busy) at=5908.3333n
.meas tran smpl_c5_p8 find v(sample_int) at=5908.3333n
.meas tran busy_c5_p9 find v(busy) at=5991.6667n
.meas tran smpl_c5_p9 find v(sample_int) at=5991.6667n
.meas tran busy_c5_p10 find v(busy) at=6075.0000n
.meas tran smpl_c5_p10 find v(sample_int) at=6075.0000n
.meas tran busy_c5_p11 find v(busy) at=6158.3333n
.meas tran smpl_c5_p11 find v(sample_int) at=6158.3333n

* --- average supply/reference currents over one steady-state ----------
* conversion (conversion 3: 3200.0000 ns to 4200.0000 ns, all 12 periods).
.meas tran i_vdd avg i(vvdd) from=3200.0000n to=4200.0000n
.meas tran i_vpwr avg i(vvpwr) from=3200.0000n to=4200.0000n
.meas tran i_vrefp avg i(vvrefp) from=3200.0000n to=4200.0000n
.meas tran i_vrefn avg i(vvrefn) from=3200.0000n to=4200.0000n
.meas tran i_vcm avg i(vvcm) from=3200.0000n to=4200.0000n
