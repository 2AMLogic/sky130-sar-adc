* input_sweep_tb_fragment.spice -- converging-range boundary-sweep
* testbench for design/sar_adc_top.spice (issue #913, the DR-021
* open item).
*
* GENERATED by sim/full-conversion-transient/gen_full_conversion_tb.py -- do not
* edit by hand; sim/tests/test_full_conversion.py pins this file
* byte-for-byte against a fresh generation.
*
* Same assembly contract as full_conversion_tb_fragment.spice, with
* one difference: the differential input is the top-level parameter
* `vin_frac` (a fraction of V_REF = vdd_val), not a per-conversion
* literal. The assembling body declares the .param and the `klt sim`
* request sweeps it as the corners.params 'vin_frac' axis -- one unit
* per level (the same convention reference-drive-budget's r_ref
* uses). Each unit holds ONE DC level from t = 0, so this schedule
* has no input steps at all.
*
* 2 conversions of 12 CLK periods:
* conversion 0 is a start-up conversion and is discarded (its phase
* structure is still probed); conversion 1 carries the swept level
* and is the one measured.

* --- supplies and references -----------------------------------------
VVDD VDD 0 DC {vdd_val}
VVPWR VPWR 0 DC {vdd_val}
VVGND VGND 0 DC 0
VVREFP VREFP 0 DC {vdd_val}
VVREFN VREFN 0 DC 0
VVCM VCM 0 DC {vdd_val*0.5}

* --- clock and reset --------------------------------------------------
VCLK CLK 0 PULSE(0 {vdd_val} 199.5000n 1n 1n 40.66667n 83.33333n)
VRSTB RST_B 0 PWL(0 0 20.0000n 0 21.0000n {vdd_val} 2283.3333n {vdd_val})

* --- swept DC differential input (Vd = {vin_frac}*V_REF about VCM) ------
* Vd is split symmetrically about VCM = vdd_val/2, exactly as the DC
* fragment splits its per-conversion literals.
VINP VINP 0 DC {vdd_val*(0.5+vin_frac/2)}
VINN VINN 0 DC {vdd_val*(0.5-vin_frac/2)}

.tran 0.5n 2283.3333n

* --- captured output code of the measured conversion, read mid-PH_EOC
* (same nodes and instants as full_conversion_tb_fragment.spice; the
* ideal code for level f is round(f*512)+512, clamped to 0..1023) --
* conversion 1: Vd = {vin_frac}*V_REF, read at 2075.0000 ns
.meas tran d9_c1 find v(dout9) at=2075.0000n
.meas tran d8_c1 find v(adcout8) at=2075.0000n
.meas tran d7_c1 find v(adcout7) at=2075.0000n
.meas tran d6_c1 find v(adcout6) at=2075.0000n
.meas tran d5_c1 find v(adcout5) at=2075.0000n
.meas tran d4_c1 find v(adcout4) at=2075.0000n
.meas tran d3_c1 find v(adcout3) at=2075.0000n
.meas tran d2_c1 find v(adcout2) at=2075.0000n
.meas tran d1_c1 find v(adcout1) at=2075.0000n
.meas tran d0_c1 find v(adcout0) at=2075.0000n

* --- phase structure: BUSY and PH_SAMPLE (SAMPLE_INT) per CLK period --
* Expected per conversion: BUSY = 1 for periods 0..10 (10 bit trials +
* EOC) and 0 for period 11 (SAMPLE); SAMPLE_INT is its complement.
.meas tran busy_c0_p0 find v(busy) at=241.6667n
.meas tran smpl_c0_p0 find v(sample_int) at=241.6667n
.meas tran busy_c0_p1 find v(busy) at=325.0000n
.meas tran smpl_c0_p1 find v(sample_int) at=325.0000n
.meas tran busy_c0_p2 find v(busy) at=408.3333n
.meas tran smpl_c0_p2 find v(sample_int) at=408.3333n
.meas tran busy_c0_p3 find v(busy) at=491.6667n
.meas tran smpl_c0_p3 find v(sample_int) at=491.6667n
.meas tran busy_c0_p4 find v(busy) at=575.0000n
.meas tran smpl_c0_p4 find v(sample_int) at=575.0000n
.meas tran busy_c0_p5 find v(busy) at=658.3333n
.meas tran smpl_c0_p5 find v(sample_int) at=658.3333n
.meas tran busy_c0_p6 find v(busy) at=741.6667n
.meas tran smpl_c0_p6 find v(sample_int) at=741.6667n
.meas tran busy_c0_p7 find v(busy) at=825.0000n
.meas tran smpl_c0_p7 find v(sample_int) at=825.0000n
.meas tran busy_c0_p8 find v(busy) at=908.3333n
.meas tran smpl_c0_p8 find v(sample_int) at=908.3333n
.meas tran busy_c0_p9 find v(busy) at=991.6667n
.meas tran smpl_c0_p9 find v(sample_int) at=991.6667n
.meas tran busy_c0_p10 find v(busy) at=1075.0000n
.meas tran smpl_c0_p10 find v(sample_int) at=1075.0000n
.meas tran busy_c0_p11 find v(busy) at=1158.3333n
.meas tran smpl_c0_p11 find v(sample_int) at=1158.3333n
.meas tran busy_c1_p0 find v(busy) at=1241.6667n
.meas tran smpl_c1_p0 find v(sample_int) at=1241.6667n
.meas tran busy_c1_p1 find v(busy) at=1325.0000n
.meas tran smpl_c1_p1 find v(sample_int) at=1325.0000n
.meas tran busy_c1_p2 find v(busy) at=1408.3333n
.meas tran smpl_c1_p2 find v(sample_int) at=1408.3333n
.meas tran busy_c1_p3 find v(busy) at=1491.6667n
.meas tran smpl_c1_p3 find v(sample_int) at=1491.6667n
.meas tran busy_c1_p4 find v(busy) at=1575.0000n
.meas tran smpl_c1_p4 find v(sample_int) at=1575.0000n
.meas tran busy_c1_p5 find v(busy) at=1658.3333n
.meas tran smpl_c1_p5 find v(sample_int) at=1658.3333n
.meas tran busy_c1_p6 find v(busy) at=1741.6667n
.meas tran smpl_c1_p6 find v(sample_int) at=1741.6667n
.meas tran busy_c1_p7 find v(busy) at=1825.0000n
.meas tran smpl_c1_p7 find v(sample_int) at=1825.0000n
.meas tran busy_c1_p8 find v(busy) at=1908.3333n
.meas tran smpl_c1_p8 find v(sample_int) at=1908.3333n
.meas tran busy_c1_p9 find v(busy) at=1991.6667n
.meas tran smpl_c1_p9 find v(sample_int) at=1991.6667n
.meas tran busy_c1_p10 find v(busy) at=2075.0000n
.meas tran smpl_c1_p10 find v(sample_int) at=2075.0000n
.meas tran busy_c1_p11 find v(busy) at=2158.3333n
.meas tran smpl_c1_p11 find v(sample_int) at=2158.3333n
