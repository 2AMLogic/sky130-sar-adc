* coherent_sine_tb_fragment.spice -- coherent-sine dynamic-test
* testbench for design/sar_adc_top.spice (issue #603).
*
* GENERATED by sim/full-conversion-transient/gen_full_conversion_tb.py -- do not
* edit by hand; sim/tests/test_dynamic_enob_fft.py pins this file
* byte-for-byte against a fresh generation.
*
* Same assembly contract as full_conversion_tb_fragment.spice (the
* driver supplies .lib/.temp/.param vdd_val/.include/.global and the
* DUT); only the input differs: a coherent antiphase sine about VCM.
*
* CLK: f_clk = 12 MHz, f_s = f_clk/12 = 1 MS/s (one code per conversion).
* Record: N = 32 conversions (1 start-up conversion(s) discarded first), tone on bin 7:
*   f_in = 7 * f_s / 32 = 218750 Hz, window = none (coherent).
* Peak differential amplitude = 0.25*V_REF (-12.04 dBFS).

* --- supplies and references -----------------------------------------
VVDD VDD 0 DC {vdd_val}
VVPWR VPWR 0 DC {vdd_val}
VVGND VGND 0 DC 0
VVREFP VREFP 0 DC {vdd_val}
VVREFN VREFN 0 DC 0
VVCM VCM 0 DC {vdd_val*0.5}

* --- clock and reset --------------------------------------------------
VCLK CLK 0 PULSE(0 {vdd_val} 199.5000n 1n 1n 40.66667n 83.33333n)
VRSTB RST_B 0 PWL(0 0 20.0000n 0 21.0000n {vdd_val} 33283.3333n {vdd_val})

* --- coherent sine input (antiphase about VCM) ------------------------
VINP VINP 0 SIN({vdd_val*0.5} {vdd_val*0.125} 218750 0 0 0)
VINN VINN 0 SIN({vdd_val*0.5} {vdd_val*0.125} 218750 0 0 180)

.tran 0.5n 33283.3333n

* --- captured output code per conversion, read mid-PH_EOC (same nodes
* and instants as full_conversion_tb_fragment.spice) -------------------
* conversion 1: sampled at 1200.0000 ns, Vd = +0.249229*V_REF, read at 2075.0000 ns
.meas tran d9_c1 find v(dout9) at=2075.0000n
.meas tran d8_c1 find v(adcout8) at=2075.0000n
.meas tran d7_c1 find v(adcout7) at=2075.0000n
.meas tran d6_c1 find v(adcout6) at=2075.0000n
.meas tran d5_c1 find v(adcout5) at=2075.0000n
.meas tran d4_c1 find v(adcout4) at=2075.0000n
.meas tran d3_c1 find v(adcout3) at=2075.0000n
.meas tran d2_c1 find v(adcout2) at=2075.0000n
.meas tran d1_c1 find v(adcout1) at=2075.0000n
.meas tran d0_c1 find v(adcout0) at=2075.0000n
* conversion 2: sampled at 2200.0000 ns, Vd = +0.029384*V_REF, read at 3075.0000 ns
.meas tran d9_c2 find v(dout9) at=3075.0000n
.meas tran d8_c2 find v(adcout8) at=3075.0000n
.meas tran d7_c2 find v(adcout7) at=3075.0000n
.meas tran d6_c2 find v(adcout6) at=3075.0000n
.meas tran d5_c2 find v(adcout5) at=3075.0000n
.meas tran d4_c2 find v(adcout4) at=3075.0000n
.meas tran d3_c2 find v(adcout3) at=3075.0000n
.meas tran d2_c2 find v(adcout2) at=3075.0000n
.meas tran d1_c2 find v(adcout1) at=3075.0000n
.meas tran d0_c2 find v(adcout0) at=3075.0000n
* conversion 3: sampled at 3200.0000 ns, Vd = -0.237764*V_REF, read at 4075.0000 ns
.meas tran d9_c3 find v(dout9) at=4075.0000n
.meas tran d8_c3 find v(adcout8) at=4075.0000n
.meas tran d7_c3 find v(adcout7) at=4075.0000n
.meas tran d6_c3 find v(adcout6) at=4075.0000n
.meas tran d5_c3 find v(adcout5) at=4075.0000n
.meas tran d4_c3 find v(adcout4) at=4075.0000n
.meas tran d3_c3 find v(adcout3) at=4075.0000n
.meas tran d2_c3 find v(adcout2) at=4075.0000n
.meas tran d1_c3 find v(adcout1) at=4075.0000n
.meas tran d0_c3 find v(adcout0) at=4075.0000n
* conversion 4: sampled at 4200.0000 ns, Vd = -0.122155*V_REF, read at 5075.0000 ns
.meas tran d9_c4 find v(dout9) at=5075.0000n
.meas tran d8_c4 find v(adcout8) at=5075.0000n
.meas tran d7_c4 find v(adcout7) at=5075.0000n
.meas tran d6_c4 find v(adcout6) at=5075.0000n
.meas tran d5_c4 find v(adcout5) at=5075.0000n
.meas tran d4_c4 find v(adcout4) at=5075.0000n
.meas tran d3_c4 find v(adcout3) at=5075.0000n
.meas tran d2_c4 find v(adcout2) at=5075.0000n
.meas tran d1_c4 find v(adcout1) at=5075.0000n
.meas tran d0_c4 find v(adcout0) at=5075.0000n
* conversion 5: sampled at 5200.0000 ns, Vd = +0.190101*V_REF, read at 6075.0000 ns
.meas tran d9_c5 find v(dout9) at=6075.0000n
.meas tran d8_c5 find v(adcout8) at=6075.0000n
.meas tran d7_c5 find v(adcout7) at=6075.0000n
.meas tran d6_c5 find v(adcout6) at=6075.0000n
.meas tran d5_c5 find v(adcout5) at=6075.0000n
.meas tran d4_c5 find v(adcout4) at=6075.0000n
.meas tran d3_c5 find v(adcout3) at=6075.0000n
.meas tran d2_c5 find v(adcout2) at=6075.0000n
.meas tran d1_c5 find v(adcout1) at=6075.0000n
.meas tran d0_c5 find v(adcout0) at=6075.0000n
* conversion 6: sampled at 6200.0000 ns, Vd = +0.196329*V_REF, read at 7075.0000 ns
.meas tran d9_c6 find v(dout9) at=7075.0000n
.meas tran d8_c6 find v(adcout8) at=7075.0000n
.meas tran d7_c6 find v(adcout7) at=7075.0000n
.meas tran d6_c6 find v(adcout6) at=7075.0000n
.meas tran d5_c6 find v(adcout5) at=7075.0000n
.meas tran d4_c6 find v(adcout4) at=7075.0000n
.meas tran d3_c6 find v(adcout3) at=7075.0000n
.meas tran d2_c6 find v(adcout2) at=7075.0000n
.meas tran d1_c6 find v(adcout1) at=7075.0000n
.meas tran d0_c6 find v(adcout0) at=7075.0000n
* conversion 7: sampled at 7200.0000 ns, Vd = -0.113498*V_REF, read at 8075.0000 ns
.meas tran d9_c7 find v(dout9) at=8075.0000n
.meas tran d8_c7 find v(adcout8) at=8075.0000n
.meas tran d7_c7 find v(adcout7) at=8075.0000n
.meas tran d6_c7 find v(adcout6) at=8075.0000n
.meas tran d5_c7 find v(adcout5) at=8075.0000n
.meas tran d4_c7 find v(adcout4) at=8075.0000n
.meas tran d3_c7 find v(adcout3) at=8075.0000n
.meas tran d2_c7 find v(adcout2) at=8075.0000n
.meas tran d1_c7 find v(adcout1) at=8075.0000n
.meas tran d0_c7 find v(adcout0) at=8075.0000n
* conversion 8: sampled at 8200.0000 ns, Vd = -0.240614*V_REF, read at 9075.0000 ns
.meas tran d9_c8 find v(dout9) at=9075.0000n
.meas tran d8_c8 find v(adcout8) at=9075.0000n
.meas tran d7_c8 find v(adcout7) at=9075.0000n
.meas tran d6_c8 find v(adcout6) at=9075.0000n
.meas tran d5_c8 find v(adcout5) at=9075.0000n
.meas tran d4_c8 find v(adcout4) at=9075.0000n
.meas tran d3_c8 find v(adcout3) at=9075.0000n
.meas tran d2_c8 find v(adcout2) at=9075.0000n
.meas tran d1_c8 find v(adcout1) at=9075.0000n
.meas tran d0_c8 find v(adcout0) at=9075.0000n
* conversion 9: sampled at 9200.0000 ns, Vd = +0.019615*V_REF, read at 10075.0000 ns
.meas tran d9_c9 find v(dout9) at=10075.0000n
.meas tran d8_c9 find v(adcout8) at=10075.0000n
.meas tran d7_c9 find v(adcout7) at=10075.0000n
.meas tran d6_c9 find v(adcout6) at=10075.0000n
.meas tran d5_c9 find v(adcout5) at=10075.0000n
.meas tran d4_c9 find v(adcout4) at=10075.0000n
.meas tran d3_c9 find v(adcout3) at=10075.0000n
.meas tran d2_c9 find v(adcout2) at=10075.0000n
.meas tran d1_c9 find v(adcout1) at=10075.0000n
.meas tran d0_c9 find v(adcout0) at=10075.0000n
* conversion 10: sampled at 10200.0000 ns, Vd = +0.248267*V_REF, read at 11075.0000 ns
.meas tran d9_c10 find v(dout9) at=11075.0000n
.meas tran d8_c10 find v(adcout8) at=11075.0000n
.meas tran d7_c10 find v(adcout7) at=11075.0000n
.meas tran d6_c10 find v(adcout6) at=11075.0000n
.meas tran d5_c10 find v(adcout5) at=11075.0000n
.meas tran d4_c10 find v(adcout4) at=11075.0000n
.meas tran d3_c10 find v(adcout3) at=11075.0000n
.meas tran d2_c10 find v(adcout2) at=11075.0000n
.meas tran d1_c10 find v(adcout1) at=11075.0000n
.meas tran d0_c10 find v(adcout0) at=11075.0000n
* conversion 11: sampled at 11200.0000 ns, Vd = +0.077254*V_REF, read at 12075.0000 ns
.meas tran d9_c11 find v(dout9) at=12075.0000n
.meas tran d8_c11 find v(adcout8) at=12075.0000n
.meas tran d7_c11 find v(adcout7) at=12075.0000n
.meas tran d6_c11 find v(adcout6) at=12075.0000n
.meas tran d5_c11 find v(adcout5) at=12075.0000n
.meas tran d4_c11 find v(adcout4) at=12075.0000n
.meas tran d3_c11 find v(adcout3) at=12075.0000n
.meas tran d2_c11 find v(adcout2) at=12075.0000n
.meas tran d1_c11 find v(adcout1) at=12075.0000n
.meas tran d0_c11 find v(adcout0) at=12075.0000n
* conversion 12: sampled at 12200.0000 ns, Vd = -0.218124*V_REF, read at 13075.0000 ns
.meas tran d9_c12 find v(dout9) at=13075.0000n
.meas tran d8_c12 find v(adcout8) at=13075.0000n
.meas tran d7_c12 find v(adcout7) at=13075.0000n
.meas tran d6_c12 find v(adcout6) at=13075.0000n
.meas tran d5_c12 find v(adcout5) at=13075.0000n
.meas tran d4_c12 find v(adcout4) at=13075.0000n
.meas tran d3_c12 find v(adcout3) at=13075.0000n
.meas tran d2_c12 find v(adcout2) at=13075.0000n
.meas tran d1_c12 find v(adcout1) at=13075.0000n
.meas tran d0_c12 find v(adcout0) at=13075.0000n
* conversion 13: sampled at 13200.0000 ns, Vd = -0.162362*V_REF, read at 14075.0000 ns
.meas tran d9_c13 find v(dout9) at=14075.0000n
.meas tran d8_c13 find v(adcout8) at=14075.0000n
.meas tran d7_c13 find v(adcout7) at=14075.0000n
.meas tran d6_c13 find v(adcout6) at=14075.0000n
.meas tran d5_c13 find v(adcout5) at=14075.0000n
.meas tran d4_c13 find v(adcout4) at=14075.0000n
.meas tran d3_c13 find v(adcout3) at=14075.0000n
.meas tran d2_c13 find v(adcout2) at=14075.0000n
.meas tran d1_c13 find v(adcout1) at=14075.0000n
.meas tran d0_c13 find v(adcout0) at=14075.0000n
* conversion 14: sampled at 14200.0000 ns, Vd = +0.154773*V_REF, read at 15075.0000 ns
.meas tran d9_c14 find v(dout9) at=15075.0000n
.meas tran d8_c14 find v(adcout8) at=15075.0000n
.meas tran d7_c14 find v(adcout7) at=15075.0000n
.meas tran d6_c14 find v(adcout6) at=15075.0000n
.meas tran d5_c14 find v(adcout5) at=15075.0000n
.meas tran d4_c14 find v(adcout4) at=15075.0000n
.meas tran d3_c14 find v(adcout3) at=15075.0000n
.meas tran d2_c14 find v(adcout2) at=15075.0000n
.meas tran d1_c14 find v(adcout1) at=15075.0000n
.meas tran d0_c14 find v(adcout0) at=15075.0000n
* conversion 15: sampled at 15200.0000 ns, Vd = +0.222752*V_REF, read at 16075.0000 ns
.meas tran d9_c15 find v(dout9) at=16075.0000n
.meas tran d8_c15 find v(adcout8) at=16075.0000n
.meas tran d7_c15 find v(adcout7) at=16075.0000n
.meas tran d6_c15 find v(adcout6) at=16075.0000n
.meas tran d5_c15 find v(adcout5) at=16075.0000n
.meas tran d4_c15 find v(adcout4) at=16075.0000n
.meas tran d3_c15 find v(adcout3) at=16075.0000n
.meas tran d2_c15 find v(adcout2) at=16075.0000n
.meas tran d1_c15 find v(adcout1) at=16075.0000n
.meas tran d0_c15 find v(adcout0) at=16075.0000n
* conversion 16: sampled at 16200.0000 ns, Vd = -0.067860*V_REF, read at 17075.0000 ns
.meas tran d9_c16 find v(dout9) at=17075.0000n
.meas tran d8_c16 find v(adcout8) at=17075.0000n
.meas tran d7_c16 find v(adcout7) at=17075.0000n
.meas tran d6_c16 find v(adcout6) at=17075.0000n
.meas tran d5_c16 find v(adcout5) at=17075.0000n
.meas tran d4_c16 find v(adcout4) at=17075.0000n
.meas tran d3_c16 find v(adcout3) at=17075.0000n
.meas tran d2_c16 find v(adcout2) at=17075.0000n
.meas tran d1_c16 find v(adcout1) at=17075.0000n
.meas tran d0_c16 find v(adcout0) at=17075.0000n
* conversion 17: sampled at 17200.0000 ns, Vd = -0.249229*V_REF, read at 18075.0000 ns
.meas tran d9_c17 find v(dout9) at=18075.0000n
.meas tran d8_c17 find v(adcout8) at=18075.0000n
.meas tran d7_c17 find v(adcout7) at=18075.0000n
.meas tran d6_c17 find v(adcout6) at=18075.0000n
.meas tran d5_c17 find v(adcout5) at=18075.0000n
.meas tran d4_c17 find v(adcout4) at=18075.0000n
.meas tran d3_c17 find v(adcout3) at=18075.0000n
.meas tran d2_c17 find v(adcout2) at=18075.0000n
.meas tran d1_c17 find v(adcout1) at=18075.0000n
.meas tran d0_c17 find v(adcout0) at=18075.0000n
* conversion 18: sampled at 18200.0000 ns, Vd = -0.029384*V_REF, read at 19075.0000 ns
.meas tran d9_c18 find v(dout9) at=19075.0000n
.meas tran d8_c18 find v(adcout8) at=19075.0000n
.meas tran d7_c18 find v(adcout7) at=19075.0000n
.meas tran d6_c18 find v(adcout6) at=19075.0000n
.meas tran d5_c18 find v(adcout5) at=19075.0000n
.meas tran d4_c18 find v(adcout4) at=19075.0000n
.meas tran d3_c18 find v(adcout3) at=19075.0000n
.meas tran d2_c18 find v(adcout2) at=19075.0000n
.meas tran d1_c18 find v(adcout1) at=19075.0000n
.meas tran d0_c18 find v(adcout0) at=19075.0000n
* conversion 19: sampled at 19200.0000 ns, Vd = +0.237764*V_REF, read at 20075.0000 ns
.meas tran d9_c19 find v(dout9) at=20075.0000n
.meas tran d8_c19 find v(adcout8) at=20075.0000n
.meas tran d7_c19 find v(adcout7) at=20075.0000n
.meas tran d6_c19 find v(adcout6) at=20075.0000n
.meas tran d5_c19 find v(adcout5) at=20075.0000n
.meas tran d4_c19 find v(adcout4) at=20075.0000n
.meas tran d3_c19 find v(adcout3) at=20075.0000n
.meas tran d2_c19 find v(adcout2) at=20075.0000n
.meas tran d1_c19 find v(adcout1) at=20075.0000n
.meas tran d0_c19 find v(adcout0) at=20075.0000n
* conversion 20: sampled at 20200.0000 ns, Vd = +0.122155*V_REF, read at 21075.0000 ns
.meas tran d9_c20 find v(dout9) at=21075.0000n
.meas tran d8_c20 find v(adcout8) at=21075.0000n
.meas tran d7_c20 find v(adcout7) at=21075.0000n
.meas tran d6_c20 find v(adcout6) at=21075.0000n
.meas tran d5_c20 find v(adcout5) at=21075.0000n
.meas tran d4_c20 find v(adcout4) at=21075.0000n
.meas tran d3_c20 find v(adcout3) at=21075.0000n
.meas tran d2_c20 find v(adcout2) at=21075.0000n
.meas tran d1_c20 find v(adcout1) at=21075.0000n
.meas tran d0_c20 find v(adcout0) at=21075.0000n
* conversion 21: sampled at 21200.0000 ns, Vd = -0.190101*V_REF, read at 22075.0000 ns
.meas tran d9_c21 find v(dout9) at=22075.0000n
.meas tran d8_c21 find v(adcout8) at=22075.0000n
.meas tran d7_c21 find v(adcout7) at=22075.0000n
.meas tran d6_c21 find v(adcout6) at=22075.0000n
.meas tran d5_c21 find v(adcout5) at=22075.0000n
.meas tran d4_c21 find v(adcout4) at=22075.0000n
.meas tran d3_c21 find v(adcout3) at=22075.0000n
.meas tran d2_c21 find v(adcout2) at=22075.0000n
.meas tran d1_c21 find v(adcout1) at=22075.0000n
.meas tran d0_c21 find v(adcout0) at=22075.0000n
* conversion 22: sampled at 22200.0000 ns, Vd = -0.196329*V_REF, read at 23075.0000 ns
.meas tran d9_c22 find v(dout9) at=23075.0000n
.meas tran d8_c22 find v(adcout8) at=23075.0000n
.meas tran d7_c22 find v(adcout7) at=23075.0000n
.meas tran d6_c22 find v(adcout6) at=23075.0000n
.meas tran d5_c22 find v(adcout5) at=23075.0000n
.meas tran d4_c22 find v(adcout4) at=23075.0000n
.meas tran d3_c22 find v(adcout3) at=23075.0000n
.meas tran d2_c22 find v(adcout2) at=23075.0000n
.meas tran d1_c22 find v(adcout1) at=23075.0000n
.meas tran d0_c22 find v(adcout0) at=23075.0000n
* conversion 23: sampled at 23200.0000 ns, Vd = +0.113498*V_REF, read at 24075.0000 ns
.meas tran d9_c23 find v(dout9) at=24075.0000n
.meas tran d8_c23 find v(adcout8) at=24075.0000n
.meas tran d7_c23 find v(adcout7) at=24075.0000n
.meas tran d6_c23 find v(adcout6) at=24075.0000n
.meas tran d5_c23 find v(adcout5) at=24075.0000n
.meas tran d4_c23 find v(adcout4) at=24075.0000n
.meas tran d3_c23 find v(adcout3) at=24075.0000n
.meas tran d2_c23 find v(adcout2) at=24075.0000n
.meas tran d1_c23 find v(adcout1) at=24075.0000n
.meas tran d0_c23 find v(adcout0) at=24075.0000n
* conversion 24: sampled at 24200.0000 ns, Vd = +0.240614*V_REF, read at 25075.0000 ns
.meas tran d9_c24 find v(dout9) at=25075.0000n
.meas tran d8_c24 find v(adcout8) at=25075.0000n
.meas tran d7_c24 find v(adcout7) at=25075.0000n
.meas tran d6_c24 find v(adcout6) at=25075.0000n
.meas tran d5_c24 find v(adcout5) at=25075.0000n
.meas tran d4_c24 find v(adcout4) at=25075.0000n
.meas tran d3_c24 find v(adcout3) at=25075.0000n
.meas tran d2_c24 find v(adcout2) at=25075.0000n
.meas tran d1_c24 find v(adcout1) at=25075.0000n
.meas tran d0_c24 find v(adcout0) at=25075.0000n
* conversion 25: sampled at 25200.0000 ns, Vd = -0.019615*V_REF, read at 26075.0000 ns
.meas tran d9_c25 find v(dout9) at=26075.0000n
.meas tran d8_c25 find v(adcout8) at=26075.0000n
.meas tran d7_c25 find v(adcout7) at=26075.0000n
.meas tran d6_c25 find v(adcout6) at=26075.0000n
.meas tran d5_c25 find v(adcout5) at=26075.0000n
.meas tran d4_c25 find v(adcout4) at=26075.0000n
.meas tran d3_c25 find v(adcout3) at=26075.0000n
.meas tran d2_c25 find v(adcout2) at=26075.0000n
.meas tran d1_c25 find v(adcout1) at=26075.0000n
.meas tran d0_c25 find v(adcout0) at=26075.0000n
* conversion 26: sampled at 26200.0000 ns, Vd = -0.248267*V_REF, read at 27075.0000 ns
.meas tran d9_c26 find v(dout9) at=27075.0000n
.meas tran d8_c26 find v(adcout8) at=27075.0000n
.meas tran d7_c26 find v(adcout7) at=27075.0000n
.meas tran d6_c26 find v(adcout6) at=27075.0000n
.meas tran d5_c26 find v(adcout5) at=27075.0000n
.meas tran d4_c26 find v(adcout4) at=27075.0000n
.meas tran d3_c26 find v(adcout3) at=27075.0000n
.meas tran d2_c26 find v(adcout2) at=27075.0000n
.meas tran d1_c26 find v(adcout1) at=27075.0000n
.meas tran d0_c26 find v(adcout0) at=27075.0000n
* conversion 27: sampled at 27200.0000 ns, Vd = -0.077254*V_REF, read at 28075.0000 ns
.meas tran d9_c27 find v(dout9) at=28075.0000n
.meas tran d8_c27 find v(adcout8) at=28075.0000n
.meas tran d7_c27 find v(adcout7) at=28075.0000n
.meas tran d6_c27 find v(adcout6) at=28075.0000n
.meas tran d5_c27 find v(adcout5) at=28075.0000n
.meas tran d4_c27 find v(adcout4) at=28075.0000n
.meas tran d3_c27 find v(adcout3) at=28075.0000n
.meas tran d2_c27 find v(adcout2) at=28075.0000n
.meas tran d1_c27 find v(adcout1) at=28075.0000n
.meas tran d0_c27 find v(adcout0) at=28075.0000n
* conversion 28: sampled at 28200.0000 ns, Vd = +0.218124*V_REF, read at 29075.0000 ns
.meas tran d9_c28 find v(dout9) at=29075.0000n
.meas tran d8_c28 find v(adcout8) at=29075.0000n
.meas tran d7_c28 find v(adcout7) at=29075.0000n
.meas tran d6_c28 find v(adcout6) at=29075.0000n
.meas tran d5_c28 find v(adcout5) at=29075.0000n
.meas tran d4_c28 find v(adcout4) at=29075.0000n
.meas tran d3_c28 find v(adcout3) at=29075.0000n
.meas tran d2_c28 find v(adcout2) at=29075.0000n
.meas tran d1_c28 find v(adcout1) at=29075.0000n
.meas tran d0_c28 find v(adcout0) at=29075.0000n
* conversion 29: sampled at 29200.0000 ns, Vd = +0.162362*V_REF, read at 30075.0000 ns
.meas tran d9_c29 find v(dout9) at=30075.0000n
.meas tran d8_c29 find v(adcout8) at=30075.0000n
.meas tran d7_c29 find v(adcout7) at=30075.0000n
.meas tran d6_c29 find v(adcout6) at=30075.0000n
.meas tran d5_c29 find v(adcout5) at=30075.0000n
.meas tran d4_c29 find v(adcout4) at=30075.0000n
.meas tran d3_c29 find v(adcout3) at=30075.0000n
.meas tran d2_c29 find v(adcout2) at=30075.0000n
.meas tran d1_c29 find v(adcout1) at=30075.0000n
.meas tran d0_c29 find v(adcout0) at=30075.0000n
* conversion 30: sampled at 30200.0000 ns, Vd = -0.154773*V_REF, read at 31075.0000 ns
.meas tran d9_c30 find v(dout9) at=31075.0000n
.meas tran d8_c30 find v(adcout8) at=31075.0000n
.meas tran d7_c30 find v(adcout7) at=31075.0000n
.meas tran d6_c30 find v(adcout6) at=31075.0000n
.meas tran d5_c30 find v(adcout5) at=31075.0000n
.meas tran d4_c30 find v(adcout4) at=31075.0000n
.meas tran d3_c30 find v(adcout3) at=31075.0000n
.meas tran d2_c30 find v(adcout2) at=31075.0000n
.meas tran d1_c30 find v(adcout1) at=31075.0000n
.meas tran d0_c30 find v(adcout0) at=31075.0000n
* conversion 31: sampled at 31200.0000 ns, Vd = -0.222752*V_REF, read at 32075.0000 ns
.meas tran d9_c31 find v(dout9) at=32075.0000n
.meas tran d8_c31 find v(adcout8) at=32075.0000n
.meas tran d7_c31 find v(adcout7) at=32075.0000n
.meas tran d6_c31 find v(adcout6) at=32075.0000n
.meas tran d5_c31 find v(adcout5) at=32075.0000n
.meas tran d4_c31 find v(adcout4) at=32075.0000n
.meas tran d3_c31 find v(adcout3) at=32075.0000n
.meas tran d2_c31 find v(adcout2) at=32075.0000n
.meas tran d1_c31 find v(adcout1) at=32075.0000n
.meas tran d0_c31 find v(adcout0) at=32075.0000n
* conversion 32: sampled at 32200.0000 ns, Vd = +0.067860*V_REF, read at 33075.0000 ns
.meas tran d9_c32 find v(dout9) at=33075.0000n
.meas tran d8_c32 find v(adcout8) at=33075.0000n
.meas tran d7_c32 find v(adcout7) at=33075.0000n
.meas tran d6_c32 find v(adcout6) at=33075.0000n
.meas tran d5_c32 find v(adcout5) at=33075.0000n
.meas tran d4_c32 find v(adcout4) at=33075.0000n
.meas tran d3_c32 find v(adcout3) at=33075.0000n
.meas tran d2_c32 find v(adcout2) at=33075.0000n
.meas tran d1_c32 find v(adcout1) at=33075.0000n
.meas tran d0_c32 find v(adcout0) at=33075.0000n

* --- phase structure: BUSY and PH_SAMPLE (SAMPLE_INT) per CLK period --
* Expected per conversion: BUSY = 1 for periods 0..10 (10 bit trials +
* EOC) and 0 for period 11 (SAMPLE); SAMPLE_INT is its complement.
.meas tran busy_c1_p0 find v(busy) at=1241.6667n
.meas tran smpl_c1_p0 find v(sample_int) at=1241.6667n
.meas tran busy_c1_p1 find v(busy) at=1325.0000n
.meas tran smpl_c1_p1 find v(sample_int) at=1325.0000n
.meas tran busy_c1_p2 find v(busy) at=1408.3333n
.meas tran smpl_c1_p2 find v(sample_int) at=1408.3333n
.meas tran busy_c1_p3 find v(busy) at=1491.6667n
.meas tran smpl_c1_p3 find v(sample_int) at=1491.6667n
.meas tran busy_c1_p4 find v(busy) at=1575.0000n
.meas tran smpl_c1_p4 find v(sample_int) at=1575.0000n
.meas tran busy_c1_p5 find v(busy) at=1658.3333n
.meas tran smpl_c1_p5 find v(sample_int) at=1658.3333n
.meas tran busy_c1_p6 find v(busy) at=1741.6667n
.meas tran smpl_c1_p6 find v(sample_int) at=1741.6667n
.meas tran busy_c1_p7 find v(busy) at=1825.0000n
.meas tran smpl_c1_p7 find v(sample_int) at=1825.0000n
.meas tran busy_c1_p8 find v(busy) at=1908.3333n
.meas tran smpl_c1_p8 find v(sample_int) at=1908.3333n
.meas tran busy_c1_p9 find v(busy) at=1991.6667n
.meas tran smpl_c1_p9 find v(sample_int) at=1991.6667n
.meas tran busy_c1_p10 find v(busy) at=2075.0000n
.meas tran smpl_c1_p10 find v(sample_int) at=2075.0000n
.meas tran busy_c1_p11 find v(busy) at=2158.3333n
.meas tran smpl_c1_p11 find v(sample_int) at=2158.3333n
.meas tran busy_c2_p0 find v(busy) at=2241.6667n
.meas tran smpl_c2_p0 find v(sample_int) at=2241.6667n
.meas tran busy_c2_p1 find v(busy) at=2325.0000n
.meas tran smpl_c2_p1 find v(sample_int) at=2325.0000n
.meas tran busy_c2_p2 find v(busy) at=2408.3333n
.meas tran smpl_c2_p2 find v(sample_int) at=2408.3333n
.meas tran busy_c2_p3 find v(busy) at=2491.6667n
.meas tran smpl_c2_p3 find v(sample_int) at=2491.6667n
.meas tran busy_c2_p4 find v(busy) at=2575.0000n
.meas tran smpl_c2_p4 find v(sample_int) at=2575.0000n
.meas tran busy_c2_p5 find v(busy) at=2658.3333n
.meas tran smpl_c2_p5 find v(sample_int) at=2658.3333n
.meas tran busy_c2_p6 find v(busy) at=2741.6667n
.meas tran smpl_c2_p6 find v(sample_int) at=2741.6667n
.meas tran busy_c2_p7 find v(busy) at=2825.0000n
.meas tran smpl_c2_p7 find v(sample_int) at=2825.0000n
.meas tran busy_c2_p8 find v(busy) at=2908.3333n
.meas tran smpl_c2_p8 find v(sample_int) at=2908.3333n
.meas tran busy_c2_p9 find v(busy) at=2991.6667n
.meas tran smpl_c2_p9 find v(sample_int) at=2991.6667n
.meas tran busy_c2_p10 find v(busy) at=3075.0000n
.meas tran smpl_c2_p10 find v(sample_int) at=3075.0000n
.meas tran busy_c2_p11 find v(busy) at=3158.3333n
.meas tran smpl_c2_p11 find v(sample_int) at=3158.3333n
.meas tran busy_c3_p0 find v(busy) at=3241.6667n
.meas tran smpl_c3_p0 find v(sample_int) at=3241.6667n
.meas tran busy_c3_p1 find v(busy) at=3325.0000n
.meas tran smpl_c3_p1 find v(sample_int) at=3325.0000n
.meas tran busy_c3_p2 find v(busy) at=3408.3333n
.meas tran smpl_c3_p2 find v(sample_int) at=3408.3333n
.meas tran busy_c3_p3 find v(busy) at=3491.6667n
.meas tran smpl_c3_p3 find v(sample_int) at=3491.6667n
.meas tran busy_c3_p4 find v(busy) at=3575.0000n
.meas tran smpl_c3_p4 find v(sample_int) at=3575.0000n
.meas tran busy_c3_p5 find v(busy) at=3658.3333n
.meas tran smpl_c3_p5 find v(sample_int) at=3658.3333n
.meas tran busy_c3_p6 find v(busy) at=3741.6667n
.meas tran smpl_c3_p6 find v(sample_int) at=3741.6667n
.meas tran busy_c3_p7 find v(busy) at=3825.0000n
.meas tran smpl_c3_p7 find v(sample_int) at=3825.0000n
.meas tran busy_c3_p8 find v(busy) at=3908.3333n
.meas tran smpl_c3_p8 find v(sample_int) at=3908.3333n
.meas tran busy_c3_p9 find v(busy) at=3991.6667n
.meas tran smpl_c3_p9 find v(sample_int) at=3991.6667n
.meas tran busy_c3_p10 find v(busy) at=4075.0000n
.meas tran smpl_c3_p10 find v(sample_int) at=4075.0000n
.meas tran busy_c3_p11 find v(busy) at=4158.3333n
.meas tran smpl_c3_p11 find v(sample_int) at=4158.3333n
.meas tran busy_c4_p0 find v(busy) at=4241.6667n
.meas tran smpl_c4_p0 find v(sample_int) at=4241.6667n
.meas tran busy_c4_p1 find v(busy) at=4325.0000n
.meas tran smpl_c4_p1 find v(sample_int) at=4325.0000n
.meas tran busy_c4_p2 find v(busy) at=4408.3333n
.meas tran smpl_c4_p2 find v(sample_int) at=4408.3333n
.meas tran busy_c4_p3 find v(busy) at=4491.6667n
.meas tran smpl_c4_p3 find v(sample_int) at=4491.6667n
.meas tran busy_c4_p4 find v(busy) at=4575.0000n
.meas tran smpl_c4_p4 find v(sample_int) at=4575.0000n
.meas tran busy_c4_p5 find v(busy) at=4658.3333n
.meas tran smpl_c4_p5 find v(sample_int) at=4658.3333n
.meas tran busy_c4_p6 find v(busy) at=4741.6667n
.meas tran smpl_c4_p6 find v(sample_int) at=4741.6667n
.meas tran busy_c4_p7 find v(busy) at=4825.0000n
.meas tran smpl_c4_p7 find v(sample_int) at=4825.0000n
.meas tran busy_c4_p8 find v(busy) at=4908.3333n
.meas tran smpl_c4_p8 find v(sample_int) at=4908.3333n
.meas tran busy_c4_p9 find v(busy) at=4991.6667n
.meas tran smpl_c4_p9 find v(sample_int) at=4991.6667n
.meas tran busy_c4_p10 find v(busy) at=5075.0000n
.meas tran smpl_c4_p10 find v(sample_int) at=5075.0000n
.meas tran busy_c4_p11 find v(busy) at=5158.3333n
.meas tran smpl_c4_p11 find v(sample_int) at=5158.3333n
.meas tran busy_c5_p0 find v(busy) at=5241.6667n
.meas tran smpl_c5_p0 find v(sample_int) at=5241.6667n
.meas tran busy_c5_p1 find v(busy) at=5325.0000n
.meas tran smpl_c5_p1 find v(sample_int) at=5325.0000n
.meas tran busy_c5_p2 find v(busy) at=5408.3333n
.meas tran smpl_c5_p2 find v(sample_int) at=5408.3333n
.meas tran busy_c5_p3 find v(busy) at=5491.6667n
.meas tran smpl_c5_p3 find v(sample_int) at=5491.6667n
.meas tran busy_c5_p4 find v(busy) at=5575.0000n
.meas tran smpl_c5_p4 find v(sample_int) at=5575.0000n
.meas tran busy_c5_p5 find v(busy) at=5658.3333n
.meas tran smpl_c5_p5 find v(sample_int) at=5658.3333n
.meas tran busy_c5_p6 find v(busy) at=5741.6667n
.meas tran smpl_c5_p6 find v(sample_int) at=5741.6667n
.meas tran busy_c5_p7 find v(busy) at=5825.0000n
.meas tran smpl_c5_p7 find v(sample_int) at=5825.0000n
.meas tran busy_c5_p8 find v(busy) at=5908.3333n
.meas tran smpl_c5_p8 find v(sample_int) at=5908.3333n
.meas tran busy_c5_p9 find v(busy) at=5991.6667n
.meas tran smpl_c5_p9 find v(sample_int) at=5991.6667n
.meas tran busy_c5_p10 find v(busy) at=6075.0000n
.meas tran smpl_c5_p10 find v(sample_int) at=6075.0000n
.meas tran busy_c5_p11 find v(busy) at=6158.3333n
.meas tran smpl_c5_p11 find v(sample_int) at=6158.3333n
.meas tran busy_c6_p0 find v(busy) at=6241.6667n
.meas tran smpl_c6_p0 find v(sample_int) at=6241.6667n
.meas tran busy_c6_p1 find v(busy) at=6325.0000n
.meas tran smpl_c6_p1 find v(sample_int) at=6325.0000n
.meas tran busy_c6_p2 find v(busy) at=6408.3333n
.meas tran smpl_c6_p2 find v(sample_int) at=6408.3333n
.meas tran busy_c6_p3 find v(busy) at=6491.6667n
.meas tran smpl_c6_p3 find v(sample_int) at=6491.6667n
.meas tran busy_c6_p4 find v(busy) at=6575.0000n
.meas tran smpl_c6_p4 find v(sample_int) at=6575.0000n
.meas tran busy_c6_p5 find v(busy) at=6658.3333n
.meas tran smpl_c6_p5 find v(sample_int) at=6658.3333n
.meas tran busy_c6_p6 find v(busy) at=6741.6667n
.meas tran smpl_c6_p6 find v(sample_int) at=6741.6667n
.meas tran busy_c6_p7 find v(busy) at=6825.0000n
.meas tran smpl_c6_p7 find v(sample_int) at=6825.0000n
.meas tran busy_c6_p8 find v(busy) at=6908.3333n
.meas tran smpl_c6_p8 find v(sample_int) at=6908.3333n
.meas tran busy_c6_p9 find v(busy) at=6991.6667n
.meas tran smpl_c6_p9 find v(sample_int) at=6991.6667n
.meas tran busy_c6_p10 find v(busy) at=7075.0000n
.meas tran smpl_c6_p10 find v(sample_int) at=7075.0000n
.meas tran busy_c6_p11 find v(busy) at=7158.3333n
.meas tran smpl_c6_p11 find v(sample_int) at=7158.3333n
.meas tran busy_c7_p0 find v(busy) at=7241.6667n
.meas tran smpl_c7_p0 find v(sample_int) at=7241.6667n
.meas tran busy_c7_p1 find v(busy) at=7325.0000n
.meas tran smpl_c7_p1 find v(sample_int) at=7325.0000n
.meas tran busy_c7_p2 find v(busy) at=7408.3333n
.meas tran smpl_c7_p2 find v(sample_int) at=7408.3333n
.meas tran busy_c7_p3 find v(busy) at=7491.6667n
.meas tran smpl_c7_p3 find v(sample_int) at=7491.6667n
.meas tran busy_c7_p4 find v(busy) at=7575.0000n
.meas tran smpl_c7_p4 find v(sample_int) at=7575.0000n
.meas tran busy_c7_p5 find v(busy) at=7658.3333n
.meas tran smpl_c7_p5 find v(sample_int) at=7658.3333n
.meas tran busy_c7_p6 find v(busy) at=7741.6667n
.meas tran smpl_c7_p6 find v(sample_int) at=7741.6667n
.meas tran busy_c7_p7 find v(busy) at=7825.0000n
.meas tran smpl_c7_p7 find v(sample_int) at=7825.0000n
.meas tran busy_c7_p8 find v(busy) at=7908.3333n
.meas tran smpl_c7_p8 find v(sample_int) at=7908.3333n
.meas tran busy_c7_p9 find v(busy) at=7991.6667n
.meas tran smpl_c7_p9 find v(sample_int) at=7991.6667n
.meas tran busy_c7_p10 find v(busy) at=8075.0000n
.meas tran smpl_c7_p10 find v(sample_int) at=8075.0000n
.meas tran busy_c7_p11 find v(busy) at=8158.3333n
.meas tran smpl_c7_p11 find v(sample_int) at=8158.3333n
.meas tran busy_c8_p0 find v(busy) at=8241.6667n
.meas tran smpl_c8_p0 find v(sample_int) at=8241.6667n
.meas tran busy_c8_p1 find v(busy) at=8325.0000n
.meas tran smpl_c8_p1 find v(sample_int) at=8325.0000n
.meas tran busy_c8_p2 find v(busy) at=8408.3333n
.meas tran smpl_c8_p2 find v(sample_int) at=8408.3333n
.meas tran busy_c8_p3 find v(busy) at=8491.6667n
.meas tran smpl_c8_p3 find v(sample_int) at=8491.6667n
.meas tran busy_c8_p4 find v(busy) at=8575.0000n
.meas tran smpl_c8_p4 find v(sample_int) at=8575.0000n
.meas tran busy_c8_p5 find v(busy) at=8658.3333n
.meas tran smpl_c8_p5 find v(sample_int) at=8658.3333n
.meas tran busy_c8_p6 find v(busy) at=8741.6667n
.meas tran smpl_c8_p6 find v(sample_int) at=8741.6667n
.meas tran busy_c8_p7 find v(busy) at=8825.0000n
.meas tran smpl_c8_p7 find v(sample_int) at=8825.0000n
.meas tran busy_c8_p8 find v(busy) at=8908.3333n
.meas tran smpl_c8_p8 find v(sample_int) at=8908.3333n
.meas tran busy_c8_p9 find v(busy) at=8991.6667n
.meas tran smpl_c8_p9 find v(sample_int) at=8991.6667n
.meas tran busy_c8_p10 find v(busy) at=9075.0000n
.meas tran smpl_c8_p10 find v(sample_int) at=9075.0000n
.meas tran busy_c8_p11 find v(busy) at=9158.3333n
.meas tran smpl_c8_p11 find v(sample_int) at=9158.3333n
.meas tran busy_c9_p0 find v(busy) at=9241.6667n
.meas tran smpl_c9_p0 find v(sample_int) at=9241.6667n
.meas tran busy_c9_p1 find v(busy) at=9325.0000n
.meas tran smpl_c9_p1 find v(sample_int) at=9325.0000n
.meas tran busy_c9_p2 find v(busy) at=9408.3333n
.meas tran smpl_c9_p2 find v(sample_int) at=9408.3333n
.meas tran busy_c9_p3 find v(busy) at=9491.6667n
.meas tran smpl_c9_p3 find v(sample_int) at=9491.6667n
.meas tran busy_c9_p4 find v(busy) at=9575.0000n
.meas tran smpl_c9_p4 find v(sample_int) at=9575.0000n
.meas tran busy_c9_p5 find v(busy) at=9658.3333n
.meas tran smpl_c9_p5 find v(sample_int) at=9658.3333n
.meas tran busy_c9_p6 find v(busy) at=9741.6667n
.meas tran smpl_c9_p6 find v(sample_int) at=9741.6667n
.meas tran busy_c9_p7 find v(busy) at=9825.0000n
.meas tran smpl_c9_p7 find v(sample_int) at=9825.0000n
.meas tran busy_c9_p8 find v(busy) at=9908.3333n
.meas tran smpl_c9_p8 find v(sample_int) at=9908.3333n
.meas tran busy_c9_p9 find v(busy) at=9991.6667n
.meas tran smpl_c9_p9 find v(sample_int) at=9991.6667n
.meas tran busy_c9_p10 find v(busy) at=10075.0000n
.meas tran smpl_c9_p10 find v(sample_int) at=10075.0000n
.meas tran busy_c9_p11 find v(busy) at=10158.3333n
.meas tran smpl_c9_p11 find v(sample_int) at=10158.3333n
.meas tran busy_c10_p0 find v(busy) at=10241.6667n
.meas tran smpl_c10_p0 find v(sample_int) at=10241.6667n
.meas tran busy_c10_p1 find v(busy) at=10325.0000n
.meas tran smpl_c10_p1 find v(sample_int) at=10325.0000n
.meas tran busy_c10_p2 find v(busy) at=10408.3333n
.meas tran smpl_c10_p2 find v(sample_int) at=10408.3333n
.meas tran busy_c10_p3 find v(busy) at=10491.6667n
.meas tran smpl_c10_p3 find v(sample_int) at=10491.6667n
.meas tran busy_c10_p4 find v(busy) at=10575.0000n
.meas tran smpl_c10_p4 find v(sample_int) at=10575.0000n
.meas tran busy_c10_p5 find v(busy) at=10658.3333n
.meas tran smpl_c10_p5 find v(sample_int) at=10658.3333n
.meas tran busy_c10_p6 find v(busy) at=10741.6667n
.meas tran smpl_c10_p6 find v(sample_int) at=10741.6667n
.meas tran busy_c10_p7 find v(busy) at=10825.0000n
.meas tran smpl_c10_p7 find v(sample_int) at=10825.0000n
.meas tran busy_c10_p8 find v(busy) at=10908.3333n
.meas tran smpl_c10_p8 find v(sample_int) at=10908.3333n
.meas tran busy_c10_p9 find v(busy) at=10991.6667n
.meas tran smpl_c10_p9 find v(sample_int) at=10991.6667n
.meas tran busy_c10_p10 find v(busy) at=11075.0000n
.meas tran smpl_c10_p10 find v(sample_int) at=11075.0000n
.meas tran busy_c10_p11 find v(busy) at=11158.3333n
.meas tran smpl_c10_p11 find v(sample_int) at=11158.3333n
.meas tran busy_c11_p0 find v(busy) at=11241.6667n
.meas tran smpl_c11_p0 find v(sample_int) at=11241.6667n
.meas tran busy_c11_p1 find v(busy) at=11325.0000n
.meas tran smpl_c11_p1 find v(sample_int) at=11325.0000n
.meas tran busy_c11_p2 find v(busy) at=11408.3333n
.meas tran smpl_c11_p2 find v(sample_int) at=11408.3333n
.meas tran busy_c11_p3 find v(busy) at=11491.6667n
.meas tran smpl_c11_p3 find v(sample_int) at=11491.6667n
.meas tran busy_c11_p4 find v(busy) at=11575.0000n
.meas tran smpl_c11_p4 find v(sample_int) at=11575.0000n
.meas tran busy_c11_p5 find v(busy) at=11658.3333n
.meas tran smpl_c11_p5 find v(sample_int) at=11658.3333n
.meas tran busy_c11_p6 find v(busy) at=11741.6667n
.meas tran smpl_c11_p6 find v(sample_int) at=11741.6667n
.meas tran busy_c11_p7 find v(busy) at=11825.0000n
.meas tran smpl_c11_p7 find v(sample_int) at=11825.0000n
.meas tran busy_c11_p8 find v(busy) at=11908.3333n
.meas tran smpl_c11_p8 find v(sample_int) at=11908.3333n
.meas tran busy_c11_p9 find v(busy) at=11991.6667n
.meas tran smpl_c11_p9 find v(sample_int) at=11991.6667n
.meas tran busy_c11_p10 find v(busy) at=12075.0000n
.meas tran smpl_c11_p10 find v(sample_int) at=12075.0000n
.meas tran busy_c11_p11 find v(busy) at=12158.3333n
.meas tran smpl_c11_p11 find v(sample_int) at=12158.3333n
.meas tran busy_c12_p0 find v(busy) at=12241.6667n
.meas tran smpl_c12_p0 find v(sample_int) at=12241.6667n
.meas tran busy_c12_p1 find v(busy) at=12325.0000n
.meas tran smpl_c12_p1 find v(sample_int) at=12325.0000n
.meas tran busy_c12_p2 find v(busy) at=12408.3333n
.meas tran smpl_c12_p2 find v(sample_int) at=12408.3333n
.meas tran busy_c12_p3 find v(busy) at=12491.6667n
.meas tran smpl_c12_p3 find v(sample_int) at=12491.6667n
.meas tran busy_c12_p4 find v(busy) at=12575.0000n
.meas tran smpl_c12_p4 find v(sample_int) at=12575.0000n
.meas tran busy_c12_p5 find v(busy) at=12658.3333n
.meas tran smpl_c12_p5 find v(sample_int) at=12658.3333n
.meas tran busy_c12_p6 find v(busy) at=12741.6667n
.meas tran smpl_c12_p6 find v(sample_int) at=12741.6667n
.meas tran busy_c12_p7 find v(busy) at=12825.0000n
.meas tran smpl_c12_p7 find v(sample_int) at=12825.0000n
.meas tran busy_c12_p8 find v(busy) at=12908.3333n
.meas tran smpl_c12_p8 find v(sample_int) at=12908.3333n
.meas tran busy_c12_p9 find v(busy) at=12991.6667n
.meas tran smpl_c12_p9 find v(sample_int) at=12991.6667n
.meas tran busy_c12_p10 find v(busy) at=13075.0000n
.meas tran smpl_c12_p10 find v(sample_int) at=13075.0000n
.meas tran busy_c12_p11 find v(busy) at=13158.3333n
.meas tran smpl_c12_p11 find v(sample_int) at=13158.3333n
.meas tran busy_c13_p0 find v(busy) at=13241.6667n
.meas tran smpl_c13_p0 find v(sample_int) at=13241.6667n
.meas tran busy_c13_p1 find v(busy) at=13325.0000n
.meas tran smpl_c13_p1 find v(sample_int) at=13325.0000n
.meas tran busy_c13_p2 find v(busy) at=13408.3333n
.meas tran smpl_c13_p2 find v(sample_int) at=13408.3333n
.meas tran busy_c13_p3 find v(busy) at=13491.6667n
.meas tran smpl_c13_p3 find v(sample_int) at=13491.6667n
.meas tran busy_c13_p4 find v(busy) at=13575.0000n
.meas tran smpl_c13_p4 find v(sample_int) at=13575.0000n
.meas tran busy_c13_p5 find v(busy) at=13658.3333n
.meas tran smpl_c13_p5 find v(sample_int) at=13658.3333n
.meas tran busy_c13_p6 find v(busy) at=13741.6667n
.meas tran smpl_c13_p6 find v(sample_int) at=13741.6667n
.meas tran busy_c13_p7 find v(busy) at=13825.0000n
.meas tran smpl_c13_p7 find v(sample_int) at=13825.0000n
.meas tran busy_c13_p8 find v(busy) at=13908.3333n
.meas tran smpl_c13_p8 find v(sample_int) at=13908.3333n
.meas tran busy_c13_p9 find v(busy) at=13991.6667n
.meas tran smpl_c13_p9 find v(sample_int) at=13991.6667n
.meas tran busy_c13_p10 find v(busy) at=14075.0000n
.meas tran smpl_c13_p10 find v(sample_int) at=14075.0000n
.meas tran busy_c13_p11 find v(busy) at=14158.3333n
.meas tran smpl_c13_p11 find v(sample_int) at=14158.3333n
.meas tran busy_c14_p0 find v(busy) at=14241.6667n
.meas tran smpl_c14_p0 find v(sample_int) at=14241.6667n
.meas tran busy_c14_p1 find v(busy) at=14325.0000n
.meas tran smpl_c14_p1 find v(sample_int) at=14325.0000n
.meas tran busy_c14_p2 find v(busy) at=14408.3333n
.meas tran smpl_c14_p2 find v(sample_int) at=14408.3333n
.meas tran busy_c14_p3 find v(busy) at=14491.6667n
.meas tran smpl_c14_p3 find v(sample_int) at=14491.6667n
.meas tran busy_c14_p4 find v(busy) at=14575.0000n
.meas tran smpl_c14_p4 find v(sample_int) at=14575.0000n
.meas tran busy_c14_p5 find v(busy) at=14658.3333n
.meas tran smpl_c14_p5 find v(sample_int) at=14658.3333n
.meas tran busy_c14_p6 find v(busy) at=14741.6667n
.meas tran smpl_c14_p6 find v(sample_int) at=14741.6667n
.meas tran busy_c14_p7 find v(busy) at=14825.0000n
.meas tran smpl_c14_p7 find v(sample_int) at=14825.0000n
.meas tran busy_c14_p8 find v(busy) at=14908.3333n
.meas tran smpl_c14_p8 find v(sample_int) at=14908.3333n
.meas tran busy_c14_p9 find v(busy) at=14991.6667n
.meas tran smpl_c14_p9 find v(sample_int) at=14991.6667n
.meas tran busy_c14_p10 find v(busy) at=15075.0000n
.meas tran smpl_c14_p10 find v(sample_int) at=15075.0000n
.meas tran busy_c14_p11 find v(busy) at=15158.3333n
.meas tran smpl_c14_p11 find v(sample_int) at=15158.3333n
.meas tran busy_c15_p0 find v(busy) at=15241.6667n
.meas tran smpl_c15_p0 find v(sample_int) at=15241.6667n
.meas tran busy_c15_p1 find v(busy) at=15325.0000n
.meas tran smpl_c15_p1 find v(sample_int) at=15325.0000n
.meas tran busy_c15_p2 find v(busy) at=15408.3333n
.meas tran smpl_c15_p2 find v(sample_int) at=15408.3333n
.meas tran busy_c15_p3 find v(busy) at=15491.6667n
.meas tran smpl_c15_p3 find v(sample_int) at=15491.6667n
.meas tran busy_c15_p4 find v(busy) at=15575.0000n
.meas tran smpl_c15_p4 find v(sample_int) at=15575.0000n
.meas tran busy_c15_p5 find v(busy) at=15658.3333n
.meas tran smpl_c15_p5 find v(sample_int) at=15658.3333n
.meas tran busy_c15_p6 find v(busy) at=15741.6667n
.meas tran smpl_c15_p6 find v(sample_int) at=15741.6667n
.meas tran busy_c15_p7 find v(busy) at=15825.0000n
.meas tran smpl_c15_p7 find v(sample_int) at=15825.0000n
.meas tran busy_c15_p8 find v(busy) at=15908.3333n
.meas tran smpl_c15_p8 find v(sample_int) at=15908.3333n
.meas tran busy_c15_p9 find v(busy) at=15991.6667n
.meas tran smpl_c15_p9 find v(sample_int) at=15991.6667n
.meas tran busy_c15_p10 find v(busy) at=16075.0000n
.meas tran smpl_c15_p10 find v(sample_int) at=16075.0000n
.meas tran busy_c15_p11 find v(busy) at=16158.3333n
.meas tran smpl_c15_p11 find v(sample_int) at=16158.3333n
.meas tran busy_c16_p0 find v(busy) at=16241.6667n
.meas tran smpl_c16_p0 find v(sample_int) at=16241.6667n
.meas tran busy_c16_p1 find v(busy) at=16325.0000n
.meas tran smpl_c16_p1 find v(sample_int) at=16325.0000n
.meas tran busy_c16_p2 find v(busy) at=16408.3333n
.meas tran smpl_c16_p2 find v(sample_int) at=16408.3333n
.meas tran busy_c16_p3 find v(busy) at=16491.6667n
.meas tran smpl_c16_p3 find v(sample_int) at=16491.6667n
.meas tran busy_c16_p4 find v(busy) at=16575.0000n
.meas tran smpl_c16_p4 find v(sample_int) at=16575.0000n
.meas tran busy_c16_p5 find v(busy) at=16658.3333n
.meas tran smpl_c16_p5 find v(sample_int) at=16658.3333n
.meas tran busy_c16_p6 find v(busy) at=16741.6667n
.meas tran smpl_c16_p6 find v(sample_int) at=16741.6667n
.meas tran busy_c16_p7 find v(busy) at=16825.0000n
.meas tran smpl_c16_p7 find v(sample_int) at=16825.0000n
.meas tran busy_c16_p8 find v(busy) at=16908.3333n
.meas tran smpl_c16_p8 find v(sample_int) at=16908.3333n
.meas tran busy_c16_p9 find v(busy) at=16991.6667n
.meas tran smpl_c16_p9 find v(sample_int) at=16991.6667n
.meas tran busy_c16_p10 find v(busy) at=17075.0000n
.meas tran smpl_c16_p10 find v(sample_int) at=17075.0000n
.meas tran busy_c16_p11 find v(busy) at=17158.3333n
.meas tran smpl_c16_p11 find v(sample_int) at=17158.3333n
.meas tran busy_c17_p0 find v(busy) at=17241.6667n
.meas tran smpl_c17_p0 find v(sample_int) at=17241.6667n
.meas tran busy_c17_p1 find v(busy) at=17325.0000n
.meas tran smpl_c17_p1 find v(sample_int) at=17325.0000n
.meas tran busy_c17_p2 find v(busy) at=17408.3333n
.meas tran smpl_c17_p2 find v(sample_int) at=17408.3333n
.meas tran busy_c17_p3 find v(busy) at=17491.6667n
.meas tran smpl_c17_p3 find v(sample_int) at=17491.6667n
.meas tran busy_c17_p4 find v(busy) at=17575.0000n
.meas tran smpl_c17_p4 find v(sample_int) at=17575.0000n
.meas tran busy_c17_p5 find v(busy) at=17658.3333n
.meas tran smpl_c17_p5 find v(sample_int) at=17658.3333n
.meas tran busy_c17_p6 find v(busy) at=17741.6667n
.meas tran smpl_c17_p6 find v(sample_int) at=17741.6667n
.meas tran busy_c17_p7 find v(busy) at=17825.0000n
.meas tran smpl_c17_p7 find v(sample_int) at=17825.0000n
.meas tran busy_c17_p8 find v(busy) at=17908.3333n
.meas tran smpl_c17_p8 find v(sample_int) at=17908.3333n
.meas tran busy_c17_p9 find v(busy) at=17991.6667n
.meas tran smpl_c17_p9 find v(sample_int) at=17991.6667n
.meas tran busy_c17_p10 find v(busy) at=18075.0000n
.meas tran smpl_c17_p10 find v(sample_int) at=18075.0000n
.meas tran busy_c17_p11 find v(busy) at=18158.3333n
.meas tran smpl_c17_p11 find v(sample_int) at=18158.3333n
.meas tran busy_c18_p0 find v(busy) at=18241.6667n
.meas tran smpl_c18_p0 find v(sample_int) at=18241.6667n
.meas tran busy_c18_p1 find v(busy) at=18325.0000n
.meas tran smpl_c18_p1 find v(sample_int) at=18325.0000n
.meas tran busy_c18_p2 find v(busy) at=18408.3333n
.meas tran smpl_c18_p2 find v(sample_int) at=18408.3333n
.meas tran busy_c18_p3 find v(busy) at=18491.6667n
.meas tran smpl_c18_p3 find v(sample_int) at=18491.6667n
.meas tran busy_c18_p4 find v(busy) at=18575.0000n
.meas tran smpl_c18_p4 find v(sample_int) at=18575.0000n
.meas tran busy_c18_p5 find v(busy) at=18658.3333n
.meas tran smpl_c18_p5 find v(sample_int) at=18658.3333n
.meas tran busy_c18_p6 find v(busy) at=18741.6667n
.meas tran smpl_c18_p6 find v(sample_int) at=18741.6667n
.meas tran busy_c18_p7 find v(busy) at=18825.0000n
.meas tran smpl_c18_p7 find v(sample_int) at=18825.0000n
.meas tran busy_c18_p8 find v(busy) at=18908.3333n
.meas tran smpl_c18_p8 find v(sample_int) at=18908.3333n
.meas tran busy_c18_p9 find v(busy) at=18991.6667n
.meas tran smpl_c18_p9 find v(sample_int) at=18991.6667n
.meas tran busy_c18_p10 find v(busy) at=19075.0000n
.meas tran smpl_c18_p10 find v(sample_int) at=19075.0000n
.meas tran busy_c18_p11 find v(busy) at=19158.3333n
.meas tran smpl_c18_p11 find v(sample_int) at=19158.3333n
.meas tran busy_c19_p0 find v(busy) at=19241.6667n
.meas tran smpl_c19_p0 find v(sample_int) at=19241.6667n
.meas tran busy_c19_p1 find v(busy) at=19325.0000n
.meas tran smpl_c19_p1 find v(sample_int) at=19325.0000n
.meas tran busy_c19_p2 find v(busy) at=19408.3333n
.meas tran smpl_c19_p2 find v(sample_int) at=19408.3333n
.meas tran busy_c19_p3 find v(busy) at=19491.6667n
.meas tran smpl_c19_p3 find v(sample_int) at=19491.6667n
.meas tran busy_c19_p4 find v(busy) at=19575.0000n
.meas tran smpl_c19_p4 find v(sample_int) at=19575.0000n
.meas tran busy_c19_p5 find v(busy) at=19658.3333n
.meas tran smpl_c19_p5 find v(sample_int) at=19658.3333n
.meas tran busy_c19_p6 find v(busy) at=19741.6667n
.meas tran smpl_c19_p6 find v(sample_int) at=19741.6667n
.meas tran busy_c19_p7 find v(busy) at=19825.0000n
.meas tran smpl_c19_p7 find v(sample_int) at=19825.0000n
.meas tran busy_c19_p8 find v(busy) at=19908.3333n
.meas tran smpl_c19_p8 find v(sample_int) at=19908.3333n
.meas tran busy_c19_p9 find v(busy) at=19991.6667n
.meas tran smpl_c19_p9 find v(sample_int) at=19991.6667n
.meas tran busy_c19_p10 find v(busy) at=20075.0000n
.meas tran smpl_c19_p10 find v(sample_int) at=20075.0000n
.meas tran busy_c19_p11 find v(busy) at=20158.3333n
.meas tran smpl_c19_p11 find v(sample_int) at=20158.3333n
.meas tran busy_c20_p0 find v(busy) at=20241.6667n
.meas tran smpl_c20_p0 find v(sample_int) at=20241.6667n
.meas tran busy_c20_p1 find v(busy) at=20325.0000n
.meas tran smpl_c20_p1 find v(sample_int) at=20325.0000n
.meas tran busy_c20_p2 find v(busy) at=20408.3333n
.meas tran smpl_c20_p2 find v(sample_int) at=20408.3333n
.meas tran busy_c20_p3 find v(busy) at=20491.6667n
.meas tran smpl_c20_p3 find v(sample_int) at=20491.6667n
.meas tran busy_c20_p4 find v(busy) at=20575.0000n
.meas tran smpl_c20_p4 find v(sample_int) at=20575.0000n
.meas tran busy_c20_p5 find v(busy) at=20658.3333n
.meas tran smpl_c20_p5 find v(sample_int) at=20658.3333n
.meas tran busy_c20_p6 find v(busy) at=20741.6667n
.meas tran smpl_c20_p6 find v(sample_int) at=20741.6667n
.meas tran busy_c20_p7 find v(busy) at=20825.0000n
.meas tran smpl_c20_p7 find v(sample_int) at=20825.0000n
.meas tran busy_c20_p8 find v(busy) at=20908.3333n
.meas tran smpl_c20_p8 find v(sample_int) at=20908.3333n
.meas tran busy_c20_p9 find v(busy) at=20991.6667n
.meas tran smpl_c20_p9 find v(sample_int) at=20991.6667n
.meas tran busy_c20_p10 find v(busy) at=21075.0000n
.meas tran smpl_c20_p10 find v(sample_int) at=21075.0000n
.meas tran busy_c20_p11 find v(busy) at=21158.3333n
.meas tran smpl_c20_p11 find v(sample_int) at=21158.3333n
.meas tran busy_c21_p0 find v(busy) at=21241.6667n
.meas tran smpl_c21_p0 find v(sample_int) at=21241.6667n
.meas tran busy_c21_p1 find v(busy) at=21325.0000n
.meas tran smpl_c21_p1 find v(sample_int) at=21325.0000n
.meas tran busy_c21_p2 find v(busy) at=21408.3333n
.meas tran smpl_c21_p2 find v(sample_int) at=21408.3333n
.meas tran busy_c21_p3 find v(busy) at=21491.6667n
.meas tran smpl_c21_p3 find v(sample_int) at=21491.6667n
.meas tran busy_c21_p4 find v(busy) at=21575.0000n
.meas tran smpl_c21_p4 find v(sample_int) at=21575.0000n
.meas tran busy_c21_p5 find v(busy) at=21658.3333n
.meas tran smpl_c21_p5 find v(sample_int) at=21658.3333n
.meas tran busy_c21_p6 find v(busy) at=21741.6667n
.meas tran smpl_c21_p6 find v(sample_int) at=21741.6667n
.meas tran busy_c21_p7 find v(busy) at=21825.0000n
.meas tran smpl_c21_p7 find v(sample_int) at=21825.0000n
.meas tran busy_c21_p8 find v(busy) at=21908.3333n
.meas tran smpl_c21_p8 find v(sample_int) at=21908.3333n
.meas tran busy_c21_p9 find v(busy) at=21991.6667n
.meas tran smpl_c21_p9 find v(sample_int) at=21991.6667n
.meas tran busy_c21_p10 find v(busy) at=22075.0000n
.meas tran smpl_c21_p10 find v(sample_int) at=22075.0000n
.meas tran busy_c21_p11 find v(busy) at=22158.3333n
.meas tran smpl_c21_p11 find v(sample_int) at=22158.3333n
.meas tran busy_c22_p0 find v(busy) at=22241.6667n
.meas tran smpl_c22_p0 find v(sample_int) at=22241.6667n
.meas tran busy_c22_p1 find v(busy) at=22325.0000n
.meas tran smpl_c22_p1 find v(sample_int) at=22325.0000n
.meas tran busy_c22_p2 find v(busy) at=22408.3333n
.meas tran smpl_c22_p2 find v(sample_int) at=22408.3333n
.meas tran busy_c22_p3 find v(busy) at=22491.6667n
.meas tran smpl_c22_p3 find v(sample_int) at=22491.6667n
.meas tran busy_c22_p4 find v(busy) at=22575.0000n
.meas tran smpl_c22_p4 find v(sample_int) at=22575.0000n
.meas tran busy_c22_p5 find v(busy) at=22658.3333n
.meas tran smpl_c22_p5 find v(sample_int) at=22658.3333n
.meas tran busy_c22_p6 find v(busy) at=22741.6667n
.meas tran smpl_c22_p6 find v(sample_int) at=22741.6667n
.meas tran busy_c22_p7 find v(busy) at=22825.0000n
.meas tran smpl_c22_p7 find v(sample_int) at=22825.0000n
.meas tran busy_c22_p8 find v(busy) at=22908.3333n
.meas tran smpl_c22_p8 find v(sample_int) at=22908.3333n
.meas tran busy_c22_p9 find v(busy) at=22991.6667n
.meas tran smpl_c22_p9 find v(sample_int) at=22991.6667n
.meas tran busy_c22_p10 find v(busy) at=23075.0000n
.meas tran smpl_c22_p10 find v(sample_int) at=23075.0000n
.meas tran busy_c22_p11 find v(busy) at=23158.3333n
.meas tran smpl_c22_p11 find v(sample_int) at=23158.3333n
.meas tran busy_c23_p0 find v(busy) at=23241.6667n
.meas tran smpl_c23_p0 find v(sample_int) at=23241.6667n
.meas tran busy_c23_p1 find v(busy) at=23325.0000n
.meas tran smpl_c23_p1 find v(sample_int) at=23325.0000n
.meas tran busy_c23_p2 find v(busy) at=23408.3333n
.meas tran smpl_c23_p2 find v(sample_int) at=23408.3333n
.meas tran busy_c23_p3 find v(busy) at=23491.6667n
.meas tran smpl_c23_p3 find v(sample_int) at=23491.6667n
.meas tran busy_c23_p4 find v(busy) at=23575.0000n
.meas tran smpl_c23_p4 find v(sample_int) at=23575.0000n
.meas tran busy_c23_p5 find v(busy) at=23658.3333n
.meas tran smpl_c23_p5 find v(sample_int) at=23658.3333n
.meas tran busy_c23_p6 find v(busy) at=23741.6667n
.meas tran smpl_c23_p6 find v(sample_int) at=23741.6667n
.meas tran busy_c23_p7 find v(busy) at=23825.0000n
.meas tran smpl_c23_p7 find v(sample_int) at=23825.0000n
.meas tran busy_c23_p8 find v(busy) at=23908.3333n
.meas tran smpl_c23_p8 find v(sample_int) at=23908.3333n
.meas tran busy_c23_p9 find v(busy) at=23991.6667n
.meas tran smpl_c23_p9 find v(sample_int) at=23991.6667n
.meas tran busy_c23_p10 find v(busy) at=24075.0000n
.meas tran smpl_c23_p10 find v(sample_int) at=24075.0000n
.meas tran busy_c23_p11 find v(busy) at=24158.3333n
.meas tran smpl_c23_p11 find v(sample_int) at=24158.3333n
.meas tran busy_c24_p0 find v(busy) at=24241.6667n
.meas tran smpl_c24_p0 find v(sample_int) at=24241.6667n
.meas tran busy_c24_p1 find v(busy) at=24325.0000n
.meas tran smpl_c24_p1 find v(sample_int) at=24325.0000n
.meas tran busy_c24_p2 find v(busy) at=24408.3333n
.meas tran smpl_c24_p2 find v(sample_int) at=24408.3333n
.meas tran busy_c24_p3 find v(busy) at=24491.6667n
.meas tran smpl_c24_p3 find v(sample_int) at=24491.6667n
.meas tran busy_c24_p4 find v(busy) at=24575.0000n
.meas tran smpl_c24_p4 find v(sample_int) at=24575.0000n
.meas tran busy_c24_p5 find v(busy) at=24658.3333n
.meas tran smpl_c24_p5 find v(sample_int) at=24658.3333n
.meas tran busy_c24_p6 find v(busy) at=24741.6667n
.meas tran smpl_c24_p6 find v(sample_int) at=24741.6667n
.meas tran busy_c24_p7 find v(busy) at=24825.0000n
.meas tran smpl_c24_p7 find v(sample_int) at=24825.0000n
.meas tran busy_c24_p8 find v(busy) at=24908.3333n
.meas tran smpl_c24_p8 find v(sample_int) at=24908.3333n
.meas tran busy_c24_p9 find v(busy) at=24991.6667n
.meas tran smpl_c24_p9 find v(sample_int) at=24991.6667n
.meas tran busy_c24_p10 find v(busy) at=25075.0000n
.meas tran smpl_c24_p10 find v(sample_int) at=25075.0000n
.meas tran busy_c24_p11 find v(busy) at=25158.3333n
.meas tran smpl_c24_p11 find v(sample_int) at=25158.3333n
.meas tran busy_c25_p0 find v(busy) at=25241.6667n
.meas tran smpl_c25_p0 find v(sample_int) at=25241.6667n
.meas tran busy_c25_p1 find v(busy) at=25325.0000n
.meas tran smpl_c25_p1 find v(sample_int) at=25325.0000n
.meas tran busy_c25_p2 find v(busy) at=25408.3333n
.meas tran smpl_c25_p2 find v(sample_int) at=25408.3333n
.meas tran busy_c25_p3 find v(busy) at=25491.6667n
.meas tran smpl_c25_p3 find v(sample_int) at=25491.6667n
.meas tran busy_c25_p4 find v(busy) at=25575.0000n
.meas tran smpl_c25_p4 find v(sample_int) at=25575.0000n
.meas tran busy_c25_p5 find v(busy) at=25658.3333n
.meas tran smpl_c25_p5 find v(sample_int) at=25658.3333n
.meas tran busy_c25_p6 find v(busy) at=25741.6667n
.meas tran smpl_c25_p6 find v(sample_int) at=25741.6667n
.meas tran busy_c25_p7 find v(busy) at=25825.0000n
.meas tran smpl_c25_p7 find v(sample_int) at=25825.0000n
.meas tran busy_c25_p8 find v(busy) at=25908.3333n
.meas tran smpl_c25_p8 find v(sample_int) at=25908.3333n
.meas tran busy_c25_p9 find v(busy) at=25991.6667n
.meas tran smpl_c25_p9 find v(sample_int) at=25991.6667n
.meas tran busy_c25_p10 find v(busy) at=26075.0000n
.meas tran smpl_c25_p10 find v(sample_int) at=26075.0000n
.meas tran busy_c25_p11 find v(busy) at=26158.3333n
.meas tran smpl_c25_p11 find v(sample_int) at=26158.3333n
.meas tran busy_c26_p0 find v(busy) at=26241.6667n
.meas tran smpl_c26_p0 find v(sample_int) at=26241.6667n
.meas tran busy_c26_p1 find v(busy) at=26325.0000n
.meas tran smpl_c26_p1 find v(sample_int) at=26325.0000n
.meas tran busy_c26_p2 find v(busy) at=26408.3333n
.meas tran smpl_c26_p2 find v(sample_int) at=26408.3333n
.meas tran busy_c26_p3 find v(busy) at=26491.6667n
.meas tran smpl_c26_p3 find v(sample_int) at=26491.6667n
.meas tran busy_c26_p4 find v(busy) at=26575.0000n
.meas tran smpl_c26_p4 find v(sample_int) at=26575.0000n
.meas tran busy_c26_p5 find v(busy) at=26658.3333n
.meas tran smpl_c26_p5 find v(sample_int) at=26658.3333n
.meas tran busy_c26_p6 find v(busy) at=26741.6667n
.meas tran smpl_c26_p6 find v(sample_int) at=26741.6667n
.meas tran busy_c26_p7 find v(busy) at=26825.0000n
.meas tran smpl_c26_p7 find v(sample_int) at=26825.0000n
.meas tran busy_c26_p8 find v(busy) at=26908.3333n
.meas tran smpl_c26_p8 find v(sample_int) at=26908.3333n
.meas tran busy_c26_p9 find v(busy) at=26991.6667n
.meas tran smpl_c26_p9 find v(sample_int) at=26991.6667n
.meas tran busy_c26_p10 find v(busy) at=27075.0000n
.meas tran smpl_c26_p10 find v(sample_int) at=27075.0000n
.meas tran busy_c26_p11 find v(busy) at=27158.3333n
.meas tran smpl_c26_p11 find v(sample_int) at=27158.3333n
.meas tran busy_c27_p0 find v(busy) at=27241.6667n
.meas tran smpl_c27_p0 find v(sample_int) at=27241.6667n
.meas tran busy_c27_p1 find v(busy) at=27325.0000n
.meas tran smpl_c27_p1 find v(sample_int) at=27325.0000n
.meas tran busy_c27_p2 find v(busy) at=27408.3333n
.meas tran smpl_c27_p2 find v(sample_int) at=27408.3333n
.meas tran busy_c27_p3 find v(busy) at=27491.6667n
.meas tran smpl_c27_p3 find v(sample_int) at=27491.6667n
.meas tran busy_c27_p4 find v(busy) at=27575.0000n
.meas tran smpl_c27_p4 find v(sample_int) at=27575.0000n
.meas tran busy_c27_p5 find v(busy) at=27658.3333n
.meas tran smpl_c27_p5 find v(sample_int) at=27658.3333n
.meas tran busy_c27_p6 find v(busy) at=27741.6667n
.meas tran smpl_c27_p6 find v(sample_int) at=27741.6667n
.meas tran busy_c27_p7 find v(busy) at=27825.0000n
.meas tran smpl_c27_p7 find v(sample_int) at=27825.0000n
.meas tran busy_c27_p8 find v(busy) at=27908.3333n
.meas tran smpl_c27_p8 find v(sample_int) at=27908.3333n
.meas tran busy_c27_p9 find v(busy) at=27991.6667n
.meas tran smpl_c27_p9 find v(sample_int) at=27991.6667n
.meas tran busy_c27_p10 find v(busy) at=28075.0000n
.meas tran smpl_c27_p10 find v(sample_int) at=28075.0000n
.meas tran busy_c27_p11 find v(busy) at=28158.3333n
.meas tran smpl_c27_p11 find v(sample_int) at=28158.3333n
.meas tran busy_c28_p0 find v(busy) at=28241.6667n
.meas tran smpl_c28_p0 find v(sample_int) at=28241.6667n
.meas tran busy_c28_p1 find v(busy) at=28325.0000n
.meas tran smpl_c28_p1 find v(sample_int) at=28325.0000n
.meas tran busy_c28_p2 find v(busy) at=28408.3333n
.meas tran smpl_c28_p2 find v(sample_int) at=28408.3333n
.meas tran busy_c28_p3 find v(busy) at=28491.6667n
.meas tran smpl_c28_p3 find v(sample_int) at=28491.6667n
.meas tran busy_c28_p4 find v(busy) at=28575.0000n
.meas tran smpl_c28_p4 find v(sample_int) at=28575.0000n
.meas tran busy_c28_p5 find v(busy) at=28658.3333n
.meas tran smpl_c28_p5 find v(sample_int) at=28658.3333n
.meas tran busy_c28_p6 find v(busy) at=28741.6667n
.meas tran smpl_c28_p6 find v(sample_int) at=28741.6667n
.meas tran busy_c28_p7 find v(busy) at=28825.0000n
.meas tran smpl_c28_p7 find v(sample_int) at=28825.0000n
.meas tran busy_c28_p8 find v(busy) at=28908.3333n
.meas tran smpl_c28_p8 find v(sample_int) at=28908.3333n
.meas tran busy_c28_p9 find v(busy) at=28991.6667n
.meas tran smpl_c28_p9 find v(sample_int) at=28991.6667n
.meas tran busy_c28_p10 find v(busy) at=29075.0000n
.meas tran smpl_c28_p10 find v(sample_int) at=29075.0000n
.meas tran busy_c28_p11 find v(busy) at=29158.3333n
.meas tran smpl_c28_p11 find v(sample_int) at=29158.3333n
.meas tran busy_c29_p0 find v(busy) at=29241.6667n
.meas tran smpl_c29_p0 find v(sample_int) at=29241.6667n
.meas tran busy_c29_p1 find v(busy) at=29325.0000n
.meas tran smpl_c29_p1 find v(sample_int) at=29325.0000n
.meas tran busy_c29_p2 find v(busy) at=29408.3333n
.meas tran smpl_c29_p2 find v(sample_int) at=29408.3333n
.meas tran busy_c29_p3 find v(busy) at=29491.6667n
.meas tran smpl_c29_p3 find v(sample_int) at=29491.6667n
.meas tran busy_c29_p4 find v(busy) at=29575.0000n
.meas tran smpl_c29_p4 find v(sample_int) at=29575.0000n
.meas tran busy_c29_p5 find v(busy) at=29658.3333n
.meas tran smpl_c29_p5 find v(sample_int) at=29658.3333n
.meas tran busy_c29_p6 find v(busy) at=29741.6667n
.meas tran smpl_c29_p6 find v(sample_int) at=29741.6667n
.meas tran busy_c29_p7 find v(busy) at=29825.0000n
.meas tran smpl_c29_p7 find v(sample_int) at=29825.0000n
.meas tran busy_c29_p8 find v(busy) at=29908.3333n
.meas tran smpl_c29_p8 find v(sample_int) at=29908.3333n
.meas tran busy_c29_p9 find v(busy) at=29991.6667n
.meas tran smpl_c29_p9 find v(sample_int) at=29991.6667n
.meas tran busy_c29_p10 find v(busy) at=30075.0000n
.meas tran smpl_c29_p10 find v(sample_int) at=30075.0000n
.meas tran busy_c29_p11 find v(busy) at=30158.3333n
.meas tran smpl_c29_p11 find v(sample_int) at=30158.3333n
.meas tran busy_c30_p0 find v(busy) at=30241.6667n
.meas tran smpl_c30_p0 find v(sample_int) at=30241.6667n
.meas tran busy_c30_p1 find v(busy) at=30325.0000n
.meas tran smpl_c30_p1 find v(sample_int) at=30325.0000n
.meas tran busy_c30_p2 find v(busy) at=30408.3333n
.meas tran smpl_c30_p2 find v(sample_int) at=30408.3333n
.meas tran busy_c30_p3 find v(busy) at=30491.6667n
.meas tran smpl_c30_p3 find v(sample_int) at=30491.6667n
.meas tran busy_c30_p4 find v(busy) at=30575.0000n
.meas tran smpl_c30_p4 find v(sample_int) at=30575.0000n
.meas tran busy_c30_p5 find v(busy) at=30658.3333n
.meas tran smpl_c30_p5 find v(sample_int) at=30658.3333n
.meas tran busy_c30_p6 find v(busy) at=30741.6667n
.meas tran smpl_c30_p6 find v(sample_int) at=30741.6667n
.meas tran busy_c30_p7 find v(busy) at=30825.0000n
.meas tran smpl_c30_p7 find v(sample_int) at=30825.0000n
.meas tran busy_c30_p8 find v(busy) at=30908.3333n
.meas tran smpl_c30_p8 find v(sample_int) at=30908.3333n
.meas tran busy_c30_p9 find v(busy) at=30991.6667n
.meas tran smpl_c30_p9 find v(sample_int) at=30991.6667n
.meas tran busy_c30_p10 find v(busy) at=31075.0000n
.meas tran smpl_c30_p10 find v(sample_int) at=31075.0000n
.meas tran busy_c30_p11 find v(busy) at=31158.3333n
.meas tran smpl_c30_p11 find v(sample_int) at=31158.3333n
.meas tran busy_c31_p0 find v(busy) at=31241.6667n
.meas tran smpl_c31_p0 find v(sample_int) at=31241.6667n
.meas tran busy_c31_p1 find v(busy) at=31325.0000n
.meas tran smpl_c31_p1 find v(sample_int) at=31325.0000n
.meas tran busy_c31_p2 find v(busy) at=31408.3333n
.meas tran smpl_c31_p2 find v(sample_int) at=31408.3333n
.meas tran busy_c31_p3 find v(busy) at=31491.6667n
.meas tran smpl_c31_p3 find v(sample_int) at=31491.6667n
.meas tran busy_c31_p4 find v(busy) at=31575.0000n
.meas tran smpl_c31_p4 find v(sample_int) at=31575.0000n
.meas tran busy_c31_p5 find v(busy) at=31658.3333n
.meas tran smpl_c31_p5 find v(sample_int) at=31658.3333n
.meas tran busy_c31_p6 find v(busy) at=31741.6667n
.meas tran smpl_c31_p6 find v(sample_int) at=31741.6667n
.meas tran busy_c31_p7 find v(busy) at=31825.0000n
.meas tran smpl_c31_p7 find v(sample_int) at=31825.0000n
.meas tran busy_c31_p8 find v(busy) at=31908.3333n
.meas tran smpl_c31_p8 find v(sample_int) at=31908.3333n
.meas tran busy_c31_p9 find v(busy) at=31991.6667n
.meas tran smpl_c31_p9 find v(sample_int) at=31991.6667n
.meas tran busy_c31_p10 find v(busy) at=32075.0000n
.meas tran smpl_c31_p10 find v(sample_int) at=32075.0000n
.meas tran busy_c31_p11 find v(busy) at=32158.3333n
.meas tran smpl_c31_p11 find v(sample_int) at=32158.3333n
.meas tran busy_c32_p0 find v(busy) at=32241.6667n
.meas tran smpl_c32_p0 find v(sample_int) at=32241.6667n
.meas tran busy_c32_p1 find v(busy) at=32325.0000n
.meas tran smpl_c32_p1 find v(sample_int) at=32325.0000n
.meas tran busy_c32_p2 find v(busy) at=32408.3333n
.meas tran smpl_c32_p2 find v(sample_int) at=32408.3333n
.meas tran busy_c32_p3 find v(busy) at=32491.6667n
.meas tran smpl_c32_p3 find v(sample_int) at=32491.6667n
.meas tran busy_c32_p4 find v(busy) at=32575.0000n
.meas tran smpl_c32_p4 find v(sample_int) at=32575.0000n
.meas tran busy_c32_p5 find v(busy) at=32658.3333n
.meas tran smpl_c32_p5 find v(sample_int) at=32658.3333n
.meas tran busy_c32_p6 find v(busy) at=32741.6667n
.meas tran smpl_c32_p6 find v(sample_int) at=32741.6667n
.meas tran busy_c32_p7 find v(busy) at=32825.0000n
.meas tran smpl_c32_p7 find v(sample_int) at=32825.0000n
.meas tran busy_c32_p8 find v(busy) at=32908.3333n
.meas tran smpl_c32_p8 find v(sample_int) at=32908.3333n
.meas tran busy_c32_p9 find v(busy) at=32991.6667n
.meas tran smpl_c32_p9 find v(sample_int) at=32991.6667n
.meas tran busy_c32_p10 find v(busy) at=33075.0000n
.meas tran smpl_c32_p10 find v(sample_int) at=33075.0000n
.meas tran busy_c32_p11 find v(busy) at=33158.3333n
.meas tran smpl_c32_p11 find v(sample_int) at=33158.3333n
