* sim/full-conversion-transient -- converging-range input sweep
* (issue #913, the DR-021 open item) of design/sar_adc_top.spice.
* Assembled by sim/full-conversion-transient/run_conversion.py --input-sweep.
* Circuit body only: klt sim supplies the .lib corner section, .temp,
* the .meas cards, the .tran analysis and the .control wrapper.
* The stimulus/measurement fragment is this experiment's
* testbench/input_sweep_tb_fragment.spice, used verbatim; the swept
* level is its vin_frac top-level parameter, a fraction of vdd_val.
.param vdd_val = 1.8
.param vin_frac = 0.0
.include $PDK_ROOT/sky130A/libs.ref/sky130_fd_sc_hd/spice/sky130_fd_sc_hd.spice
* VPWR/VGND have no schematic-graph node inside sar_sequencer (see
* design/sar_adc_top.sch's header); the testbench ties them here.
.global VPWR VGND

* sar_adc_top.spice -- full-hierarchy SAR ADC netlist (issue #56).
* Regenerate with: ./design/regen_netlist.sh (requires PDK_ROOT/PDK, see
* docs/environment-setup.md). CI fails (design/regen_netlist.sh --check,
* wired into .github/workflows/ci.yml's pdk-smoke job) if this file does
* not match a fresh regeneration from the current schematic sources --
* staleness is failure (this issue's AC4).
*
* Provenance: sha256 of each source schematic this netlist derives from
* (reproduce with: sha256sum <path>). This is the file-content hash, not
* a git commit reference, so it stays meaningful in a shallow CI clone
* and does not drift when an unrelated commit elsewhere touches HEAD.
*   design/sampling_frontend.sch: sha256:59a1888aa4bc4491454dd9f0d5a209da42f0f32c36d1bdf6e217e13a285b2f01
*   design/cdac/cdac_array.sch: sha256:01af2a637837210d9f8c33175532a18ef7911880de8dc181832b76438023348f
*   design/comparator.sch: sha256:f41de8706e334fec841686572647db4441fa365d726ef26c18093777b1629536
*   design/sar_sequencer.sch: sha256:9d76813255ceb43a7f2dcde6cba04d6396cb9e7767c3e0f2cce178b5db849999
*   design/sar_adc_top.sch: sha256:fbd3643f1988a5ed243a1f14d67251640272dd8ca2d923b69bc907179e0b9fc8
*
* Every device instance below is a ratified flavour (nfet_01v8/pfet_01v8/
* cap_mim_m3_1 sky130_fd_pr primitives, or sky130_fd_sc_hd standard
* cells) -- verified mechanically by this script, not by review alone.
** sch_path: design/sar_adc_top.sch
**.subckt sar_adc_top VINP VINN VDD VREFP VREFN VCM CLK RST_B DOUT9 DOUT8 DOUT7 DOUT6 DOUT5 DOUT4 DOUT3 DOUT2 DOUT1 DOUT0 BUSY VPWR VGND GND
*.ipin VINP
*.ipin VINN
*.ipin VDD
*.ipin VREFP
*.ipin VREFN
*.ipin VCM
*.ipin CLK
*.ipin RST_B
*.opin DOUT9
*.opin DOUT8
*.opin DOUT7
*.opin DOUT6
*.opin DOUT5
*.opin DOUT4
*.opin DOUT3
*.opin DOUT2
*.opin DOUT1
*.opin DOUT0
*.opin BUSY
*.ipin VPWR
*.ipin VGND
*.ipin GND
xfe VINP VINN SAMPLE_INT VCM VDD TOP_P TOP_N BPREF_P_NC BPREF_N_NC sampling_frontend
xcdac VREFP VREFN VDD GND SELn0 SELp0 SELn1 SELp1 SELn2 SELp2 SELn3 SELp3 SELn4 SELp4 TOP_N TOP_P SELp5 SELn5 SELp6 SELn6 SELn7 SELp7 SELn8 SELp8 cdac_array
xcmp VDD CLKN TOP_P TOP_N COMP_OUT OUTN_NC comparator
xseq DOUT9 PH_B9 CLK net1 DOUT8 RST_B net2 DOUT7 COMP_OUT DOUT6 net3 net4 DOUT5 DOUT4 net5 DOUT3 net6 DOUT2 net7 net8 DOUT1 net9 DOUT0 net10 SAMPLE_INT BUSY sar_sequencer
xinv_clkcap CLK VGND VGND VPWR VPWR CLKN sky130_fd_sc_hd__inv_1
xinv_dout9n DOUT9 VGND VGND VPWR VPWR DOUT9N sky130_fd_sc_hd__inv_1
xand_seln0 DOUT0 DOUT9N VGND VGND VPWR VPWR SELn0 sky130_fd_sc_hd__and2_1
xand_selp0 DOUT9 DOUT0 VGND VGND VPWR VPWR SELp0 sky130_fd_sc_hd__and2_1
xand_seln1 DOUT1 DOUT9N VGND VGND VPWR VPWR SELn1 sky130_fd_sc_hd__and2_1
xand_selp1 DOUT9 DOUT1 VGND VGND VPWR VPWR SELp1 sky130_fd_sc_hd__and2_1
xand_seln2 DOUT2 DOUT9N VGND VGND VPWR VPWR SELn2 sky130_fd_sc_hd__and2_1
xand_selp2 DOUT9 DOUT2 VGND VGND VPWR VPWR SELp2 sky130_fd_sc_hd__and2_1
xand_seln3 DOUT3 DOUT9N VGND VGND VPWR VPWR SELn3 sky130_fd_sc_hd__and2_1
xand_selp3 DOUT9 DOUT3 VGND VGND VPWR VPWR SELp3 sky130_fd_sc_hd__and2_1
xand_seln4 DOUT4 DOUT9N VGND VGND VPWR VPWR SELn4 sky130_fd_sc_hd__and2_1
xand_selp4 DOUT9 DOUT4 VGND VGND VPWR VPWR SELp4 sky130_fd_sc_hd__and2_1
xand_seln5 DOUT5 DOUT9N VGND VGND VPWR VPWR SELn5 sky130_fd_sc_hd__and2_1
xand_selp5 DOUT9 DOUT5 VGND VGND VPWR VPWR SELp5 sky130_fd_sc_hd__and2_1
xand_seln6 DOUT6 DOUT9N VGND VGND VPWR VPWR SELn6 sky130_fd_sc_hd__and2_1
xand_selp6 DOUT9 DOUT6 VGND VGND VPWR VPWR SELp6 sky130_fd_sc_hd__and2_1
xand_seln7 DOUT7 DOUT9N VGND VGND VPWR VPWR SELn7 sky130_fd_sc_hd__and2_1
xand_selp7 DOUT9 DOUT7 VGND VGND VPWR VPWR SELp7 sky130_fd_sc_hd__and2_1
xand_seln8 DOUT8 DOUT9N VGND VGND VPWR VPWR SELn8 sky130_fd_sc_hd__and2_1
xand_selp8 DOUT9 DOUT8 VGND VGND VPWR VPWR SELp8 sky130_fd_sc_hd__and2_1
xxor_code0 DOUT0 DOUT9N VGND VGND VPWR VPWR ADCOUT0 sky130_fd_sc_hd__xor2_1
xxor_code1 DOUT1 DOUT9N VGND VGND VPWR VPWR ADCOUT1 sky130_fd_sc_hd__xor2_1
xxor_code2 DOUT2 DOUT9N VGND VGND VPWR VPWR ADCOUT2 sky130_fd_sc_hd__xor2_1
xxor_code3 DOUT3 DOUT9N VGND VGND VPWR VPWR ADCOUT3 sky130_fd_sc_hd__xor2_1
xxor_code4 DOUT4 DOUT9N VGND VGND VPWR VPWR ADCOUT4 sky130_fd_sc_hd__xor2_1
xxor_code5 DOUT5 DOUT9N VGND VGND VPWR VPWR ADCOUT5 sky130_fd_sc_hd__xor2_1
xxor_code6 DOUT6 DOUT9N VGND VGND VPWR VPWR ADCOUT6 sky130_fd_sc_hd__xor2_1
xxor_code7 DOUT7 DOUT9N VGND VGND VPWR VPWR ADCOUT7 sky130_fd_sc_hd__xor2_1
xxor_code8 DOUT8 DOUT9N VGND VGND VPWR VPWR ADCOUT8 sky130_fd_sc_hd__xor2_1
xdum_mux_n DOUT9 OUTN_NC PH_B9 VGND VGND VPWR VPWR DUMLOAD_MUX_NC sky130_fd_sc_hd__mux2_1
xdum_xnor_n OUTN_NC DOUT9 VGND VGND VPWR VPWR DUMLOAD_XNOR_NC sky130_fd_sc_hd__xnor2_1
xand_halflsb PH_B9 BUSY VGND VGND VPWR VPWR HALF_LSB_EN sky130_fd_sc_hd__and2b_1
xinv_halflsb HALF_LSB_EN VGND VGND VPWR VPWR HALF_LSB_ENN sky130_fd_sc_hd__inv_1
XChoff_n BOT_OFF_N TOP_N sky130_fd_pr__cap_mim_m3_1 W=1.9000 L=1.9000 MF=1 m=1
XMoff_n_refp BOT_OFF_N HALF_LSB_EN VREFP VDD sky130_fd_pr__pfet_01v8 L=0.15 W=2 nf=1 ad=0.58 as=0.58 pd=4.58 ps=4.58 nrd=0.145 nrs=0.145 sa=0 sb=0 sd=0 mult=1 m=1
XMoff_n_cmn BOT_OFF_N HALF_LSB_EN VCM GND sky130_fd_pr__nfet_01v8 L=0.15 W=1 nf=1 ad=0.29 as=0.29 pd=2.58 ps=2.58 nrd=0.29 nrs=0.29 sa=0 sb=0 sd=0 mult=1 m=1
XMoff_n_cmp BOT_OFF_N HALF_LSB_ENN VCM VDD sky130_fd_pr__pfet_01v8 L=0.15 W=2 nf=1 ad=0.58 as=0.58 pd=4.58 ps=4.58 nrd=0.145 nrs=0.145 sa=0 sb=0 sd=0 mult=1 m=1
XChoff_p BOT_OFF_P TOP_P sky130_fd_pr__cap_mim_m3_1 W=1.9000 L=1.9000 MF=1 m=1
XMoff_p_refp BOT_OFF_P VGND VREFP VDD sky130_fd_pr__pfet_01v8 L=0.15 W=2 nf=1 ad=0.58 as=0.58 pd=4.58 ps=4.58 nrd=0.145 nrs=0.145 sa=0 sb=0 sd=0 mult=1 m=1
XMoff_p_cmn BOT_OFF_P VGND VCM GND sky130_fd_pr__nfet_01v8 L=0.15 W=1 nf=1 ad=0.29 as=0.29 pd=2.58 ps=2.58 nrd=0.29 nrs=0.29 sa=0 sb=0 sd=0 mult=1 m=1
XMoff_p_cmp BOT_OFF_P VPWR VCM VDD sky130_fd_pr__pfet_01v8 L=0.15 W=2 nf=1 ad=0.58 as=0.58 pd=4.58 ps=4.58 nrd=0.145 nrs=0.145 sa=0 sb=0 sd=0 mult=1 m=1
XCdecap_a GND VDD sky130_fd_pr__cap_mim_m3_1 W=46.9 L=46.9 MF=2 m=2
XCdecap_d VGND VPWR sky130_fd_pr__cap_mim_m3_1 W=46.9 L=46.9 MF=2 m=2
**.ends
* expanding   symbol:  design/sampling_frontend.sym # of pins=9
** sym_path: design/sampling_frontend.sym
** sch_path: design/sampling_frontend.sch
.subckt sampling_frontend VINP VINN SAMPLE VCM VDD TOP_P TOP_N BPREF_P BPREF_N
*.ipin VINP
*.ipin VINN
*.ipin SAMPLE
*.ipin VCM
*.ipin VDD
*.opin TOP_P
*.opin TOP_N
*.opin BPREF_P
*.opin BPREF_N
XMsw_p VINP G_P TOP_P GND sky130_fd_pr__nfet_01v8 L=0.15 W=2 nf=1 ad=0.58 as=0.58 pd=4.58 ps=4.58 nrd=0.145 nrs=0.145 sa=0 sb=0 sd=0 mult=1 m=1
XSa_p BOOST_P G_P VDD BOOST_P sky130_fd_pr__pfet_01v8 L=0.5 W=1 nf=1 ad=0.29 as=0.29 pd=2.58 ps=2.58 nrd=0.29 nrs=0.29 sa=0 sb=0 sd=0 mult=1 m=1
XSb_p BSBOT_P SAMPLEB GND GND sky130_fd_pr__nfet_01v8 L=0.15 W=1 nf=1 ad=0.29 as=0.29 pd=2.58 ps=2.58 nrd=0.29 nrs=0.29 sa=0 sb=0 sd=0 mult=1 m=1
XScn_p BSBOT_P SAMPLE VINP GND sky130_fd_pr__nfet_01v8 L=0.15 W=1 nf=1 ad=0.29 as=0.29 pd=2.58 ps=2.58 nrd=0.29 nrs=0.29 sa=0 sb=0 sd=0 mult=1 m=1
XScp_p BSBOT_P SAMPLEB VINP VDD sky130_fd_pr__pfet_01v8 L=0.15 W=1 nf=1 ad=0.29 as=0.29 pd=2.58 ps=2.58 nrd=0.29 nrs=0.29 sa=0 sb=0 sd=0 mult=1 m=1
XSd_p G_P SAMPLEB GND GND sky130_fd_pr__nfet_01v8 L=0.5 W=1 nf=1 ad=0.29 as=0.29 pd=2.58 ps=2.58 nrd=0.29 nrs=0.29 sa=0 sb=0 sd=0 mult=1 m=1
XSe_p G_P SAMPLEB BOOST_P BOOST_P sky130_fd_pr__pfet_01v8 L=0.15 W=1 nf=1 ad=0.29 as=0.29 pd=2.58 ps=2.58 nrd=0.29 nrs=0.29 sa=0 sb=0 sd=0 mult=1 m=1
XCmswn_p BPREF_P SAMPLE VCM GND sky130_fd_pr__nfet_01v8 L=0.15 W=16 nf=1 ad=4.64 as=4.64 pd=32.58 ps=32.58 nrd=0.018125 nrs=0.018125 sa=0 sb=0 sd=0 mult=1 m=1
XCmswp_p BPREF_P SAMPLEB VCM VDD sky130_fd_pr__pfet_01v8 L=0.15 W=16 nf=1 ad=4.64 as=4.64 pd=32.58 ps=32.58 nrd=0.018125 nrs=0.018125 sa=0 sb=0 sd=0 mult=1 m=1
XCboot_p BOOST_P BSBOT_P sky130_fd_pr__cap_mim_m3_1 W=9.8 L=9.8 MF=1 m=1
XCsamp_p TOP_P BPREF_P sky130_fd_pr__cap_mim_m3_1 W=46.9 L=46.9 MF=1 m=1
XMsw_n VINN G_N TOP_N GND sky130_fd_pr__nfet_01v8 L=0.15 W=2 nf=1 ad=0.58 as=0.58 pd=4.58 ps=4.58 nrd=0.145 nrs=0.145 sa=0 sb=0 sd=0 mult=1 m=1
XSa_n BOOST_N G_N VDD BOOST_N sky130_fd_pr__pfet_01v8 L=0.5 W=1 nf=1 ad=0.29 as=0.29 pd=2.58 ps=2.58 nrd=0.29 nrs=0.29 sa=0 sb=0 sd=0 mult=1 m=1
XSb_n BSBOT_N SAMPLEB GND GND sky130_fd_pr__nfet_01v8 L=0.15 W=1 nf=1 ad=0.29 as=0.29 pd=2.58 ps=2.58 nrd=0.29 nrs=0.29 sa=0 sb=0 sd=0 mult=1 m=1
XScn_n BSBOT_N SAMPLE VINN GND sky130_fd_pr__nfet_01v8 L=0.15 W=1 nf=1 ad=0.29 as=0.29 pd=2.58 ps=2.58 nrd=0.29 nrs=0.29 sa=0 sb=0 sd=0 mult=1 m=1
XScp_n BSBOT_N SAMPLEB VINN VDD sky130_fd_pr__pfet_01v8 L=0.15 W=1 nf=1 ad=0.29 as=0.29 pd=2.58 ps=2.58 nrd=0.29 nrs=0.29 sa=0 sb=0 sd=0 mult=1 m=1
XSd_n G_N SAMPLEB GND GND sky130_fd_pr__nfet_01v8 L=0.5 W=1 nf=1 ad=0.29 as=0.29 pd=2.58 ps=2.58 nrd=0.29 nrs=0.29 sa=0 sb=0 sd=0 mult=1 m=1
XSe_n G_N SAMPLEB BOOST_N BOOST_N sky130_fd_pr__pfet_01v8 L=0.15 W=1 nf=1 ad=0.29 as=0.29 pd=2.58 ps=2.58 nrd=0.29 nrs=0.29 sa=0 sb=0 sd=0 mult=1 m=1
XCmswn_n BPREF_N SAMPLE VCM GND sky130_fd_pr__nfet_01v8 L=0.15 W=16 nf=1 ad=4.64 as=4.64 pd=32.58 ps=32.58 nrd=0.018125 nrs=0.018125 sa=0 sb=0 sd=0 mult=1 m=1
XCmswp_n BPREF_N SAMPLEB VCM VDD sky130_fd_pr__pfet_01v8 L=0.15 W=16 nf=1 ad=4.64 as=4.64 pd=32.58 ps=32.58 nrd=0.018125 nrs=0.018125 sa=0 sb=0 sd=0 mult=1 m=1
XCboot_n BOOST_N BSBOT_N sky130_fd_pr__cap_mim_m3_1 W=9.8 L=9.8 MF=1 m=1
XCsamp_n TOP_N BPREF_N sky130_fd_pr__cap_mim_m3_1 W=46.9 L=46.9 MF=1 m=1
XInvp SAMPLEB SAMPLE VDD VDD sky130_fd_pr__pfet_01v8 L=0.15 W=2 nf=1 ad=0.58 as=0.58 pd=4.58 ps=4.58 nrd=0.145 nrs=0.145 sa=0 sb=0 sd=0 mult=1 m=1
XInvn SAMPLEB SAMPLE GND GND sky130_fd_pr__nfet_01v8 L=0.15 W=1 nf=1 ad=0.29 as=0.29 pd=2.58 ps=2.58 nrd=0.29 nrs=0.29 sa=0 sb=0 sd=0 mult=1 m=1
.ends
* expanding   symbol:  design/cdac/cdac_array.sym # of pins=24
** sym_path: design/cdac/cdac_array.sym
** sch_path: design/cdac/cdac_array.sch
.subckt cdac_array VREFP VREFN VDD VSS SELn0 SELp0 SELn1 SELp1 SELn2 SELp2 SELn3 SELp3 SELn4 SELp4 TOP_N TOP_P SELp5 SELn5 SELp6 SELn6 SELn7 SELp7 SELn8 SELp8
*.ipin SELp0
*.ipin SELp1
*.ipin SELp2
*.ipin SELp3
*.ipin SELp4
*.ipin SELp5
*.ipin SELp6
*.ipin SELp7
*.ipin SELp8
*.opin TOP_P
*.ipin SELn0
*.ipin SELn1
*.ipin SELn2
*.ipin SELn3
*.ipin SELn4
*.ipin SELn5
*.ipin SELn6
*.ipin SELn7
*.ipin SELn8
*.opin TOP_N
*.ipin VREFP
*.ipin VREFN
*.ipin VDD
*.ipin VSS
XCp0 BOT_p0 TOP_P sky130_fd_pr__cap_mim_m3_1 W=1.9000 L=1.9000 MF=1 m=1
XMp0n BOT_p0 SELp0 VREFN VSS sky130_fd_pr__nfet_01v8 L=0.15 W=1 nf=1 ad=0.29 as=0.29 pd=2.58 ps=2.58 nrd=0.29 nrs=0.29 sa=0 sb=0 sd=0 mult=1 m=1
XMp0p BOT_p0 SELp0 VREFP VDD sky130_fd_pr__pfet_01v8 L=0.15 W=2 nf=1 ad=0.58 as=0.58 pd=4.58 ps=4.58 nrd=0.145 nrs=0.145 sa=0 sb=0 sd=0 mult=1 m=1
XCp1 BOT_p1 TOP_P sky130_fd_pr__cap_mim_m3_1 W=1.9000 L=1.9000 MF=2 m=2
XMp1n BOT_p1 SELp1 VREFN VSS sky130_fd_pr__nfet_01v8 L=0.15 W=1 nf=1 ad=0.29 as=0.29 pd=2.58 ps=2.58 nrd=0.29 nrs=0.29 sa=0 sb=0 sd=0 mult=1 m=1
XMp1p BOT_p1 SELp1 VREFP VDD sky130_fd_pr__pfet_01v8 L=0.15 W=2 nf=1 ad=0.58 as=0.58 pd=4.58 ps=4.58 nrd=0.145 nrs=0.145 sa=0 sb=0 sd=0 mult=1 m=1
XCp2 BOT_p2 TOP_P sky130_fd_pr__cap_mim_m3_1 W=1.9000 L=1.9000 MF=4 m=4
XMp2n BOT_p2 SELp2 VREFN VSS sky130_fd_pr__nfet_01v8 L=0.15 W=1 nf=1 ad=0.29 as=0.29 pd=2.58 ps=2.58 nrd=0.29 nrs=0.29 sa=0 sb=0 sd=0 mult=1 m=1
XMp2p BOT_p2 SELp2 VREFP VDD sky130_fd_pr__pfet_01v8 L=0.15 W=2 nf=1 ad=0.58 as=0.58 pd=4.58 ps=4.58 nrd=0.145 nrs=0.145 sa=0 sb=0 sd=0 mult=1 m=1
XCp3 BOT_p3 TOP_P sky130_fd_pr__cap_mim_m3_1 W=1.9000 L=1.9000 MF=8 m=8
XMp3n BOT_p3 SELp3 VREFN VSS sky130_fd_pr__nfet_01v8 L=0.15 W=1 nf=1 ad=0.29 as=0.29 pd=2.58 ps=2.58 nrd=0.29 nrs=0.29 sa=0 sb=0 sd=0 mult=1 m=1
XMp3p BOT_p3 SELp3 VREFP VDD sky130_fd_pr__pfet_01v8 L=0.15 W=2 nf=1 ad=0.58 as=0.58 pd=4.58 ps=4.58 nrd=0.145 nrs=0.145 sa=0 sb=0 sd=0 mult=1 m=1
XCp4 BOT_p4 TOP_P sky130_fd_pr__cap_mim_m3_1 W=1.9000 L=1.9000 MF=16 m=16
XMp4n BOT_p4 SELp4 VREFN VSS sky130_fd_pr__nfet_01v8 L=0.15 W=1 nf=1 ad=0.29 as=0.29 pd=2.58 ps=2.58 nrd=0.29 nrs=0.29 sa=0 sb=0 sd=0 mult=1 m=1
XMp4p BOT_p4 SELp4 VREFP VDD sky130_fd_pr__pfet_01v8 L=0.15 W=2 nf=1 ad=0.58 as=0.58 pd=4.58 ps=4.58 nrd=0.145 nrs=0.145 sa=0 sb=0 sd=0 mult=1 m=1
XCp5 BOT_p5 TOP_P sky130_fd_pr__cap_mim_m3_1 W=1.9000 L=1.9000 MF=32 m=32
XMp5n BOT_p5 SELp5 VREFN VSS sky130_fd_pr__nfet_01v8 L=0.15 W=1 nf=1 ad=0.29 as=0.29 pd=2.58 ps=2.58 nrd=0.29 nrs=0.29 sa=0 sb=0 sd=0 mult=1 m=1
XMp5p BOT_p5 SELp5 VREFP VDD sky130_fd_pr__pfet_01v8 L=0.15 W=2 nf=1 ad=0.58 as=0.58 pd=4.58 ps=4.58 nrd=0.145 nrs=0.145 sa=0 sb=0 sd=0 mult=1 m=1
XCp6 BOT_p6 TOP_P sky130_fd_pr__cap_mim_m3_1 W=1.9000 L=1.9000 MF=64 m=64
XMp6n BOT_p6 SELp6 VREFN VSS sky130_fd_pr__nfet_01v8 L=0.15 W=1 nf=1 ad=0.29 as=0.29 pd=2.58 ps=2.58 nrd=0.29 nrs=0.29 sa=0 sb=0 sd=0 mult=1 m=1
XMp6p BOT_p6 SELp6 VREFP VDD sky130_fd_pr__pfet_01v8 L=0.15 W=2 nf=1 ad=0.58 as=0.58 pd=4.58 ps=4.58 nrd=0.145 nrs=0.145 sa=0 sb=0 sd=0 mult=1 m=1
XCp7 BOT_p7 TOP_P sky130_fd_pr__cap_mim_m3_1 W=1.9000 L=1.9000 MF=128 m=128
XMp7n BOT_p7 SELp7 VREFN VSS sky130_fd_pr__nfet_01v8 L=0.15 W=1 nf=1 ad=0.29 as=0.29 pd=2.58 ps=2.58 nrd=0.29 nrs=0.29 sa=0 sb=0 sd=0 mult=1 m=1
XMp7p BOT_p7 SELp7 VREFP VDD sky130_fd_pr__pfet_01v8 L=0.15 W=2 nf=1 ad=0.58 as=0.58 pd=4.58 ps=4.58 nrd=0.145 nrs=0.145 sa=0 sb=0 sd=0 mult=1 m=1
XCp8 BOT_p8 TOP_P sky130_fd_pr__cap_mim_m3_1 W=1.9000 L=1.9000 MF=256 m=256
XMp8n BOT_p8 SELp8 VREFN VSS sky130_fd_pr__nfet_01v8 L=0.15 W=1 nf=1 ad=0.29 as=0.29 pd=2.58 ps=2.58 nrd=0.29 nrs=0.29 sa=0 sb=0 sd=0 mult=1 m=1
XMp8p BOT_p8 SELp8 VREFP VDD sky130_fd_pr__pfet_01v8 L=0.15 W=2 nf=1 ad=0.58 as=0.58 pd=4.58 ps=4.58 nrd=0.145 nrs=0.145 sa=0 sb=0 sd=0 mult=1 m=1
XCp_term VREFN TOP_P sky130_fd_pr__cap_mim_m3_1 W=1.9000 L=1.9000 MF=1 m=1
XCn0 BOT_n0 TOP_N sky130_fd_pr__cap_mim_m3_1 W=1.9000 L=1.9000 MF=1 m=1
XMn0n BOT_n0 SELn0 VREFN VSS sky130_fd_pr__nfet_01v8 L=0.15 W=1 nf=1 ad=0.29 as=0.29 pd=2.58 ps=2.58 nrd=0.29 nrs=0.29 sa=0 sb=0 sd=0 mult=1 m=1
XMn0p BOT_n0 SELn0 VREFP VDD sky130_fd_pr__pfet_01v8 L=0.15 W=2 nf=1 ad=0.58 as=0.58 pd=4.58 ps=4.58 nrd=0.145 nrs=0.145 sa=0 sb=0 sd=0 mult=1 m=1
XCn1 BOT_n1 TOP_N sky130_fd_pr__cap_mim_m3_1 W=1.9000 L=1.9000 MF=2 m=2
XMn1n BOT_n1 SELn1 VREFN VSS sky130_fd_pr__nfet_01v8 L=0.15 W=1 nf=1 ad=0.29 as=0.29 pd=2.58 ps=2.58 nrd=0.29 nrs=0.29 sa=0 sb=0 sd=0 mult=1 m=1
XMn1p BOT_n1 SELn1 VREFP VDD sky130_fd_pr__pfet_01v8 L=0.15 W=2 nf=1 ad=0.58 as=0.58 pd=4.58 ps=4.58 nrd=0.145 nrs=0.145 sa=0 sb=0 sd=0 mult=1 m=1
XCn2 BOT_n2 TOP_N sky130_fd_pr__cap_mim_m3_1 W=1.9000 L=1.9000 MF=4 m=4
XMn2n BOT_n2 SELn2 VREFN VSS sky130_fd_pr__nfet_01v8 L=0.15 W=1 nf=1 ad=0.29 as=0.29 pd=2.58 ps=2.58 nrd=0.29 nrs=0.29 sa=0 sb=0 sd=0 mult=1 m=1
XMn2p BOT_n2 SELn2 VREFP VDD sky130_fd_pr__pfet_01v8 L=0.15 W=2 nf=1 ad=0.58 as=0.58 pd=4.58 ps=4.58 nrd=0.145 nrs=0.145 sa=0 sb=0 sd=0 mult=1 m=1
XCn3 BOT_n3 TOP_N sky130_fd_pr__cap_mim_m3_1 W=1.9000 L=1.9000 MF=8 m=8
XMn3n BOT_n3 SELn3 VREFN VSS sky130_fd_pr__nfet_01v8 L=0.15 W=1 nf=1 ad=0.29 as=0.29 pd=2.58 ps=2.58 nrd=0.29 nrs=0.29 sa=0 sb=0 sd=0 mult=1 m=1
XMn3p BOT_n3 SELn3 VREFP VDD sky130_fd_pr__pfet_01v8 L=0.15 W=2 nf=1 ad=0.58 as=0.58 pd=4.58 ps=4.58 nrd=0.145 nrs=0.145 sa=0 sb=0 sd=0 mult=1 m=1
XCn4 BOT_n4 TOP_N sky130_fd_pr__cap_mim_m3_1 W=1.9000 L=1.9000 MF=16 m=16
XMn4n BOT_n4 SELn4 VREFN VSS sky130_fd_pr__nfet_01v8 L=0.15 W=1 nf=1 ad=0.29 as=0.29 pd=2.58 ps=2.58 nrd=0.29 nrs=0.29 sa=0 sb=0 sd=0 mult=1 m=1
XMn4p BOT_n4 SELn4 VREFP VDD sky130_fd_pr__pfet_01v8 L=0.15 W=2 nf=1 ad=0.58 as=0.58 pd=4.58 ps=4.58 nrd=0.145 nrs=0.145 sa=0 sb=0 sd=0 mult=1 m=1
XCn5 BOT_n5 TOP_N sky130_fd_pr__cap_mim_m3_1 W=1.9000 L=1.9000 MF=32 m=32
XMn5n BOT_n5 SELn5 VREFN VSS sky130_fd_pr__nfet_01v8 L=0.15 W=1 nf=1 ad=0.29 as=0.29 pd=2.58 ps=2.58 nrd=0.29 nrs=0.29 sa=0 sb=0 sd=0 mult=1 m=1
XMn5p BOT_n5 SELn5 VREFP VDD sky130_fd_pr__pfet_01v8 L=0.15 W=2 nf=1 ad=0.58 as=0.58 pd=4.58 ps=4.58 nrd=0.145 nrs=0.145 sa=0 sb=0 sd=0 mult=1 m=1
XCn6 BOT_n6 TOP_N sky130_fd_pr__cap_mim_m3_1 W=1.9000 L=1.9000 MF=64 m=64
XMn6n BOT_n6 SELn6 VREFN VSS sky130_fd_pr__nfet_01v8 L=0.15 W=1 nf=1 ad=0.29 as=0.29 pd=2.58 ps=2.58 nrd=0.29 nrs=0.29 sa=0 sb=0 sd=0 mult=1 m=1
XMn6p BOT_n6 SELn6 VREFP VDD sky130_fd_pr__pfet_01v8 L=0.15 W=2 nf=1 ad=0.58 as=0.58 pd=4.58 ps=4.58 nrd=0.145 nrs=0.145 sa=0 sb=0 sd=0 mult=1 m=1
XCn7 BOT_n7 TOP_N sky130_fd_pr__cap_mim_m3_1 W=1.9000 L=1.9000 MF=128 m=128
XMn7n BOT_n7 SELn7 VREFN VSS sky130_fd_pr__nfet_01v8 L=0.15 W=1 nf=1 ad=0.29 as=0.29 pd=2.58 ps=2.58 nrd=0.29 nrs=0.29 sa=0 sb=0 sd=0 mult=1 m=1
XMn7p BOT_n7 SELn7 VREFP VDD sky130_fd_pr__pfet_01v8 L=0.15 W=2 nf=1 ad=0.58 as=0.58 pd=4.58 ps=4.58 nrd=0.145 nrs=0.145 sa=0 sb=0 sd=0 mult=1 m=1
XCn8 BOT_n8 TOP_N sky130_fd_pr__cap_mim_m3_1 W=1.9000 L=1.9000 MF=256 m=256
XMn8n BOT_n8 SELn8 VREFN VSS sky130_fd_pr__nfet_01v8 L=0.15 W=1 nf=1 ad=0.29 as=0.29 pd=2.58 ps=2.58 nrd=0.29 nrs=0.29 sa=0 sb=0 sd=0 mult=1 m=1
XMn8p BOT_n8 SELn8 VREFP VDD sky130_fd_pr__pfet_01v8 L=0.15 W=2 nf=1 ad=0.58 as=0.58 pd=4.58 ps=4.58 nrd=0.145 nrs=0.145 sa=0 sb=0 sd=0 mult=1 m=1
XCn_term VREFN TOP_N sky130_fd_pr__cap_mim_m3_1 W=1.9000 L=1.9000 MF=1 m=1
.ends
* expanding   symbol:  design/comparator.sym # of pins=6
** sym_path: design/comparator.sym
** sch_path: design/comparator.sch
.subckt comparator VDD CLK VINP VINN OUTP OUTN
*.ipin VDD
*.ipin CLK
*.ipin VINP
*.ipin VINN
*.opin OUTP
*.opin OUTN
XM_TAIL TAIL CLK GND GND sky130_fd_pr__nfet_01v8 L=0.5 W=8 nf=1 ad=2.32 as=2.32 pd=16.58 ps=16.58 nrd=0.03625 nrs=0.03625 sa=0 sb=0 sd=0 mult=1 m=1
XM_INN DIP VINN TAIL GND sky130_fd_pr__nfet_01v8 L=0.5 W=4 nf=1 ad=1.16 as=1.16 pd=8.58 ps=8.58 nrd=0.0725 nrs=0.0725 sa=0 sb=0 sd=0 mult=1 m=1
XM_INP DIN VINP TAIL GND sky130_fd_pr__nfet_01v8 L=0.5 W=4 nf=1 ad=1.16 as=1.16 pd=8.58 ps=8.58 nrd=0.0725 nrs=0.0725 sa=0 sb=0 sd=0 mult=1 m=1
XM_LATN_P OUTP OUTN DIP GND sky130_fd_pr__nfet_01v8 L=0.5 W=4 nf=1 ad=1.16 as=1.16 pd=8.58 ps=8.58 nrd=0.0725 nrs=0.0725 sa=0 sb=0 sd=0 mult=1 m=1
XM_LATN_N OUTN OUTP DIN GND sky130_fd_pr__nfet_01v8 L=0.5 W=4 nf=1 ad=1.16 as=1.16 pd=8.58 ps=8.58 nrd=0.0725 nrs=0.0725 sa=0 sb=0 sd=0 mult=1 m=1
XM_LATP_P OUTP OUTN VDD VDD sky130_fd_pr__pfet_01v8 L=0.5 W=8 nf=1 ad=2.32 as=2.32 pd=16.58 ps=16.58 nrd=0.03625 nrs=0.03625 sa=0 sb=0 sd=0 mult=1 m=1
XM_LATP_N OUTN OUTP VDD VDD sky130_fd_pr__pfet_01v8 L=0.5 W=8 nf=1 ad=2.32 as=2.32 pd=16.58 ps=16.58 nrd=0.03625 nrs=0.03625 sa=0 sb=0 sd=0 mult=1 m=1
XM_RST_P OUTP CLK VDD VDD sky130_fd_pr__pfet_01v8 L=0.5 W=16 nf=1 ad=4.64 as=4.64 pd=32.58 ps=32.58 nrd=0.018125 nrs=0.018125 sa=0 sb=0 sd=0 mult=1 m=1
XM_RST_N OUTN CLK VDD VDD sky130_fd_pr__pfet_01v8 L=0.5 W=16 nf=1 ad=4.64 as=4.64 pd=32.58 ps=32.58 nrd=0.018125 nrs=0.018125 sa=0 sb=0 sd=0 mult=1 m=1
XM_RST_DIP DIP CLK VDD VDD sky130_fd_pr__pfet_01v8 L=0.5 W=4 nf=1 ad=1.16 as=1.16 pd=8.58 ps=8.58 nrd=0.0725 nrs=0.0725 sa=0 sb=0 sd=0 mult=1 m=1
XM_RST_DIN DIN CLK VDD VDD sky130_fd_pr__pfet_01v8 L=0.5 W=4 nf=1 ad=1.16 as=1.16 pd=8.58 ps=8.58 nrd=0.0725 nrs=0.0725 sa=0 sb=0 sd=0 mult=1 m=1
.ends
* expanding   symbol:  design/sar_sequencer.sym # of pins=26
** sym_path: design/sar_sequencer.sym
** sch_path: design/sar_sequencer.sch
.subckt sar_sequencer DOUT9 PH_B9 CLK PH_B8 DOUT8 RST_B PH_B7 DOUT7 COMP_OUT DOUT6 PH_B6 PH_B5 DOUT5 DOUT4 PH_B4 DOUT3 PH_B3 DOUT2 PH_B2 PH_B1 DOUT1 PH_B0 DOUT0 PH_EOC PH_SAMPLE BUSY
*.ipin CLK
*.ipin RST_B
*.ipin COMP_OUT
*.opin PH_B9
*.opin PH_B8
*.opin PH_B7
*.opin PH_B6
*.opin PH_B5
*.opin PH_B4
*.opin PH_B3
*.opin PH_B2
*.opin PH_B1
*.opin PH_B0
*.opin PH_EOC
*.opin PH_SAMPLE
*.opin BUSY
*.opin DOUT9
*.opin DOUT8
*.opin DOUT7
*.opin DOUT6
*.opin DOUT5
*.opin DOUT4
*.opin DOUT3
*.opin DOUT2
*.opin DOUT1
*.opin DOUT0
xringb9 CLK PH_SAMPLE RST_B VGND VGND VPWR VPWR PH_B9 sky130_fd_sc_hd__dfrtp_1
xringb8 CLK PH_B9 RST_B VGND VGND VPWR VPWR PH_B8 sky130_fd_sc_hd__dfrtp_1
xringb7 CLK PH_B8 RST_B VGND VGND VPWR VPWR PH_B7 sky130_fd_sc_hd__dfrtp_1
xringb6 CLK PH_B7 RST_B VGND VGND VPWR VPWR PH_B6 sky130_fd_sc_hd__dfrtp_1
xringb5 CLK PH_B6 RST_B VGND VGND VPWR VPWR PH_B5 sky130_fd_sc_hd__dfrtp_1
xringb4 CLK PH_B5 RST_B VGND VGND VPWR VPWR PH_B4 sky130_fd_sc_hd__dfrtp_1
xringb3 CLK PH_B4 RST_B VGND VGND VPWR VPWR PH_B3 sky130_fd_sc_hd__dfrtp_1
xringb2 CLK PH_B3 RST_B VGND VGND VPWR VPWR PH_B2 sky130_fd_sc_hd__dfrtp_1
xringb1 CLK PH_B2 RST_B VGND VGND VPWR VPWR PH_B1 sky130_fd_sc_hd__dfrtp_1
xringb0 CLK PH_B1 RST_B VGND VGND VPWR VPWR PH_B0 sky130_fd_sc_hd__dfrtp_1
xringeoc CLK PH_B0 RST_B VGND VGND VPWR VPWR PH_EOC sky130_fd_sc_hd__dfrtp_1
xor_g1 PH_B9 PH_B8 PH_B7 PH_B6 VGND VGND VPWR VPWR ORG1 sky130_fd_sc_hd__or4_1
xor_g2 PH_B5 PH_B4 PH_B3 PH_B2 VGND VGND VPWR VPWR ORG2 sky130_fd_sc_hd__or4_1
xor_g3 PH_B1 PH_B0 PH_EOC VGND VGND VPWR VPWR ORG3 sky130_fd_sc_hd__or3_1
xor_busy ORG1 ORG2 ORG3 VGND VGND VPWR VPWR BUSY sky130_fd_sc_hd__or3_1
xinv_sample BUSY VGND VGND VPWR VPWR PH_SAMPLE sky130_fd_sc_hd__inv_1
xor_g4 PH_B1 PH_B0 VGND VGND VPWR VPWR ORG4 sky130_fd_sc_hd__or2_1
xor_busybits ORG1 ORG2 ORG4 VGND VGND VPWR VPWR BUSY_BITS sky130_fd_sc_hd__or3_1
xmux9 DOUT9 COMP_OUT PH_B9 VGND VGND VPWR VPWR MUXOUT9 sky130_fd_sc_hd__mux2_1
xbreg9 CLK MUXOUT9 RST_B VGND VGND VPWR VPWR DOUT9 sky130_fd_sc_hd__dfrtp_1
xmux8 DOUT8 COMP_EFF PH_B8 VGND VGND VPWR VPWR MUXOUT8 sky130_fd_sc_hd__mux2_1
xbreg8 CLK DFEED8 RST_B VGND VGND VPWR VPWR DOUT8 sky130_fd_sc_hd__dfrtp_1
xmux7 DOUT7 COMP_EFF PH_B7 VGND VGND VPWR VPWR MUXOUT7 sky130_fd_sc_hd__mux2_1
xbreg7 CLK DFEED7 RST_B VGND VGND VPWR VPWR DOUT7 sky130_fd_sc_hd__dfrtp_1
xmux6 DOUT6 COMP_EFF PH_B6 VGND VGND VPWR VPWR MUXOUT6 sky130_fd_sc_hd__mux2_1
xbreg6 CLK DFEED6 RST_B VGND VGND VPWR VPWR DOUT6 sky130_fd_sc_hd__dfrtp_1
xmux5 DOUT5 COMP_EFF PH_B5 VGND VGND VPWR VPWR MUXOUT5 sky130_fd_sc_hd__mux2_1
xbreg5 CLK DFEED5 RST_B VGND VGND VPWR VPWR DOUT5 sky130_fd_sc_hd__dfrtp_1
xmux4 DOUT4 COMP_EFF PH_B4 VGND VGND VPWR VPWR MUXOUT4 sky130_fd_sc_hd__mux2_1
xbreg4 CLK DFEED4 RST_B VGND VGND VPWR VPWR DOUT4 sky130_fd_sc_hd__dfrtp_1
xmux3 DOUT3 COMP_EFF PH_B3 VGND VGND VPWR VPWR MUXOUT3 sky130_fd_sc_hd__mux2_1
xbreg3 CLK DFEED3 RST_B VGND VGND VPWR VPWR DOUT3 sky130_fd_sc_hd__dfrtp_1
xmux2 DOUT2 COMP_EFF PH_B2 VGND VGND VPWR VPWR MUXOUT2 sky130_fd_sc_hd__mux2_1
xbreg2 CLK DFEED2 RST_B VGND VGND VPWR VPWR DOUT2 sky130_fd_sc_hd__dfrtp_1
xmux1 DOUT1 COMP_EFF PH_B1 VGND VGND VPWR VPWR MUXOUT1 sky130_fd_sc_hd__mux2_1
xbreg1 CLK DFEED1 RST_B VGND VGND VPWR VPWR DOUT1 sky130_fd_sc_hd__dfrtp_1
xmux0 DOUT0 COMP_EFF PH_B0 VGND VGND VPWR VPWR MUXOUT0 sky130_fd_sc_hd__mux2_1
xbreg0 CLK DFEED0 RST_B VGND VGND VPWR VPWR DOUT0 sky130_fd_sc_hd__dfrtp_1
xxnor_compeff COMP_OUT DOUT9 VGND VGND VPWR VPWR COMP_EFF sky130_fd_sc_hd__xnor2_1
xpre8 MUXOUT8 PH_B9 VGND VGND VPWR VPWR PRESET8 sky130_fd_sc_hd__or2_1
xclr8 PRESET8 BUSY_BITS VGND VGND VPWR VPWR DFEED8 sky130_fd_sc_hd__and2_1
xpre7 MUXOUT7 PH_B8 VGND VGND VPWR VPWR PRESET7 sky130_fd_sc_hd__or2_1
xclr7 PRESET7 BUSY_BITS VGND VGND VPWR VPWR DFEED7 sky130_fd_sc_hd__and2_1
xpre6 MUXOUT6 PH_B7 VGND VGND VPWR VPWR PRESET6 sky130_fd_sc_hd__or2_1
xclr6 PRESET6 BUSY_BITS VGND VGND VPWR VPWR DFEED6 sky130_fd_sc_hd__and2_1
xpre5 MUXOUT5 PH_B6 VGND VGND VPWR VPWR PRESET5 sky130_fd_sc_hd__or2_1
xclr5 PRESET5 BUSY_BITS VGND VGND VPWR VPWR DFEED5 sky130_fd_sc_hd__and2_1
xpre4 MUXOUT4 PH_B5 VGND VGND VPWR VPWR PRESET4 sky130_fd_sc_hd__or2_1
xclr4 PRESET4 BUSY_BITS VGND VGND VPWR VPWR DFEED4 sky130_fd_sc_hd__and2_1
xpre3 MUXOUT3 PH_B4 VGND VGND VPWR VPWR PRESET3 sky130_fd_sc_hd__or2_1
xclr3 PRESET3 BUSY_BITS VGND VGND VPWR VPWR DFEED3 sky130_fd_sc_hd__and2_1
xpre2 MUXOUT2 PH_B3 VGND VGND VPWR VPWR PRESET2 sky130_fd_sc_hd__or2_1
xclr2 PRESET2 BUSY_BITS VGND VGND VPWR VPWR DFEED2 sky130_fd_sc_hd__and2_1
xpre1 MUXOUT1 PH_B2 VGND VGND VPWR VPWR PRESET1 sky130_fd_sc_hd__or2_1
xclr1 PRESET1 BUSY_BITS VGND VGND VPWR VPWR DFEED1 sky130_fd_sc_hd__and2_1
xpre0 MUXOUT0 PH_B1 VGND VGND VPWR VPWR PRESET0 sky130_fd_sc_hd__or2_1
xclr0 PRESET0 BUSY_BITS VGND VGND VPWR VPWR DFEED0 sky130_fd_sc_hd__and2_1
.ends
.GLOBAL GND
.GLOBAL VDD
.GLOBAL VPWR
.GLOBAL VGND

* input_sweep_tb_fragment.spice -- converging-range boundary-sweep
* testbench for design/sar_adc_top.spice (issue #913, the DR-021
* open item).
*
* GENERATED by sim/full-conversion-transient/gen_full_conversion_tb.py -- do not
* edit by hand; sim/tests/test_full_conversion.py pins this file
* byte-for-byte against a fresh generation.
*
* Same assembly contract as full_conversion_tb_fragment.spice, with
* one difference: the differential input is the top-level parameter
* `vin_frac` (a fraction of V_REF = vdd_val), not a per-conversion
* literal. The assembling body declares the .param and the `klt sim`
* request sweeps it as the corners.params 'vin_frac' axis -- one unit
* per level (the same convention reference-drive-budget's r_ref
* uses). Each unit holds ONE DC level from t = 0, so this schedule
* has no input steps at all.
*
* 2 conversions of 12 CLK periods:
* conversion 0 is a start-up conversion and is discarded (its phase
* structure is still probed); conversion 1 carries the swept level
* and is the one measured.

* --- supplies and references -----------------------------------------
VVDD VDD 0 DC {vdd_val}
VVPWR VPWR 0 DC {vdd_val}
VVGND VGND 0 DC 0
VVREFP VREFP 0 DC {vdd_val}
VVREFN VREFN 0 DC 0
VVCM VCM 0 DC {vdd_val*0.5}

* --- clock and reset --------------------------------------------------
VCLK CLK 0 PULSE(0 {vdd_val} 199.5000n 1n 1n 40.66667n 83.33333n)
VRSTB RST_B 0 PWL(0 0 20.0000n 0 21.0000n {vdd_val} 2283.3333n {vdd_val})

* --- swept DC differential input (Vd = {vin_frac}*V_REF about VCM) ------
* Vd is split symmetrically about VCM = vdd_val/2, exactly as the DC
* fragment splits its per-conversion literals.
VINP VINP 0 DC {vdd_val*(0.5+vin_frac/2)}
VINN VINN 0 DC {vdd_val*(0.5-vin_frac/2)}

* --- captured output code of the measured conversion, read mid-PH_EOC
* (same nodes and instants as full_conversion_tb_fragment.spice; the
* ideal code for level f is round(f*512)+512, clamped to 0..1023) --
* conversion 1: Vd = {vin_frac}*V_REF, read at 2075.0000 ns

* --- phase structure: BUSY and PH_SAMPLE (SAMPLE_INT) per CLK period --
* Expected per conversion: BUSY = 1 for periods 0..10 (10 bit trials +
* EOC) and 0 for period 11 (SAMPLE); SAMPLE_INT is its complement.

* --- solver profile 'reltol-gear' (reference policy, DR-023; issue #637 solver policy; simulator options only, DUT and stimulus unmodified) ---
.options reltol=1e-4 method=gear
