* extracted by klt extract --deck sky130

* cell sar_sequencer
* pin A,BUSY,X
* pin A,CLK
* pin A,CLK,X
* pin A,D,PH_B1,Q,S
* pin A,D,PH_B5,Q,S
* pin A,D,PH_B9,Q,S
* pin A0,DOUT0,Q
* pin A0,DOUT1,Q
* pin A0,DOUT2,Q
* pin A0,DOUT3,Q
* pin A0,DOUT4,Q
* pin A0,DOUT5,Q
* pin A0,DOUT6,Q
* pin A0,DOUT7,Q
* pin A0,DOUT8,Q
* pin A0,DOUT9,Q
* pin A1,COMP_OUT
* pin B,D,PH_B0,Q,S
* pin B,D,PH_B4,Q,S
* pin B,D,PH_B8,Q,S
* pin C,D,PH_B3,Q,S
* pin C,D,PH_B7,Q,S
* pin C,PH_EOC,Q
* pin CLK,X
* pin D,PH_B2,Q,S
* pin D,PH_B6,Q,S
* pin D,PH_SAMPLE,Y
* pin RESET_B,RST_B
* pin VGND
* pin VPB,VPWR
.SUBCKT sar_sequencer A|BUSY|X A|CLK A|CLK|X A|D|PH_B1|Q|S A|D|PH_B5|Q|S
+ A|D|PH_B9|Q|S A0|DOUT0|Q A0|DOUT1|Q A0|DOUT2|Q A0|DOUT3|Q A0|DOUT4|Q
+ A0|DOUT5|Q A0|DOUT6|Q A0|DOUT7|Q A0|DOUT8|Q A0|DOUT9|Q A1|COMP_OUT
+ B|D|PH_B0|Q|S B|D|PH_B4|Q|S B|D|PH_B8|Q|S C|D|PH_B3|Q|S C|D|PH_B7|Q|S
+ C|PH_EOC|Q CLK|X D|PH_B2|Q|S D|PH_B6|Q|S D|PH_SAMPLE|Y RESET_B|RST_B VGND
+ VPB|VPWR
* device instance $1 r0 *1 12.975,3.165 nfet
M$1 \$11 D|PH_B6|Q|S VGND VGND nfet L=0.15U W=0.42U AS=0.11285P AD=0.0693P
+ PS=1.045U PD=0.75U
* device instance $2 r0 *1 13.455,3.165 nfet
M$2 \$1 A1|COMP_OUT \$11 VGND nfet L=0.15U W=0.42U AS=0.0693P AD=0.09975P
+ PS=0.75U PD=0.895U
* device instance $3 r0 *1 14.08,3.165 nfet
M$3 \$13 A0|DOUT6|Q \$1 VGND nfet L=0.15U W=0.42U AS=0.09975P AD=0.0693P
+ PS=0.895U PD=0.75U
* device instance $4 r0 *1 14.56,3.165 nfet
M$4 VGND \$2 \$13 VGND nfet L=0.15U W=0.42U AS=0.0693P AD=0.1449P PS=0.75U
+ PD=1.11U
* device instance $5 r0 *1 15.4,3.165 nfet
M$5 \$2 D|PH_B6|Q|S VGND VGND nfet L=0.15U W=0.42U AS=0.1449P AD=0.1092P
+ PS=1.11U PD=1.36U
* device instance $6 r0 *1 12.43,3.28 nfet
M$6 VGND \$1 D|X VGND nfet L=0.15U W=0.65U AS=0.169P AD=0.11285P PS=1.82U
+ PD=1.045U
* device instance $7 r0 *1 30.83,3.165 nfet
M$7 VGND CLK|X \$3 VGND nfet L=0.15U W=0.42U AS=0.1092P AD=0.0567P PS=1.36U
+ PD=0.69U
* device instance $8 r0 *1 31.25,3.165 nfet
M$8 \$4 \$3 VGND VGND nfet L=0.15U W=0.42U AS=0.0567P AD=0.1092P PS=0.69U
+ PD=1.36U
* device instance $9 r0 *1 33,3.135 nfet
M$9 \$6 \$3 \$5 VGND nfet L=0.15U W=0.36U AS=0.066P AD=0.0594P PS=0.745U
+ PD=0.69U
* device instance $10 r0 *1 33.48,3.135 nfet
M$10 \$15 \$4 \$6 VGND nfet L=0.15U W=0.36U AS=0.0594P AD=0.1401P PS=0.69U
+ PD=1.1U
* device instance $11 r0 *1 35.825,3.135 nfet
M$11 \$7 \$4 \$18 VGND nfet L=0.15U W=0.36U AS=0.0999P AD=0.0711P PS=0.985U
+ PD=0.755U
* device instance $12 r0 *1 36.37,3.135 nfet
M$12 \$14 \$3 \$7 VGND nfet L=0.15U W=0.36U AS=0.0711P AD=0.0669P PS=0.755U
+ PD=0.75U
* device instance $13 r0 *1 32.525,3.165 nfet
M$13 \$5 C|D|PH_B7|Q|S VGND VGND nfet L=0.15U W=0.42U AS=0.2205P AD=0.066P
+ PS=1.89U PD=0.745U
* device instance $14 r0 *1 34.31,3.165 nfet
M$14 \$16 \$18 \$15 VGND nfet L=0.15U W=0.42U AS=0.1401P AD=0.0441P PS=1.1U
+ PD=0.63U
* device instance $15 r0 *1 34.67,3.165 nfet
M$15 VGND RESET_B|RST_B \$16 VGND nfet L=0.15U W=0.42U AS=0.0441P AD=0.1346P
+ PS=0.63U PD=1.15U
* device instance $16 r0 *1 36.85,3.165 nfet
M$16 VGND \$8 \$14 VGND nfet L=0.15U W=0.42U AS=0.0669P AD=0.12495P PS=0.75U
+ PD=1.015U
* device instance $17 r0 *1 37.595,3.165 nfet
M$17 \$12 RESET_B|RST_B VGND VGND nfet L=0.15U W=0.42U AS=0.12495P AD=0.06405P
+ PS=1.015U PD=0.725U
* device instance $18 r0 *1 38.05,3.165 nfet
M$18 \$8 \$7 \$12 VGND nfet L=0.15U W=0.42U AS=0.06405P AD=0.1092P PS=0.725U
+ PD=1.36U
* device instance $19 r0 *1 35.33,3.275 nfet
M$19 \$18 \$6 VGND VGND nfet L=0.15U W=0.64U AS=0.1346P AD=0.0999P PS=1.15U
+ PD=0.985U
* device instance $20 r0 *1 39.09,3.28 nfet
M$20 D|PH_B6|Q|S \$8 VGND VGND nfet L=0.15U W=0.65U AS=0.2087P AD=0.169P
+ PS=2.02U PD=1.82U
* device instance $21 r0 *1 9.67,7.715 nfet
M$21 VGND CLK|X \$26 VGND nfet L=0.15U W=0.42U AS=0.1092P AD=0.0567P PS=1.36U
+ PD=0.69U
* device instance $22 r0 *1 10.09,7.715 nfet
M$22 \$27 \$26 VGND VGND nfet L=0.15U W=0.42U AS=0.0567P AD=0.1092P PS=0.69U
+ PD=1.36U
* device instance $23 r0 *1 11.365,7.715 nfet
M$23 \$28 D|X$2 VGND VGND nfet L=0.15U W=0.42U AS=0.2205P AD=0.066P PS=1.89U
+ PD=0.745U
* device instance $24 r0 *1 11.84,7.745 nfet
M$24 \$29 \$26 \$28 VGND nfet L=0.15U W=0.36U AS=0.066P AD=0.0594P PS=0.745U
+ PD=0.69U
* device instance $25 r0 *1 12.32,7.745 nfet
M$25 \$29 \$27 \$59 VGND nfet L=0.15U W=0.36U AS=0.1401P AD=0.0594P PS=1.1U
+ PD=0.69U
* device instance $26 r0 *1 13.15,7.715 nfet
M$26 \$60 \$31 \$59 VGND nfet L=0.15U W=0.42U AS=0.1401P AD=0.0441P PS=1.1U
+ PD=0.63U
* device instance $27 r0 *1 13.51,7.715 nfet
M$27 \$60 RESET_B|RST_B VGND VGND nfet L=0.15U W=0.42U AS=0.1346P AD=0.0441P
+ PS=1.15U PD=0.63U
* device instance $28 r0 *1 14.17,7.605 nfet
M$28 \$31 \$29 VGND VGND nfet L=0.15U W=0.64U AS=0.1346P AD=0.0999P PS=1.15U
+ PD=0.985U
* device instance $29 r0 *1 14.665,7.745 nfet
M$29 \$32 \$27 \$31 VGND nfet L=0.15U W=0.36U AS=0.0999P AD=0.0711P PS=0.985U
+ PD=0.755U
* device instance $30 r0 *1 15.21,7.745 nfet
M$30 \$32 \$26 \$61 VGND nfet L=0.15U W=0.36U AS=0.0669P AD=0.0711P PS=0.75U
+ PD=0.755U
* device instance $31 r0 *1 15.69,7.715 nfet
M$31 VGND \$33 \$61 VGND nfet L=0.15U W=0.42U AS=0.0669P AD=0.12495P PS=0.75U
+ PD=1.015U
* device instance $32 r0 *1 16.435,7.715 nfet
M$32 \$63 RESET_B|RST_B VGND VGND nfet L=0.15U W=0.42U AS=0.12495P AD=0.06405P
+ PS=1.015U PD=0.725U
* device instance $33 r0 *1 16.89,7.715 nfet
M$33 \$33 \$32 \$63 VGND nfet L=0.15U W=0.42U AS=0.06405P AD=0.1092P PS=0.725U
+ PD=1.36U
* device instance $34 r0 *1 17.93,7.6 nfet
M$34 A0|DOUT2|Q \$33 VGND VGND nfet L=0.15U W=0.65U AS=0.2087P AD=0.169P
+ PS=2.02U PD=1.82U
* device instance $35 r0 *1 26.23,7.6 nfet
M$35 VGND \$36 D|X$1 VGND nfet L=0.15U W=0.65U AS=0.169P AD=0.11285P PS=1.82U
+ PD=1.045U
* device instance $36 r0 *1 26.775,7.715 nfet
M$36 \$64 C|D|PH_B7|Q|S VGND VGND nfet L=0.15U W=0.42U AS=0.11285P AD=0.0693P
+ PS=1.045U PD=0.75U
* device instance $37 r0 *1 27.255,7.715 nfet
M$37 \$36 A1|COMP_OUT \$64 VGND nfet L=0.15U W=0.42U AS=0.0693P AD=0.09975P
+ PS=0.75U PD=0.895U
* device instance $38 r0 *1 27.88,7.715 nfet
M$38 \$62 A0|DOUT7|Q \$36 VGND nfet L=0.15U W=0.42U AS=0.09975P AD=0.0693P
+ PS=0.895U PD=0.75U
* device instance $39 r0 *1 28.36,7.715 nfet
M$39 VGND \$38 \$62 VGND nfet L=0.15U W=0.42U AS=0.0693P AD=0.1449P PS=0.75U
+ PD=1.11U
* device instance $40 r0 *1 29.2,7.715 nfet
M$40 \$38 C|D|PH_B7|Q|S VGND VGND nfet L=0.15U W=0.42U AS=0.1449P AD=0.1092P
+ PS=1.11U PD=1.36U
* device instance $41 r0 *1 30.83,7.715 nfet
M$41 VGND CLK|X \$39 VGND nfet L=0.15U W=0.42U AS=0.1092P AD=0.0567P PS=1.36U
+ PD=0.69U
* device instance $42 r0 *1 31.25,7.715 nfet
M$42 \$40 \$39 VGND VGND nfet L=0.15U W=0.42U AS=0.0567P AD=0.1092P PS=0.69U
+ PD=1.36U
* device instance $43 r0 *1 32.525,7.715 nfet
M$43 \$41 D|X$1 VGND VGND nfet L=0.15U W=0.42U AS=0.2205P AD=0.066P PS=1.89U
+ PD=0.745U
* device instance $44 r0 *1 33,7.745 nfet
M$44 \$42 \$39 \$41 VGND nfet L=0.15U W=0.36U AS=0.066P AD=0.0594P PS=0.745U
+ PD=0.69U
* device instance $45 r0 *1 33.48,7.745 nfet
M$45 \$42 \$40 \$57 VGND nfet L=0.15U W=0.36U AS=0.1401P AD=0.0594P PS=1.1U
+ PD=0.69U
* device instance $46 r0 *1 34.31,7.715 nfet
M$46 \$58 \$44 \$57 VGND nfet L=0.15U W=0.42U AS=0.1401P AD=0.0441P PS=1.1U
+ PD=0.63U
* device instance $47 r0 *1 34.67,7.715 nfet
M$47 \$58 RESET_B|RST_B VGND VGND nfet L=0.15U W=0.42U AS=0.1346P AD=0.0441P
+ PS=1.15U PD=0.63U
* device instance $48 r0 *1 35.33,7.605 nfet
M$48 \$44 \$42 VGND VGND nfet L=0.15U W=0.64U AS=0.1346P AD=0.0999P PS=1.15U
+ PD=0.985U
* device instance $49 r0 *1 35.825,7.745 nfet
M$49 \$45 \$40 \$44 VGND nfet L=0.15U W=0.36U AS=0.0999P AD=0.0711P PS=0.985U
+ PD=0.755U
* device instance $50 r0 *1 36.37,7.745 nfet
M$50 \$45 \$39 \$56 VGND nfet L=0.15U W=0.36U AS=0.0669P AD=0.0711P PS=0.75U
+ PD=0.755U
* device instance $51 r0 *1 36.85,7.715 nfet
M$51 VGND \$46 \$56 VGND nfet L=0.15U W=0.42U AS=0.0669P AD=0.12495P PS=0.75U
+ PD=1.015U
* device instance $52 r0 *1 37.595,7.715 nfet
M$52 \$55 RESET_B|RST_B VGND VGND nfet L=0.15U W=0.42U AS=0.12495P AD=0.06405P
+ PS=1.015U PD=0.725U
* device instance $53 r0 *1 38.05,7.715 nfet
M$53 \$46 \$45 \$55 VGND nfet L=0.15U W=0.42U AS=0.06405P AD=0.1092P PS=0.725U
+ PD=1.36U
* device instance $54 r0 *1 39.09,7.6 nfet
M$54 A0|DOUT7|Q \$46 VGND VGND nfet L=0.15U W=0.65U AS=0.2087P AD=0.169P
+ PS=2.02U PD=1.82U
* device instance $55 r0 *1 12.975,8.605 nfet
M$55 \$77 D|PH_B2|Q|S VGND VGND nfet L=0.15U W=0.42U AS=0.11285P AD=0.0693P
+ PS=1.045U PD=0.75U
* device instance $56 r0 *1 13.455,8.605 nfet
M$56 \$65 A1|COMP_OUT \$77 VGND nfet L=0.15U W=0.42U AS=0.0693P AD=0.09975P
+ PS=0.75U PD=0.895U
* device instance $57 r0 *1 14.08,8.605 nfet
M$57 \$78 A0|DOUT2|Q \$65 VGND nfet L=0.15U W=0.42U AS=0.09975P AD=0.0693P
+ PS=0.895U PD=0.75U
* device instance $58 r0 *1 14.56,8.605 nfet
M$58 VGND \$66 \$78 VGND nfet L=0.15U W=0.42U AS=0.0693P AD=0.1449P PS=0.75U
+ PD=1.11U
* device instance $59 r0 *1 15.4,8.605 nfet
M$59 \$66 D|PH_B2|Q|S VGND VGND nfet L=0.15U W=0.42U AS=0.1449P AD=0.1092P
+ PS=1.11U PD=1.36U
* device instance $60 r0 *1 12.43,8.72 nfet
M$60 VGND \$65 D|X$2 VGND nfet L=0.15U W=0.65U AS=0.169P AD=0.11285P PS=1.82U
+ PD=1.045U
* device instance $61 r0 *1 18.39,13.04 nfet
M$61 A0|DOUT6|Q \$94 VGND VGND nfet L=0.15U W=0.65U AS=0.2087P AD=0.169P
+ PS=2.02U PD=1.82U
* device instance $62 r0 *1 26.23,13.04 nfet
M$62 VGND \$97 D|X$4 VGND nfet L=0.15U W=0.65U AS=0.169P AD=0.11285P PS=1.82U
+ PD=1.045U
* device instance $63 r0 *1 26.775,13.155 nfet
M$63 \$113 B|D|PH_B8|Q|S VGND VGND nfet L=0.15U W=0.42U AS=0.11285P AD=0.0693P
+ PS=1.045U PD=0.75U
* device instance $64 r0 *1 27.255,13.155 nfet
M$64 \$97 A1|COMP_OUT \$113 VGND nfet L=0.15U W=0.42U AS=0.0693P AD=0.09975P
+ PS=0.75U PD=0.895U
* device instance $65 r0 *1 27.88,13.155 nfet
M$65 \$112 A0|DOUT8|Q \$97 VGND nfet L=0.15U W=0.42U AS=0.09975P AD=0.0693P
+ PS=0.895U PD=0.75U
* device instance $66 r0 *1 28.36,13.155 nfet
M$66 VGND \$98 \$112 VGND nfet L=0.15U W=0.42U AS=0.0693P AD=0.1449P PS=0.75U
+ PD=1.11U
* device instance $67 r0 *1 29.2,13.155 nfet
M$67 \$98 B|D|PH_B8|Q|S VGND VGND nfet L=0.15U W=0.42U AS=0.1449P AD=0.1092P
+ PS=1.11U PD=1.36U
* device instance $68 r0 *1 27.15,8.605 nfet
M$68 VGND CLK|X \$68 VGND nfet L=0.15U W=0.42U AS=0.1092P AD=0.0567P PS=1.36U
+ PD=0.69U
* device instance $69 r0 *1 27.57,8.605 nfet
M$69 \$69 \$68 VGND VGND nfet L=0.15U W=0.42U AS=0.0567P AD=0.1092P PS=0.69U
+ PD=1.36U
* device instance $70 r0 *1 29.32,8.575 nfet
M$70 \$72 \$68 \$71 VGND nfet L=0.15U W=0.36U AS=0.066P AD=0.0594P PS=0.745U
+ PD=0.69U
* device instance $71 r0 *1 29.8,8.575 nfet
M$71 \$79 \$69 \$72 VGND nfet L=0.15U W=0.36U AS=0.0594P AD=0.1401P PS=0.69U
+ PD=1.1U
* device instance $72 r0 *1 32.145,8.575 nfet
M$72 \$74 \$69 \$73 VGND nfet L=0.15U W=0.36U AS=0.0999P AD=0.0711P PS=0.985U
+ PD=0.755U
* device instance $73 r0 *1 32.69,8.575 nfet
M$73 \$82 \$68 \$74 VGND nfet L=0.15U W=0.36U AS=0.0711P AD=0.0669P PS=0.755U
+ PD=0.75U
* device instance $74 r0 *1 28.845,8.605 nfet
M$74 \$71 D|X$3 VGND VGND nfet L=0.15U W=0.42U AS=0.2205P AD=0.066P PS=1.89U
+ PD=0.745U
* device instance $75 r0 *1 30.63,8.605 nfet
M$75 \$80 \$73 \$79 VGND nfet L=0.15U W=0.42U AS=0.1401P AD=0.0441P PS=1.1U
+ PD=0.63U
* device instance $76 r0 *1 30.99,8.605 nfet
M$76 VGND RESET_B|RST_B \$80 VGND nfet L=0.15U W=0.42U AS=0.0441P AD=0.1346P
+ PS=0.63U PD=1.15U
* device instance $77 r0 *1 33.17,8.605 nfet
M$77 VGND \$75 \$82 VGND nfet L=0.15U W=0.42U AS=0.0669P AD=0.12495P PS=0.75U
+ PD=1.015U
* device instance $78 r0 *1 33.915,8.605 nfet
M$78 \$81 RESET_B|RST_B VGND VGND nfet L=0.15U W=0.42U AS=0.12495P AD=0.06405P
+ PS=1.015U PD=0.725U
* device instance $79 r0 *1 34.37,8.605 nfet
M$79 \$75 \$74 \$81 VGND nfet L=0.15U W=0.42U AS=0.06405P AD=0.1092P PS=0.725U
+ PD=1.36U
* device instance $80 r0 *1 31.65,8.715 nfet
M$80 \$73 \$72 VGND VGND nfet L=0.15U W=0.64U AS=0.1346P AD=0.0999P PS=1.15U
+ PD=0.985U
* device instance $81 r0 *1 30.83,13.04 nfet
M$81 VGND \$100 D|X$3 VGND nfet L=0.15U W=0.65U AS=0.169P AD=0.11285P PS=1.82U
+ PD=1.045U
* device instance $82 r0 *1 31.375,13.155 nfet
M$82 \$109 A|D|PH_B9|Q|S VGND VGND nfet L=0.15U W=0.42U AS=0.11285P AD=0.0693P
+ PS=1.045U PD=0.75U
* device instance $83 r0 *1 31.855,13.155 nfet
M$83 \$100 A1|COMP_OUT \$109 VGND nfet L=0.15U W=0.42U AS=0.0693P AD=0.09975P
+ PS=0.75U PD=0.895U
* device instance $84 r0 *1 32.48,13.155 nfet
M$84 \$108 A0|DOUT9|Q \$100 VGND nfet L=0.15U W=0.42U AS=0.09975P AD=0.0693P
+ PS=0.895U PD=0.75U
* device instance $85 r0 *1 32.96,13.155 nfet
M$85 VGND \$101 \$108 VGND nfet L=0.15U W=0.42U AS=0.0693P AD=0.1449P PS=0.75U
+ PD=1.11U
* device instance $86 r0 *1 33.8,13.155 nfet
M$86 \$101 A|D|PH_B9|Q|S VGND VGND nfet L=0.15U W=0.42U AS=0.1449P AD=0.1092P
+ PS=1.11U PD=1.36U
* device instance $87 r0 *1 35.41,8.72 nfet
M$87 A0|DOUT9|Q \$75 VGND VGND nfet L=0.15U W=0.65U AS=0.2087P AD=0.169P
+ PS=2.02U PD=1.82U
* device instance $88 r0 *1 10.13,13.155 nfet
M$88 VGND CLK|X \$87 VGND nfet L=0.15U W=0.42U AS=0.1092P AD=0.0567P PS=1.36U
+ PD=0.69U
* device instance $89 r0 *1 10.55,13.155 nfet
M$89 \$88 \$87 VGND VGND nfet L=0.15U W=0.42U AS=0.0567P AD=0.1092P PS=0.69U
+ PD=1.36U
* device instance $90 r0 *1 11.825,13.155 nfet
M$90 \$89 D|X VGND VGND nfet L=0.15U W=0.42U AS=0.2205P AD=0.066P PS=1.89U
+ PD=0.745U
* device instance $91 r0 *1 12.3,13.185 nfet
M$91 \$90 \$87 \$89 VGND nfet L=0.15U W=0.36U AS=0.066P AD=0.0594P PS=0.745U
+ PD=0.69U
* device instance $92 r0 *1 12.78,13.185 nfet
M$92 \$90 \$88 \$111 VGND nfet L=0.15U W=0.36U AS=0.1401P AD=0.0594P PS=1.1U
+ PD=0.69U
* device instance $93 r0 *1 13.61,13.155 nfet
M$93 \$110 \$92 \$111 VGND nfet L=0.15U W=0.42U AS=0.1401P AD=0.0441P PS=1.1U
+ PD=0.63U
* device instance $94 r0 *1 13.97,13.155 nfet
M$94 \$110 RESET_B|RST_B VGND VGND nfet L=0.15U W=0.42U AS=0.1346P AD=0.0441P
+ PS=1.15U PD=0.63U
* device instance $95 r0 *1 14.63,13.045 nfet
M$95 \$92 \$90 VGND VGND nfet L=0.15U W=0.64U AS=0.1346P AD=0.0999P PS=1.15U
+ PD=0.985U
* device instance $96 r0 *1 15.125,13.185 nfet
M$96 \$93 \$88 \$92 VGND nfet L=0.15U W=0.36U AS=0.0999P AD=0.0711P PS=0.985U
+ PD=0.755U
* device instance $97 r0 *1 15.67,13.185 nfet
M$97 \$93 \$87 \$114 VGND nfet L=0.15U W=0.36U AS=0.0669P AD=0.0711P PS=0.75U
+ PD=0.755U
* device instance $98 r0 *1 16.15,13.155 nfet
M$98 VGND \$94 \$114 VGND nfet L=0.15U W=0.42U AS=0.0669P AD=0.12495P PS=0.75U
+ PD=1.015U
* device instance $99 r0 *1 16.895,13.155 nfet
M$99 \$115 RESET_B|RST_B VGND VGND nfet L=0.15U W=0.42U AS=0.12495P AD=0.06405P
+ PS=1.015U PD=0.725U
* device instance $100 r0 *1 17.35,13.155 nfet
M$100 \$94 \$93 \$115 VGND nfet L=0.15U W=0.42U AS=0.06405P AD=0.1092P
+ PS=0.725U PD=1.36U
* device instance $101 r0 *1 7.37,14.045 nfet
M$101 VGND CLK|X \$116 VGND nfet L=0.15U W=0.42U AS=0.1092P AD=0.0567P PS=1.36U
+ PD=0.69U
* device instance $102 r0 *1 7.79,14.045 nfet
M$102 \$117 \$116 VGND VGND nfet L=0.15U W=0.42U AS=0.0567P AD=0.1092P PS=0.69U
+ PD=1.36U
* device instance $103 r0 *1 9.54,14.015 nfet
M$103 \$119 \$116 \$118 VGND nfet L=0.15U W=0.36U AS=0.066P AD=0.0594P
+ PS=0.745U PD=0.69U
* device instance $104 r0 *1 10.02,14.015 nfet
M$104 \$133 \$117 \$119 VGND nfet L=0.15U W=0.36U AS=0.0594P AD=0.1401P
+ PS=0.69U PD=1.1U
* device instance $105 r0 *1 12.365,14.015 nfet
M$105 \$121 \$117 \$120 VGND nfet L=0.15U W=0.36U AS=0.0999P AD=0.0711P
+ PS=0.985U PD=0.755U
* device instance $106 r0 *1 12.91,14.015 nfet
M$106 \$135 \$116 \$121 VGND nfet L=0.15U W=0.36U AS=0.0711P AD=0.0669P
+ PS=0.755U PD=0.75U
* device instance $107 r0 *1 9.065,14.045 nfet
M$107 \$118 D|X$5 VGND VGND nfet L=0.15U W=0.42U AS=0.2205P AD=0.066P PS=1.89U
+ PD=0.745U
* device instance $108 r0 *1 10.85,14.045 nfet
M$108 \$134 \$120 \$133 VGND nfet L=0.15U W=0.42U AS=0.1401P AD=0.0441P PS=1.1U
+ PD=0.63U
* device instance $109 r0 *1 11.21,14.045 nfet
M$109 VGND RESET_B|RST_B \$134 VGND nfet L=0.15U W=0.42U AS=0.0441P AD=0.1346P
+ PS=0.63U PD=1.15U
* device instance $110 r0 *1 13.39,14.045 nfet
M$110 VGND \$122 \$135 VGND nfet L=0.15U W=0.42U AS=0.0669P AD=0.12495P
+ PS=0.75U PD=1.015U
* device instance $111 r0 *1 14.135,14.045 nfet
M$111 \$136 RESET_B|RST_B VGND VGND nfet L=0.15U W=0.42U AS=0.12495P
+ AD=0.06405P PS=1.015U PD=0.725U
* device instance $112 r0 *1 14.59,14.045 nfet
M$112 \$122 \$121 \$136 VGND nfet L=0.15U W=0.42U AS=0.06405P AD=0.1092P
+ PS=0.725U PD=1.36U
* device instance $113 r0 *1 11.87,14.155 nfet
M$113 \$120 \$119 VGND VGND nfet L=0.15U W=0.64U AS=0.1346P AD=0.0999P PS=1.15U
+ PD=0.985U
* device instance $114 r0 *1 15.63,14.16 nfet
M$114 A0|DOUT5|Q \$122 VGND VGND nfet L=0.15U W=0.65U AS=0.2087P AD=0.169P
+ PS=2.02U PD=1.82U
* device instance $115 r0 *1 24.39,14.16 nfet
M$115 VGND A|X \$124 VGND nfet L=0.15U W=0.65U AS=0.169P AD=0.08775P PS=1.82U
+ PD=0.92U
* device instance $116 r0 *1 24.81,14.16 nfet
M$116 CLK|X \$124 VGND VGND nfet L=0.15U W=0.65U AS=0.08775P AD=0.08775P
+ PS=0.92U PD=0.92U
* device instance $117 r0 *1 25.23,14.16 nfet
M$117 VGND \$124 CLK|X VGND nfet L=0.15U W=0.65U AS=0.08775P AD=0.08775P
+ PS=0.92U PD=0.92U
* device instance $118 r0 *1 25.65,14.16 nfet
M$118 CLK|X \$124 VGND VGND nfet L=0.15U W=0.65U AS=0.08775P AD=0.08775P
+ PS=0.92U PD=0.92U
* device instance $119 r0 *1 26.07,14.16 nfet
M$119 VGND \$124 CLK|X VGND nfet L=0.15U W=0.65U AS=0.08775P AD=0.169P PS=0.92U
+ PD=1.82U
* device instance $120 r0 *1 29.45,14.045 nfet
M$120 VGND CLK|X \$125 VGND nfet L=0.15U W=0.42U AS=0.1092P AD=0.0567P PS=1.36U
+ PD=0.69U
* device instance $121 r0 *1 29.87,14.045 nfet
M$121 \$126 \$125 VGND VGND nfet L=0.15U W=0.42U AS=0.0567P AD=0.1092P PS=0.69U
+ PD=1.36U
* device instance $122 r0 *1 31.62,14.015 nfet
M$122 \$129 \$125 \$128 VGND nfet L=0.15U W=0.36U AS=0.066P AD=0.0594P
+ PS=0.745U PD=0.69U
* device instance $123 r0 *1 32.1,14.015 nfet
M$123 \$140 \$126 \$129 VGND nfet L=0.15U W=0.36U AS=0.0594P AD=0.1401P
+ PS=0.69U PD=1.1U
* device instance $124 r0 *1 34.445,14.015 nfet
M$124 \$131 \$126 \$130 VGND nfet L=0.15U W=0.36U AS=0.0999P AD=0.0711P
+ PS=0.985U PD=0.755U
* device instance $125 r0 *1 34.99,14.015 nfet
M$125 \$138 \$125 \$131 VGND nfet L=0.15U W=0.36U AS=0.0711P AD=0.0669P
+ PS=0.755U PD=0.75U
* device instance $126 r0 *1 31.145,14.045 nfet
M$126 \$128 D|PH_SAMPLE|Y VGND VGND nfet L=0.15U W=0.42U AS=0.2205P AD=0.066P
+ PS=1.89U PD=0.745U
* device instance $127 r0 *1 32.93,14.045 nfet
M$127 \$139 \$130 \$140 VGND nfet L=0.15U W=0.42U AS=0.1401P AD=0.0441P PS=1.1U
+ PD=0.63U
* device instance $128 r0 *1 33.29,14.045 nfet
M$128 VGND RESET_B|RST_B \$139 VGND nfet L=0.15U W=0.42U AS=0.0441P AD=0.1346P
+ PS=0.63U PD=1.15U
* device instance $129 r0 *1 35.47,14.045 nfet
M$129 VGND \$132 \$138 VGND nfet L=0.15U W=0.42U AS=0.0669P AD=0.12495P
+ PS=0.75U PD=1.015U
* device instance $130 r0 *1 36.215,14.045 nfet
M$130 \$137 RESET_B|RST_B VGND VGND nfet L=0.15U W=0.42U AS=0.12495P
+ AD=0.06405P PS=1.015U PD=0.725U
* device instance $131 r0 *1 36.67,14.045 nfet
M$131 \$132 \$131 \$137 VGND nfet L=0.15U W=0.42U AS=0.06405P AD=0.1092P
+ PS=0.725U PD=1.36U
* device instance $132 r0 *1 33.95,14.155 nfet
M$132 \$130 \$129 VGND VGND nfet L=0.15U W=0.64U AS=0.1346P AD=0.0999P PS=1.15U
+ PD=0.985U
* device instance $133 r0 *1 37.71,14.16 nfet
M$133 A|D|PH_B9|Q|S \$132 VGND VGND nfet L=0.15U W=0.65U AS=0.2087P AD=0.169P
+ PS=2.02U PD=1.82U
* device instance $134 r0 *1 11.97,18.48 nfet
M$134 VGND \$148 D|X$5 VGND nfet L=0.15U W=0.65U AS=0.169P AD=0.11285P PS=1.82U
+ PD=1.045U
* device instance $135 r0 *1 12.515,18.595 nfet
M$135 \$174 A|D|PH_B5|Q|S VGND VGND nfet L=0.15U W=0.42U AS=0.11285P AD=0.0693P
+ PS=1.045U PD=0.75U
* device instance $136 r0 *1 12.995,18.595 nfet
M$136 \$148 A1|COMP_OUT \$174 VGND nfet L=0.15U W=0.42U AS=0.0693P AD=0.09975P
+ PS=0.75U PD=0.895U
* device instance $137 r0 *1 13.62,18.595 nfet
M$137 \$175 A0|DOUT5|Q \$148 VGND nfet L=0.15U W=0.42U AS=0.09975P AD=0.0693P
+ PS=0.895U PD=0.75U
* device instance $138 r0 *1 14.1,18.595 nfet
M$138 VGND \$149 \$175 VGND nfet L=0.15U W=0.42U AS=0.0693P AD=0.1449P PS=0.75U
+ PD=1.11U
* device instance $139 r0 *1 14.94,18.595 nfet
M$139 \$149 A|D|PH_B5|Q|S VGND VGND nfet L=0.15U W=0.42U AS=0.1449P AD=0.1092P
+ PS=1.11U PD=1.36U
* device instance $140 r0 *1 21.17,18.595 nfet
M$140 VGND CLK|X \$150 VGND nfet L=0.15U W=0.42U AS=0.1092P AD=0.0567P PS=1.36U
+ PD=0.69U
* device instance $141 r0 *1 21.59,18.595 nfet
M$141 \$151 \$150 VGND VGND nfet L=0.15U W=0.42U AS=0.0567P AD=0.1092P PS=0.69U
+ PD=1.36U
* device instance $142 r0 *1 22.865,18.595 nfet
M$142 \$152 D|X$4 VGND VGND nfet L=0.15U W=0.42U AS=0.2205P AD=0.066P PS=1.89U
+ PD=0.745U
* device instance $143 r0 *1 23.34,18.625 nfet
M$143 \$153 \$150 \$152 VGND nfet L=0.15U W=0.36U AS=0.066P AD=0.0594P
+ PS=0.745U PD=0.69U
* device instance $144 r0 *1 23.82,18.625 nfet
M$144 \$153 \$151 \$178 VGND nfet L=0.15U W=0.36U AS=0.1401P AD=0.0594P PS=1.1U
+ PD=0.69U
* device instance $145 r0 *1 24.65,18.595 nfet
M$145 \$179 \$155 \$178 VGND nfet L=0.15U W=0.42U AS=0.1401P AD=0.0441P PS=1.1U
+ PD=0.63U
* device instance $146 r0 *1 25.01,18.595 nfet
M$146 \$179 RESET_B|RST_B VGND VGND nfet L=0.15U W=0.42U AS=0.1346P AD=0.0441P
+ PS=1.15U PD=0.63U
* device instance $147 r0 *1 25.67,18.485 nfet
M$147 \$155 \$153 VGND VGND nfet L=0.15U W=0.64U AS=0.1346P AD=0.0999P PS=1.15U
+ PD=0.985U
* device instance $148 r0 *1 26.165,18.625 nfet
M$148 \$156 \$151 \$155 VGND nfet L=0.15U W=0.36U AS=0.0999P AD=0.0711P
+ PS=0.985U PD=0.755U
* device instance $149 r0 *1 26.71,18.625 nfet
M$149 \$156 \$150 \$177 VGND nfet L=0.15U W=0.36U AS=0.0669P AD=0.0711P
+ PS=0.75U PD=0.755U
* device instance $150 r0 *1 27.19,18.595 nfet
M$150 VGND \$157 \$177 VGND nfet L=0.15U W=0.42U AS=0.0669P AD=0.12495P
+ PS=0.75U PD=1.015U
* device instance $151 r0 *1 27.935,18.595 nfet
M$151 \$176 RESET_B|RST_B VGND VGND nfet L=0.15U W=0.42U AS=0.12495P
+ AD=0.06405P PS=1.015U PD=0.725U
* device instance $152 r0 *1 28.39,18.595 nfet
M$152 \$157 \$156 \$176 VGND nfet L=0.15U W=0.42U AS=0.06405P AD=0.1092P
+ PS=0.725U PD=1.36U
* device instance $153 r0 *1 29.43,18.48 nfet
M$153 A0|DOUT8|Q \$157 VGND VGND nfet L=0.15U W=0.65U AS=0.2087P AD=0.169P
+ PS=2.02U PD=1.82U
* device instance $154 r0 *1 30.83,18.595 nfet
M$154 VGND CLK|X \$158 VGND nfet L=0.15U W=0.42U AS=0.1092P AD=0.0567P PS=1.36U
+ PD=0.69U
* device instance $155 r0 *1 31.25,18.595 nfet
M$155 \$159 \$158 VGND VGND nfet L=0.15U W=0.42U AS=0.0567P AD=0.1092P PS=0.69U
+ PD=1.36U
* device instance $156 r0 *1 32.525,18.595 nfet
M$156 \$160 A|D|PH_B9|Q|S VGND VGND nfet L=0.15U W=0.42U AS=0.2205P AD=0.066P
+ PS=1.89U PD=0.745U
* device instance $157 r0 *1 33,18.625 nfet
M$157 \$161 \$158 \$160 VGND nfet L=0.15U W=0.36U AS=0.066P AD=0.0594P
+ PS=0.745U PD=0.69U
* device instance $158 r0 *1 33.48,18.625 nfet
M$158 \$161 \$159 \$172 VGND nfet L=0.15U W=0.36U AS=0.1401P AD=0.0594P PS=1.1U
+ PD=0.69U
* device instance $159 r0 *1 34.31,18.595 nfet
M$159 \$173 \$163 \$172 VGND nfet L=0.15U W=0.42U AS=0.1401P AD=0.0441P PS=1.1U
+ PD=0.63U
* device instance $160 r0 *1 34.67,18.595 nfet
M$160 \$173 RESET_B|RST_B VGND VGND nfet L=0.15U W=0.42U AS=0.1346P AD=0.0441P
+ PS=1.15U PD=0.63U
* device instance $161 r0 *1 35.33,18.485 nfet
M$161 \$163 \$161 VGND VGND nfet L=0.15U W=0.64U AS=0.1346P AD=0.0999P PS=1.15U
+ PD=0.985U
* device instance $162 r0 *1 35.825,18.625 nfet
M$162 \$164 \$159 \$163 VGND nfet L=0.15U W=0.36U AS=0.0999P AD=0.0711P
+ PS=0.985U PD=0.755U
* device instance $163 r0 *1 36.37,18.625 nfet
M$163 \$164 \$158 \$171 VGND nfet L=0.15U W=0.36U AS=0.0669P AD=0.0711P
+ PS=0.75U PD=0.755U
* device instance $164 r0 *1 36.85,18.595 nfet
M$164 VGND \$165 \$171 VGND nfet L=0.15U W=0.42U AS=0.0669P AD=0.12495P
+ PS=0.75U PD=1.015U
* device instance $165 r0 *1 37.595,18.595 nfet
M$165 \$170 RESET_B|RST_B VGND VGND nfet L=0.15U W=0.42U AS=0.12495P
+ AD=0.06405P PS=1.015U PD=0.725U
* device instance $166 r0 *1 38.05,18.595 nfet
M$166 \$165 \$164 \$170 VGND nfet L=0.15U W=0.42U AS=0.06405P AD=0.1092P
+ PS=0.725U PD=1.36U
* device instance $167 r0 *1 39.09,18.48 nfet
M$167 B|D|PH_B8|Q|S \$165 VGND VGND nfet L=0.15U W=0.65U AS=0.2087P AD=0.169P
+ PS=2.02U PD=1.82U
* device instance $168 r0 *1 7.37,19.485 nfet
M$168 VGND A|CLK|X \$180 VGND nfet L=0.15U W=0.42U AS=0.1092P AD=0.0567P
+ PS=1.36U PD=0.69U
* device instance $169 r0 *1 7.79,19.485 nfet
M$169 \$181 \$180 VGND VGND nfet L=0.15U W=0.42U AS=0.0567P AD=0.1092P PS=0.69U
+ PD=1.36U
* device instance $170 r0 *1 9.54,19.455 nfet
M$170 \$183 \$180 \$182 VGND nfet L=0.15U W=0.36U AS=0.066P AD=0.0594P
+ PS=0.745U PD=0.69U
* device instance $171 r0 *1 10.02,19.455 nfet
M$171 \$195 \$181 \$183 VGND nfet L=0.15U W=0.36U AS=0.0594P AD=0.1401P
+ PS=0.69U PD=1.1U
* device instance $172 r0 *1 12.365,19.455 nfet
M$172 \$185 \$181 \$184 VGND nfet L=0.15U W=0.36U AS=0.0999P AD=0.0711P
+ PS=0.985U PD=0.755U
* device instance $173 r0 *1 12.91,19.455 nfet
M$173 \$197 \$180 \$185 VGND nfet L=0.15U W=0.36U AS=0.0711P AD=0.0669P
+ PS=0.755U PD=0.75U
* device instance $174 r0 *1 9.065,19.485 nfet
M$174 \$182 D|PH_B6|Q|S VGND VGND nfet L=0.15U W=0.42U AS=0.2205P AD=0.066P
+ PS=1.89U PD=0.745U
* device instance $175 r0 *1 10.85,19.485 nfet
M$175 \$196 \$184 \$195 VGND nfet L=0.15U W=0.42U AS=0.1401P AD=0.0441P PS=1.1U
+ PD=0.63U
* device instance $176 r0 *1 11.21,19.485 nfet
M$176 VGND RESET_B|RST_B \$196 VGND nfet L=0.15U W=0.42U AS=0.0441P AD=0.1346P
+ PS=0.63U PD=1.15U
* device instance $177 r0 *1 13.39,19.485 nfet
M$177 VGND \$186 \$197 VGND nfet L=0.15U W=0.42U AS=0.0669P AD=0.12495P
+ PS=0.75U PD=1.015U
* device instance $178 r0 *1 14.135,19.485 nfet
M$178 \$198 RESET_B|RST_B VGND VGND nfet L=0.15U W=0.42U AS=0.12495P
+ AD=0.06405P PS=1.015U PD=0.725U
* device instance $179 r0 *1 14.59,19.485 nfet
M$179 \$186 \$185 \$198 VGND nfet L=0.15U W=0.42U AS=0.06405P AD=0.1092P
+ PS=0.725U PD=1.36U
* device instance $180 r0 *1 11.87,19.595 nfet
M$180 \$184 \$183 VGND VGND nfet L=0.15U W=0.64U AS=0.1346P AD=0.0999P PS=1.15U
+ PD=0.985U
* device instance $181 r0 *1 15.63,19.6 nfet
M$181 A|D|PH_B5|Q|S \$186 VGND VGND nfet L=0.15U W=0.65U AS=0.2087P AD=0.169P
+ PS=2.02U PD=1.82U
* device instance $182 r0 *1 17.93,23.92 nfet
M$182 D|PH_B2|Q|S \$216 VGND VGND nfet L=0.15U W=0.65U AS=0.2087P AD=0.169P
+ PS=2.02U PD=1.82U
* device instance $183 r0 *1 19.33,19.6 nfet
M$183 VGND A|CLK \$187 VGND nfet L=0.15U W=0.65U AS=0.169P AD=0.08775P PS=1.82U
+ PD=0.92U
* device instance $184 r0 *1 19.75,19.6 nfet
M$184 A|X \$187 VGND VGND nfet L=0.15U W=0.65U AS=0.08775P AD=0.08775P PS=0.92U
+ PD=0.92U
* device instance $185 r0 *1 20.17,19.6 nfet
M$185 VGND \$187 A|X VGND nfet L=0.15U W=0.65U AS=0.08775P AD=0.08775P PS=0.92U
+ PD=0.92U
* device instance $186 r0 *1 20.59,19.6 nfet
M$186 A|X \$187 VGND VGND nfet L=0.15U W=0.65U AS=0.08775P AD=0.08775P PS=0.92U
+ PD=0.92U
* device instance $187 r0 *1 21.01,19.6 nfet
M$187 VGND \$187 A|X VGND nfet L=0.15U W=0.65U AS=0.08775P AD=0.169P PS=0.92U
+ PD=1.82U
* device instance $188 r0 *1 27.15,19.485 nfet
M$188 VGND CLK|X \$188 VGND nfet L=0.15U W=0.42U AS=0.1092P AD=0.0567P PS=1.36U
+ PD=0.69U
* device instance $189 r0 *1 27.57,19.485 nfet
M$189 \$189 \$188 VGND VGND nfet L=0.15U W=0.42U AS=0.0567P AD=0.1092P PS=0.69U
+ PD=1.36U
* device instance $190 r0 *1 29.32,19.455 nfet
M$190 \$191 \$188 \$190 VGND nfet L=0.15U W=0.36U AS=0.066P AD=0.0594P
+ PS=0.745U PD=0.69U
* device instance $191 r0 *1 29.8,19.455 nfet
M$191 \$201 \$189 \$191 VGND nfet L=0.15U W=0.36U AS=0.0594P AD=0.1401P
+ PS=0.69U PD=1.1U
* device instance $192 r0 *1 32.145,19.455 nfet
M$192 \$193 \$189 \$192 VGND nfet L=0.15U W=0.36U AS=0.0999P AD=0.0711P
+ PS=0.985U PD=0.755U
* device instance $193 r0 *1 32.69,19.455 nfet
M$193 \$200 \$188 \$193 VGND nfet L=0.15U W=0.36U AS=0.0711P AD=0.0669P
+ PS=0.755U PD=0.75U
* device instance $194 r0 *1 28.845,19.485 nfet
M$194 \$190 B|D|PH_B8|Q|S VGND VGND nfet L=0.15U W=0.42U AS=0.2205P AD=0.066P
+ PS=1.89U PD=0.745U
* device instance $195 r0 *1 30.63,19.485 nfet
M$195 \$202 \$192 \$201 VGND nfet L=0.15U W=0.42U AS=0.1401P AD=0.0441P PS=1.1U
+ PD=0.63U
* device instance $196 r0 *1 30.99,19.485 nfet
M$196 VGND RESET_B|RST_B \$202 VGND nfet L=0.15U W=0.42U AS=0.0441P AD=0.1346P
+ PS=0.63U PD=1.15U
* device instance $197 r0 *1 33.17,19.485 nfet
M$197 VGND \$194 \$200 VGND nfet L=0.15U W=0.42U AS=0.0669P AD=0.12495P
+ PS=0.75U PD=1.015U
* device instance $198 r0 *1 33.915,19.485 nfet
M$198 \$199 RESET_B|RST_B VGND VGND nfet L=0.15U W=0.42U AS=0.12495P
+ AD=0.06405P PS=1.015U PD=0.725U
* device instance $199 r0 *1 34.37,19.485 nfet
M$199 \$194 \$193 \$199 VGND nfet L=0.15U W=0.42U AS=0.06405P AD=0.1092P
+ PS=0.725U PD=1.36U
* device instance $200 r0 *1 31.65,19.595 nfet
M$200 \$192 \$191 VGND VGND nfet L=0.15U W=0.64U AS=0.1346P AD=0.0999P PS=1.15U
+ PD=0.985U
* device instance $201 r0 *1 35.41,19.6 nfet
M$201 C|D|PH_B7|Q|S \$194 VGND VGND nfet L=0.15U W=0.65U AS=0.2087P AD=0.169P
+ PS=2.02U PD=1.82U
* device instance $202 r0 *1 39.09,23.92 nfet
M$202 C|PH_EOC|Q \$225 VGND VGND nfet L=0.15U W=0.65U AS=0.2087P AD=0.169P
+ PS=2.02U PD=1.82U
* device instance $203 r0 *1 27.61,24.005 nfet
M$203 \$230 D|PH_B6|Q|S VGND VGND nfet L=0.15U W=0.42U AS=0.1092P AD=0.0693P
+ PS=1.36U PD=0.75U
* device instance $204 r0 *1 28.09,24.005 nfet
M$204 VGND C|D|PH_B7|Q|S \$230 VGND nfet L=0.15U W=0.42U AS=0.0693P AD=0.0567P
+ PS=0.75U PD=0.69U
* device instance $205 r0 *1 28.51,24.005 nfet
M$205 \$230 B|D|PH_B8|Q|S VGND VGND nfet L=0.15U W=0.42U AS=0.0567P AD=0.0567P
+ PS=0.69U PD=0.69U
* device instance $206 r0 *1 28.93,24.005 nfet
M$206 \$230 A|D|PH_B9|Q|S VGND VGND nfet L=0.15U W=0.42U AS=0.101875P
+ AD=0.0567P PS=0.99U PD=0.69U
* device instance $207 r0 *1 29.42,23.92 nfet
M$207 A|X$1 \$230 VGND VGND nfet L=0.15U W=0.65U AS=0.101875P AD=0.1755P
+ PS=0.99U PD=1.84U
* device instance $208 r0 *1 9.67,24.035 nfet
M$208 VGND A|CLK|X \$209 VGND nfet L=0.15U W=0.42U AS=0.1092P AD=0.0567P
+ PS=1.36U PD=0.69U
* device instance $209 r0 *1 10.09,24.035 nfet
M$209 \$210 \$209 VGND VGND nfet L=0.15U W=0.42U AS=0.0567P AD=0.1092P PS=0.69U
+ PD=1.36U
* device instance $210 r0 *1 11.365,24.035 nfet
M$210 \$211 C|D|PH_B3|Q|S VGND VGND nfet L=0.15U W=0.42U AS=0.2205P AD=0.066P
+ PS=1.89U PD=0.745U
* device instance $211 r0 *1 11.84,24.065 nfet
M$211 \$212 \$209 \$211 VGND nfet L=0.15U W=0.36U AS=0.066P AD=0.0594P
+ PS=0.745U PD=0.69U
* device instance $212 r0 *1 12.32,24.065 nfet
M$212 \$212 \$210 \$239 VGND nfet L=0.15U W=0.36U AS=0.1401P AD=0.0594P PS=1.1U
+ PD=0.69U
* device instance $213 r0 *1 13.15,24.035 nfet
M$213 \$238 \$214 \$239 VGND nfet L=0.15U W=0.42U AS=0.1401P AD=0.0441P PS=1.1U
+ PD=0.63U
* device instance $214 r0 *1 13.51,24.035 nfet
M$214 \$238 RESET_B|RST_B VGND VGND nfet L=0.15U W=0.42U AS=0.1346P AD=0.0441P
+ PS=1.15U PD=0.63U
* device instance $215 r0 *1 14.17,23.925 nfet
M$215 \$214 \$212 VGND VGND nfet L=0.15U W=0.64U AS=0.1346P AD=0.0999P PS=1.15U
+ PD=0.985U
* device instance $216 r0 *1 14.665,24.065 nfet
M$216 \$215 \$210 \$214 VGND nfet L=0.15U W=0.36U AS=0.0999P AD=0.0711P
+ PS=0.985U PD=0.755U
* device instance $217 r0 *1 15.21,24.065 nfet
M$217 \$215 \$209 \$241 VGND nfet L=0.15U W=0.36U AS=0.0669P AD=0.0711P
+ PS=0.75U PD=0.755U
* device instance $218 r0 *1 15.69,24.035 nfet
M$218 VGND \$216 \$241 VGND nfet L=0.15U W=0.42U AS=0.0669P AD=0.12495P
+ PS=0.75U PD=1.015U
* device instance $219 r0 *1 16.435,24.035 nfet
M$219 \$242 RESET_B|RST_B VGND VGND nfet L=0.15U W=0.42U AS=0.12495P
+ AD=0.06405P PS=1.015U PD=0.725U
* device instance $220 r0 *1 16.89,24.035 nfet
M$220 \$216 \$215 \$242 VGND nfet L=0.15U W=0.42U AS=0.06405P AD=0.1092P
+ PS=0.725U PD=1.36U
* device instance $221 r0 *1 30.83,24.035 nfet
M$221 VGND CLK|X \$218 VGND nfet L=0.15U W=0.42U AS=0.1092P AD=0.0567P PS=1.36U
+ PD=0.69U
* device instance $222 r0 *1 31.25,24.035 nfet
M$222 \$219 \$218 VGND VGND nfet L=0.15U W=0.42U AS=0.0567P AD=0.1092P PS=0.69U
+ PD=1.36U
* device instance $223 r0 *1 32.525,24.035 nfet
M$223 \$220 B|D|PH_B0|Q|S VGND VGND nfet L=0.15U W=0.42U AS=0.2205P AD=0.066P
+ PS=1.89U PD=0.745U
* device instance $224 r0 *1 33,24.065 nfet
M$224 \$221 \$218 \$220 VGND nfet L=0.15U W=0.36U AS=0.066P AD=0.0594P
+ PS=0.745U PD=0.69U
* device instance $225 r0 *1 33.48,24.065 nfet
M$225 \$221 \$219 \$237 VGND nfet L=0.15U W=0.36U AS=0.1401P AD=0.0594P PS=1.1U
+ PD=0.69U
* device instance $226 r0 *1 34.31,24.035 nfet
M$226 \$240 \$223 \$237 VGND nfet L=0.15U W=0.42U AS=0.1401P AD=0.0441P PS=1.1U
+ PD=0.63U
* device instance $227 r0 *1 34.67,24.035 nfet
M$227 \$240 RESET_B|RST_B VGND VGND nfet L=0.15U W=0.42U AS=0.1346P AD=0.0441P
+ PS=1.15U PD=0.63U
* device instance $228 r0 *1 35.33,23.925 nfet
M$228 \$223 \$221 VGND VGND nfet L=0.15U W=0.64U AS=0.1346P AD=0.0999P PS=1.15U
+ PD=0.985U
* device instance $229 r0 *1 35.825,24.065 nfet
M$229 \$224 \$219 \$223 VGND nfet L=0.15U W=0.36U AS=0.0999P AD=0.0711P
+ PS=0.985U PD=0.755U
* device instance $230 r0 *1 36.37,24.065 nfet
M$230 \$224 \$218 \$236 VGND nfet L=0.15U W=0.36U AS=0.0669P AD=0.0711P
+ PS=0.75U PD=0.755U
* device instance $231 r0 *1 36.85,24.035 nfet
M$231 VGND \$225 \$236 VGND nfet L=0.15U W=0.42U AS=0.0669P AD=0.12495P
+ PS=0.75U PD=1.015U
* device instance $232 r0 *1 37.595,24.035 nfet
M$232 \$235 RESET_B|RST_B VGND VGND nfet L=0.15U W=0.42U AS=0.12495P
+ AD=0.06405P PS=1.015U PD=0.725U
* device instance $233 r0 *1 38.05,24.035 nfet
M$233 \$225 \$224 \$235 VGND nfet L=0.15U W=0.42U AS=0.06405P AD=0.1092P
+ PS=0.725U PD=1.36U
* device instance $234 r0 *1 7.37,24.925 nfet
M$234 VGND A|CLK|X \$243 VGND nfet L=0.15U W=0.42U AS=0.1092P AD=0.0567P
+ PS=1.36U PD=0.69U
* device instance $235 r0 *1 7.79,24.925 nfet
M$235 \$244 \$243 VGND VGND nfet L=0.15U W=0.42U AS=0.0567P AD=0.1092P PS=0.69U
+ PD=1.36U
* device instance $236 r0 *1 9.54,24.895 nfet
M$236 \$246 \$243 \$245 VGND nfet L=0.15U W=0.36U AS=0.066P AD=0.0594P
+ PS=0.745U PD=0.69U
* device instance $237 r0 *1 10.02,24.895 nfet
M$237 \$258 \$244 \$246 VGND nfet L=0.15U W=0.36U AS=0.0594P AD=0.1401P
+ PS=0.69U PD=1.1U
* device instance $238 r0 *1 12.365,24.895 nfet
M$238 \$247 \$244 \$265 VGND nfet L=0.15U W=0.36U AS=0.0999P AD=0.0711P
+ PS=0.985U PD=0.755U
* device instance $239 r0 *1 12.91,24.895 nfet
M$239 \$260 \$243 \$247 VGND nfet L=0.15U W=0.36U AS=0.0711P AD=0.0669P
+ PS=0.755U PD=0.75U
* device instance $240 r0 *1 9.065,24.925 nfet
M$240 \$245 A|D|PH_B5|Q|S VGND VGND nfet L=0.15U W=0.42U AS=0.2205P AD=0.066P
+ PS=1.89U PD=0.745U
* device instance $241 r0 *1 10.85,24.925 nfet
M$241 \$259 \$265 \$258 VGND nfet L=0.15U W=0.42U AS=0.1401P AD=0.0441P PS=1.1U
+ PD=0.63U
* device instance $242 r0 *1 11.21,24.925 nfet
M$242 VGND RESET_B|RST_B \$259 VGND nfet L=0.15U W=0.42U AS=0.0441P AD=0.1346P
+ PS=0.63U PD=1.15U
* device instance $243 r0 *1 13.39,24.925 nfet
M$243 VGND \$248 \$260 VGND nfet L=0.15U W=0.42U AS=0.0669P AD=0.12495P
+ PS=0.75U PD=1.015U
* device instance $244 r0 *1 14.135,24.925 nfet
M$244 \$261 RESET_B|RST_B VGND VGND nfet L=0.15U W=0.42U AS=0.12495P
+ AD=0.06405P PS=1.015U PD=0.725U
* device instance $245 r0 *1 14.59,24.925 nfet
M$245 \$248 \$247 \$261 VGND nfet L=0.15U W=0.42U AS=0.06405P AD=0.1092P
+ PS=0.725U PD=1.36U
* device instance $246 r0 *1 11.87,25.035 nfet
M$246 \$265 \$246 VGND VGND nfet L=0.15U W=0.64U AS=0.1346P AD=0.0999P PS=1.15U
+ PD=0.985U
* device instance $247 r0 *1 15.63,25.04 nfet
M$247 B|D|PH_B4|Q|S \$248 VGND VGND nfet L=0.15U W=0.65U AS=0.2087P AD=0.169P
+ PS=2.02U PD=1.82U
* device instance $248 r0 *1 26.775,24.925 nfet
M$248 \$262 A|D|PH_B1|Q|S VGND VGND nfet L=0.15U W=0.42U AS=0.11285P AD=0.0693P
+ PS=1.045U PD=0.75U
* device instance $249 r0 *1 27.255,24.925 nfet
M$249 \$251 A1|COMP_OUT \$262 VGND nfet L=0.15U W=0.42U AS=0.0693P AD=0.09975P
+ PS=0.75U PD=0.895U
* device instance $250 r0 *1 27.88,24.925 nfet
M$250 \$263 A0|DOUT1|Q \$251 VGND nfet L=0.15U W=0.42U AS=0.09975P AD=0.0693P
+ PS=0.895U PD=0.75U
* device instance $251 r0 *1 28.36,24.925 nfet
M$251 VGND \$253 \$263 VGND nfet L=0.15U W=0.42U AS=0.0693P AD=0.1449P PS=0.75U
+ PD=1.11U
* device instance $252 r0 *1 29.2,24.925 nfet
M$252 \$253 A|D|PH_B1|Q|S VGND VGND nfet L=0.15U W=0.42U AS=0.1449P AD=0.1092P
+ PS=1.11U PD=1.36U
* device instance $253 r0 *1 26.23,25.04 nfet
M$253 VGND \$251 D|X$6 VGND nfet L=0.15U W=0.65U AS=0.169P AD=0.11285P PS=1.82U
+ PD=1.045U
* device instance $254 r0 *1 11.05,29.36 nfet
M$254 VGND \$277 D|X$7 VGND nfet L=0.15U W=0.65U AS=0.169P AD=0.11285P PS=1.82U
+ PD=1.045U
* device instance $255 r0 *1 11.595,29.475 nfet
M$255 \$308 B|D|PH_B4|Q|S VGND VGND nfet L=0.15U W=0.42U AS=0.11285P AD=0.0693P
+ PS=1.045U PD=0.75U
* device instance $256 r0 *1 12.075,29.475 nfet
M$256 \$277 A1|COMP_OUT \$308 VGND nfet L=0.15U W=0.42U AS=0.0693P AD=0.09975P
+ PS=0.75U PD=0.895U
* device instance $257 r0 *1 12.7,29.475 nfet
M$257 \$309 A0|DOUT4|Q \$277 VGND nfet L=0.15U W=0.42U AS=0.09975P AD=0.0693P
+ PS=0.895U PD=0.75U
* device instance $258 r0 *1 13.18,29.475 nfet
M$258 VGND \$279 \$309 VGND nfet L=0.15U W=0.42U AS=0.0693P AD=0.1449P PS=0.75U
+ PD=1.11U
* device instance $259 r0 *1 14.02,29.475 nfet
M$259 \$279 B|D|PH_B4|Q|S VGND VGND nfet L=0.15U W=0.42U AS=0.1449P AD=0.1092P
+ PS=1.11U PD=1.36U
* device instance $260 r0 *1 15.19,29.475 nfet
M$260 VGND A|CLK|X \$280 VGND nfet L=0.15U W=0.42U AS=0.1092P AD=0.0567P
+ PS=1.36U PD=0.69U
* device instance $261 r0 *1 15.61,29.475 nfet
M$261 \$281 \$280 VGND VGND nfet L=0.15U W=0.42U AS=0.0567P AD=0.1092P PS=0.69U
+ PD=1.36U
* device instance $262 r0 *1 16.885,29.475 nfet
M$262 \$282 D|PH_B2|Q|S VGND VGND nfet L=0.15U W=0.42U AS=0.2205P AD=0.066P
+ PS=1.89U PD=0.745U
* device instance $263 r0 *1 17.36,29.505 nfet
M$263 \$283 \$280 \$282 VGND nfet L=0.15U W=0.36U AS=0.066P AD=0.0594P
+ PS=0.745U PD=0.69U
* device instance $264 r0 *1 17.84,29.505 nfet
M$264 \$283 \$281 \$313 VGND nfet L=0.15U W=0.36U AS=0.1401P AD=0.0594P PS=1.1U
+ PD=0.69U
* device instance $265 r0 *1 18.67,29.475 nfet
M$265 \$312 \$285 \$313 VGND nfet L=0.15U W=0.42U AS=0.1401P AD=0.0441P PS=1.1U
+ PD=0.63U
* device instance $266 r0 *1 19.03,29.475 nfet
M$266 \$312 RESET_B|RST_B VGND VGND nfet L=0.15U W=0.42U AS=0.1346P AD=0.0441P
+ PS=1.15U PD=0.63U
* device instance $267 r0 *1 19.69,29.365 nfet
M$267 \$285 \$283 VGND VGND nfet L=0.15U W=0.64U AS=0.1346P AD=0.0999P PS=1.15U
+ PD=0.985U
* device instance $268 r0 *1 20.185,29.505 nfet
M$268 \$286 \$281 \$285 VGND nfet L=0.15U W=0.36U AS=0.0999P AD=0.0711P
+ PS=0.985U PD=0.755U
* device instance $269 r0 *1 20.73,29.505 nfet
M$269 \$286 \$280 \$315 VGND nfet L=0.15U W=0.36U AS=0.0669P AD=0.0711P
+ PS=0.75U PD=0.755U
* device instance $270 r0 *1 21.21,29.475 nfet
M$270 VGND \$287 \$315 VGND nfet L=0.15U W=0.42U AS=0.0669P AD=0.12495P
+ PS=0.75U PD=1.015U
* device instance $271 r0 *1 21.955,29.475 nfet
M$271 \$314 RESET_B|RST_B VGND VGND nfet L=0.15U W=0.42U AS=0.12495P
+ AD=0.06405P PS=1.015U PD=0.725U
* device instance $272 r0 *1 22.41,29.475 nfet
M$272 \$287 \$286 \$314 VGND nfet L=0.15U W=0.42U AS=0.06405P AD=0.1092P
+ PS=0.725U PD=1.36U
* device instance $273 r0 *1 23.45,29.36 nfet
M$273 A|D|PH_B1|Q|S \$287 VGND VGND nfet L=0.15U W=0.65U AS=0.2087P AD=0.169P
+ PS=2.02U PD=1.82U
* device instance $274 r0 *1 26.23,29.36 nfet
M$274 VGND \$289 D|X$8 VGND nfet L=0.15U W=0.65U AS=0.169P AD=0.11285P PS=1.82U
+ PD=1.045U
* device instance $275 r0 *1 26.775,29.475 nfet
M$275 \$311 C|D|PH_B3|Q|S VGND VGND nfet L=0.15U W=0.42U AS=0.11285P AD=0.0693P
+ PS=1.045U PD=0.75U
* device instance $276 r0 *1 27.255,29.475 nfet
M$276 \$289 A1|COMP_OUT \$311 VGND nfet L=0.15U W=0.42U AS=0.0693P AD=0.09975P
+ PS=0.75U PD=0.895U
* device instance $277 r0 *1 27.88,29.475 nfet
M$277 \$310 A0|DOUT3|Q \$289 VGND nfet L=0.15U W=0.42U AS=0.09975P AD=0.0693P
+ PS=0.895U PD=0.75U
* device instance $278 r0 *1 28.36,29.475 nfet
M$278 VGND \$290 \$310 VGND nfet L=0.15U W=0.42U AS=0.0693P AD=0.1449P PS=0.75U
+ PD=1.11U
* device instance $279 r0 *1 29.2,29.475 nfet
M$279 \$290 C|D|PH_B3|Q|S VGND VGND nfet L=0.15U W=0.42U AS=0.1449P AD=0.1092P
+ PS=1.11U PD=1.36U
* device instance $280 r0 *1 30.37,24.955 nfet
M$280 \$254 D|PH_B2|Q|S VGND VGND nfet L=0.15U W=0.42U AS=0.1092P AD=0.0693P
+ PS=1.36U PD=0.75U
* device instance $281 r0 *1 30.85,24.955 nfet
M$281 VGND C|D|PH_B3|Q|S \$254 VGND nfet L=0.15U W=0.42U AS=0.0693P AD=0.0567P
+ PS=0.75U PD=0.69U
* device instance $282 r0 *1 31.27,24.955 nfet
M$282 \$254 B|D|PH_B4|Q|S VGND VGND nfet L=0.15U W=0.42U AS=0.0567P AD=0.0567P
+ PS=0.69U PD=0.69U
* device instance $283 r0 *1 31.69,24.955 nfet
M$283 \$254 A|D|PH_B5|Q|S VGND VGND nfet L=0.15U W=0.42U AS=0.101875P
+ AD=0.0567P PS=0.99U PD=0.69U
* device instance $284 r0 *1 32.18,25.04 nfet
M$284 B|X \$254 VGND VGND nfet L=0.15U W=0.65U AS=0.101875P AD=0.1755P PS=0.99U
+ PD=1.84U
* device instance $285 r0 *1 30.84,29.445 nfet
M$285 VGND C|PH_EOC|Q \$294 VGND nfet L=0.15U W=0.42U AS=0.1092P AD=0.0567P
+ PS=1.36U PD=0.69U
* device instance $286 r0 *1 31.26,29.445 nfet
M$286 \$294 B|D|PH_B0|Q|S VGND VGND nfet L=0.15U W=0.42U AS=0.0567P AD=0.0567P
+ PS=0.69U PD=0.69U
* device instance $287 r0 *1 31.68,29.445 nfet
M$287 \$294 A|D|PH_B1|Q|S VGND VGND nfet L=0.15U W=0.42U AS=0.101875P
+ AD=0.0567P PS=0.99U PD=0.69U
* device instance $288 r0 *1 32.17,29.36 nfet
M$288 C|X \$294 VGND VGND nfet L=0.15U W=0.65U AS=0.101875P AD=0.182P PS=0.99U
+ PD=1.86U
* device instance $289 r0 *1 33.14,24.955 nfet
M$289 VGND C|X \$256 VGND nfet L=0.15U W=0.42U AS=0.1092P AD=0.0567P PS=1.36U
+ PD=0.69U
* device instance $290 r0 *1 33.56,24.955 nfet
M$290 \$256 B|X VGND VGND nfet L=0.15U W=0.42U AS=0.0567P AD=0.0567P PS=0.69U
+ PD=0.69U
* device instance $291 r0 *1 33.98,24.955 nfet
M$291 \$256 A|X$1 VGND VGND nfet L=0.15U W=0.42U AS=0.101875P AD=0.0567P
+ PS=0.99U PD=0.69U
* device instance $292 r0 *1 34.47,25.04 nfet
M$292 A|BUSY|X \$256 VGND VGND nfet L=0.15U W=0.65U AS=0.101875P AD=0.182P
+ PS=0.99U PD=1.86U
* device instance $293 r0 *1 33.335,29.36 nfet
M$293 D|PH_SAMPLE|Y A|BUSY|X VGND VGND nfet L=0.15U W=0.65U AS=0.169P AD=0.169P
+ PS=1.82U PD=1.82U
* device instance $294 r0 *1 34.51,29.36 nfet
M$294 VGND \$292 D|X$9 VGND nfet L=0.15U W=0.65U AS=0.169P AD=0.11285P PS=1.82U
+ PD=1.045U
* device instance $295 r0 *1 35.055,29.475 nfet
M$295 \$307 B|D|PH_B0|Q|S VGND VGND nfet L=0.15U W=0.42U AS=0.11285P AD=0.0693P
+ PS=1.045U PD=0.75U
* device instance $296 r0 *1 35.535,29.475 nfet
M$296 \$292 A1|COMP_OUT \$307 VGND nfet L=0.15U W=0.42U AS=0.0693P AD=0.09975P
+ PS=0.75U PD=0.895U
* device instance $297 r0 *1 36.16,29.475 nfet
M$297 \$306 A0|DOUT0|Q \$292 VGND nfet L=0.15U W=0.42U AS=0.09975P AD=0.0693P
+ PS=0.895U PD=0.75U
* device instance $298 r0 *1 36.64,29.475 nfet
M$298 VGND \$293 \$306 VGND nfet L=0.15U W=0.42U AS=0.0693P AD=0.1449P PS=0.75U
+ PD=1.11U
* device instance $299 r0 *1 37.48,29.475 nfet
M$299 \$293 B|D|PH_B0|Q|S VGND VGND nfet L=0.15U W=0.42U AS=0.1449P AD=0.1092P
+ PS=1.11U PD=1.36U
* device instance $300 r0 *1 7.37,30.365 nfet
M$300 VGND A|CLK|X \$316 VGND nfet L=0.15U W=0.42U AS=0.1092P AD=0.0567P
+ PS=1.36U PD=0.69U
* device instance $301 r0 *1 7.79,30.365 nfet
M$301 \$317 \$316 VGND VGND nfet L=0.15U W=0.42U AS=0.0567P AD=0.1092P PS=0.69U
+ PD=1.36U
* device instance $302 r0 *1 9.54,30.335 nfet
M$302 \$319 \$316 \$318 VGND nfet L=0.15U W=0.36U AS=0.066P AD=0.0594P
+ PS=0.745U PD=0.69U
* device instance $303 r0 *1 10.02,30.335 nfet
M$303 \$329 \$317 \$319 VGND nfet L=0.15U W=0.36U AS=0.0594P AD=0.1401P
+ PS=0.69U PD=1.1U
* device instance $304 r0 *1 12.365,30.335 nfet
M$304 \$320 \$317 \$337 VGND nfet L=0.15U W=0.36U AS=0.0999P AD=0.0711P
+ PS=0.985U PD=0.755U
* device instance $305 r0 *1 12.91,30.335 nfet
M$305 \$331 \$316 \$320 VGND nfet L=0.15U W=0.36U AS=0.0711P AD=0.0669P
+ PS=0.755U PD=0.75U
* device instance $306 r0 *1 9.065,30.365 nfet
M$306 \$318 B|D|PH_B4|Q|S VGND VGND nfet L=0.15U W=0.42U AS=0.2205P AD=0.066P
+ PS=1.89U PD=0.745U
* device instance $307 r0 *1 10.85,30.365 nfet
M$307 \$330 \$337 \$329 VGND nfet L=0.15U W=0.42U AS=0.1401P AD=0.0441P PS=1.1U
+ PD=0.63U
* device instance $308 r0 *1 11.21,30.365 nfet
M$308 VGND RESET_B|RST_B \$330 VGND nfet L=0.15U W=0.42U AS=0.0441P AD=0.1346P
+ PS=0.63U PD=1.15U
* device instance $309 r0 *1 13.39,30.365 nfet
M$309 VGND \$321 \$331 VGND nfet L=0.15U W=0.42U AS=0.0669P AD=0.12495P
+ PS=0.75U PD=1.015U
* device instance $310 r0 *1 14.135,30.365 nfet
M$310 \$332 RESET_B|RST_B VGND VGND nfet L=0.15U W=0.42U AS=0.12495P
+ AD=0.06405P PS=1.015U PD=0.725U
* device instance $311 r0 *1 14.59,30.365 nfet
M$311 \$321 \$320 \$332 VGND nfet L=0.15U W=0.42U AS=0.06405P AD=0.1092P
+ PS=0.725U PD=1.36U
* device instance $312 r0 *1 11.87,30.475 nfet
M$312 \$337 \$319 VGND VGND nfet L=0.15U W=0.64U AS=0.1346P AD=0.0999P PS=1.15U
+ PD=0.985U
* device instance $313 r0 *1 15.63,30.48 nfet
M$313 C|D|PH_B3|Q|S \$321 VGND VGND nfet L=0.15U W=0.65U AS=0.2087P AD=0.169P
+ PS=2.02U PD=1.82U
* device instance $314 r0 *1 17.03,30.48 nfet
M$314 VGND A|X \$322 VGND nfet L=0.15U W=0.65U AS=0.169P AD=0.08775P PS=1.82U
+ PD=0.92U
* device instance $315 r0 *1 17.45,30.48 nfet
M$315 A|CLK|X \$322 VGND VGND nfet L=0.15U W=0.65U AS=0.08775P AD=0.08775P
+ PS=0.92U PD=0.92U
* device instance $316 r0 *1 17.87,30.48 nfet
M$316 VGND \$322 A|CLK|X VGND nfet L=0.15U W=0.65U AS=0.08775P AD=0.08775P
+ PS=0.92U PD=0.92U
* device instance $317 r0 *1 18.29,30.48 nfet
M$317 A|CLK|X \$322 VGND VGND nfet L=0.15U W=0.65U AS=0.08775P AD=0.08775P
+ PS=0.92U PD=0.92U
* device instance $318 r0 *1 18.71,30.48 nfet
M$318 VGND \$322 A|CLK|X VGND nfet L=0.15U W=0.65U AS=0.08775P AD=0.169P
+ PS=0.92U PD=1.82U
* device instance $319 r0 *1 25.77,30.365 nfet
M$319 VGND A|CLK|X \$323 VGND nfet L=0.15U W=0.42U AS=0.1092P AD=0.0567P
+ PS=1.36U PD=0.69U
* device instance $320 r0 *1 26.19,30.365 nfet
M$320 \$324 \$323 VGND VGND nfet L=0.15U W=0.42U AS=0.0567P AD=0.1092P PS=0.69U
+ PD=1.36U
* device instance $321 r0 *1 27.94,30.335 nfet
M$321 \$326 \$323 \$325 VGND nfet L=0.15U W=0.36U AS=0.066P AD=0.0594P
+ PS=0.745U PD=0.69U
* device instance $322 r0 *1 28.42,30.335 nfet
M$322 \$335 \$324 \$326 VGND nfet L=0.15U W=0.36U AS=0.0594P AD=0.1401P
+ PS=0.69U PD=1.1U
* device instance $323 r0 *1 30.765,30.335 nfet
M$323 \$327 \$324 \$338 VGND nfet L=0.15U W=0.36U AS=0.0999P AD=0.0711P
+ PS=0.985U PD=0.755U
* device instance $324 r0 *1 31.31,30.335 nfet
M$324 \$334 \$323 \$327 VGND nfet L=0.15U W=0.36U AS=0.0711P AD=0.0669P
+ PS=0.755U PD=0.75U
* device instance $325 r0 *1 27.465,30.365 nfet
M$325 \$325 D|X$8 VGND VGND nfet L=0.15U W=0.42U AS=0.2205P AD=0.066P PS=1.89U
+ PD=0.745U
* device instance $326 r0 *1 29.25,30.365 nfet
M$326 \$336 \$338 \$335 VGND nfet L=0.15U W=0.42U AS=0.1401P AD=0.0441P PS=1.1U
+ PD=0.63U
* device instance $327 r0 *1 29.61,30.365 nfet
M$327 VGND RESET_B|RST_B \$336 VGND nfet L=0.15U W=0.42U AS=0.0441P AD=0.1346P
+ PS=0.63U PD=1.15U
* device instance $328 r0 *1 31.79,30.365 nfet
M$328 VGND \$328 \$334 VGND nfet L=0.15U W=0.42U AS=0.0669P AD=0.12495P
+ PS=0.75U PD=1.015U
* device instance $329 r0 *1 32.535,30.365 nfet
M$329 \$333 RESET_B|RST_B VGND VGND nfet L=0.15U W=0.42U AS=0.12495P
+ AD=0.06405P PS=1.015U PD=0.725U
* device instance $330 r0 *1 32.99,30.365 nfet
M$330 \$328 \$327 \$333 VGND nfet L=0.15U W=0.42U AS=0.06405P AD=0.1092P
+ PS=0.725U PD=1.36U
* device instance $331 r0 *1 30.27,30.475 nfet
M$331 \$338 \$326 VGND VGND nfet L=0.15U W=0.64U AS=0.1346P AD=0.0999P PS=1.15U
+ PD=0.985U
* device instance $332 r0 *1 34.03,30.48 nfet
M$332 A0|DOUT3|Q \$328 VGND VGND nfet L=0.15U W=0.65U AS=0.2087P AD=0.169P
+ PS=2.02U PD=1.82U
* device instance $333 r0 *1 8.75,34.915 nfet
M$333 VGND A|CLK|X \$343 VGND nfet L=0.15U W=0.42U AS=0.1092P AD=0.0567P
+ PS=1.36U PD=0.69U
* device instance $334 r0 *1 9.17,34.915 nfet
M$334 \$344 \$343 VGND VGND nfet L=0.15U W=0.42U AS=0.0567P AD=0.1092P PS=0.69U
+ PD=1.36U
* device instance $335 r0 *1 10.445,34.915 nfet
M$335 \$345 D|X$7 VGND VGND nfet L=0.15U W=0.42U AS=0.2205P AD=0.066P PS=1.89U
+ PD=0.745U
* device instance $336 r0 *1 10.92,34.945 nfet
M$336 \$346 \$343 \$345 VGND nfet L=0.15U W=0.36U AS=0.066P AD=0.0594P
+ PS=0.745U PD=0.69U
* device instance $337 r0 *1 11.4,34.945 nfet
M$337 \$346 \$344 \$375 VGND nfet L=0.15U W=0.36U AS=0.1401P AD=0.0594P PS=1.1U
+ PD=0.69U
* device instance $338 r0 *1 12.23,34.915 nfet
M$338 \$374 \$348 \$375 VGND nfet L=0.15U W=0.42U AS=0.1401P AD=0.0441P PS=1.1U
+ PD=0.63U
* device instance $339 r0 *1 12.59,34.915 nfet
M$339 \$374 RESET_B|RST_B VGND VGND nfet L=0.15U W=0.42U AS=0.1346P AD=0.0441P
+ PS=1.15U PD=0.63U
* device instance $340 r0 *1 13.25,34.805 nfet
M$340 \$348 \$346 VGND VGND nfet L=0.15U W=0.64U AS=0.1346P AD=0.0999P PS=1.15U
+ PD=0.985U
* device instance $341 r0 *1 13.745,34.945 nfet
M$341 \$349 \$344 \$348 VGND nfet L=0.15U W=0.36U AS=0.0999P AD=0.0711P
+ PS=0.985U PD=0.755U
* device instance $342 r0 *1 14.29,34.945 nfet
M$342 \$349 \$343 \$376 VGND nfet L=0.15U W=0.36U AS=0.0669P AD=0.0711P
+ PS=0.75U PD=0.755U
* device instance $343 r0 *1 14.77,34.915 nfet
M$343 VGND \$350 \$376 VGND nfet L=0.15U W=0.42U AS=0.0669P AD=0.12495P
+ PS=0.75U PD=1.015U
* device instance $344 r0 *1 15.515,34.915 nfet
M$344 \$377 RESET_B|RST_B VGND VGND nfet L=0.15U W=0.42U AS=0.12495P
+ AD=0.06405P PS=1.015U PD=0.725U
* device instance $345 r0 *1 15.97,34.915 nfet
M$345 \$350 \$349 \$377 VGND nfet L=0.15U W=0.42U AS=0.06405P AD=0.1092P
+ PS=0.725U PD=1.36U
* device instance $346 r0 *1 17.01,34.8 nfet
M$346 A0|DOUT4|Q \$350 VGND VGND nfet L=0.15U W=0.65U AS=0.2087P AD=0.169P
+ PS=2.02U PD=1.82U
* device instance $347 r0 *1 21.17,34.915 nfet
M$347 VGND A|CLK|X \$351 VGND nfet L=0.15U W=0.42U AS=0.1092P AD=0.0567P
+ PS=1.36U PD=0.69U
* device instance $348 r0 *1 21.59,34.915 nfet
M$348 \$352 \$351 VGND VGND nfet L=0.15U W=0.42U AS=0.0567P AD=0.1092P PS=0.69U
+ PD=1.36U
* device instance $349 r0 *1 22.865,34.915 nfet
M$349 \$353 A|D|PH_B1|Q|S VGND VGND nfet L=0.15U W=0.42U AS=0.2205P AD=0.066P
+ PS=1.89U PD=0.745U
* device instance $350 r0 *1 23.34,34.945 nfet
M$350 \$354 \$351 \$353 VGND nfet L=0.15U W=0.36U AS=0.066P AD=0.0594P
+ PS=0.745U PD=0.69U
* device instance $351 r0 *1 23.82,34.945 nfet
M$351 \$354 \$352 \$381 VGND nfet L=0.15U W=0.36U AS=0.1401P AD=0.0594P PS=1.1U
+ PD=0.69U
* device instance $352 r0 *1 24.65,34.915 nfet
M$352 \$380 \$356 \$381 VGND nfet L=0.15U W=0.42U AS=0.1401P AD=0.0441P PS=1.1U
+ PD=0.63U
* device instance $353 r0 *1 25.01,34.915 nfet
M$353 \$380 RESET_B|RST_B VGND VGND nfet L=0.15U W=0.42U AS=0.1346P AD=0.0441P
+ PS=1.15U PD=0.63U
* device instance $354 r0 *1 25.67,34.805 nfet
M$354 \$356 \$354 VGND VGND nfet L=0.15U W=0.64U AS=0.1346P AD=0.0999P PS=1.15U
+ PD=0.985U
* device instance $355 r0 *1 26.165,34.945 nfet
M$355 \$357 \$352 \$356 VGND nfet L=0.15U W=0.36U AS=0.0999P AD=0.0711P
+ PS=0.985U PD=0.755U
* device instance $356 r0 *1 26.71,34.945 nfet
M$356 \$357 \$351 \$379 VGND nfet L=0.15U W=0.36U AS=0.0669P AD=0.0711P
+ PS=0.75U PD=0.755U
* device instance $357 r0 *1 27.19,34.915 nfet
M$357 VGND \$358 \$379 VGND nfet L=0.15U W=0.42U AS=0.0669P AD=0.12495P
+ PS=0.75U PD=1.015U
* device instance $358 r0 *1 27.935,34.915 nfet
M$358 \$378 RESET_B|RST_B VGND VGND nfet L=0.15U W=0.42U AS=0.12495P
+ AD=0.06405P PS=1.015U PD=0.725U
* device instance $359 r0 *1 28.39,34.915 nfet
M$359 \$358 \$357 \$378 VGND nfet L=0.15U W=0.42U AS=0.06405P AD=0.1092P
+ PS=0.725U PD=1.36U
* device instance $360 r0 *1 29.43,34.8 nfet
M$360 B|D|PH_B0|Q|S \$358 VGND VGND nfet L=0.15U W=0.65U AS=0.2087P AD=0.169P
+ PS=2.02U PD=1.82U
* device instance $361 r0 *1 30.83,34.915 nfet
M$361 VGND A|CLK|X \$359 VGND nfet L=0.15U W=0.42U AS=0.1092P AD=0.0567P
+ PS=1.36U PD=0.69U
* device instance $362 r0 *1 31.25,34.915 nfet
M$362 \$360 \$359 VGND VGND nfet L=0.15U W=0.42U AS=0.0567P AD=0.1092P PS=0.69U
+ PD=1.36U
* device instance $363 r0 *1 32.525,34.915 nfet
M$363 \$361 D|X$9 VGND VGND nfet L=0.15U W=0.42U AS=0.2205P AD=0.066P PS=1.89U
+ PD=0.745U
* device instance $364 r0 *1 33,34.945 nfet
M$364 \$362 \$359 \$361 VGND nfet L=0.15U W=0.36U AS=0.066P AD=0.0594P
+ PS=0.745U PD=0.69U
* device instance $365 r0 *1 33.48,34.945 nfet
M$365 \$362 \$360 \$373 VGND nfet L=0.15U W=0.36U AS=0.1401P AD=0.0594P PS=1.1U
+ PD=0.69U
* device instance $366 r0 *1 34.31,34.915 nfet
M$366 \$372 \$364 \$373 VGND nfet L=0.15U W=0.42U AS=0.1401P AD=0.0441P PS=1.1U
+ PD=0.63U
* device instance $367 r0 *1 34.67,34.915 nfet
M$367 \$372 RESET_B|RST_B VGND VGND nfet L=0.15U W=0.42U AS=0.1346P AD=0.0441P
+ PS=1.15U PD=0.63U
* device instance $368 r0 *1 35.33,34.805 nfet
M$368 \$364 \$362 VGND VGND nfet L=0.15U W=0.64U AS=0.1346P AD=0.0999P PS=1.15U
+ PD=0.985U
* device instance $369 r0 *1 35.825,34.945 nfet
M$369 \$365 \$360 \$364 VGND nfet L=0.15U W=0.36U AS=0.0999P AD=0.0711P
+ PS=0.985U PD=0.755U
* device instance $370 r0 *1 36.37,34.945 nfet
M$370 \$365 \$359 \$371 VGND nfet L=0.15U W=0.36U AS=0.0669P AD=0.0711P
+ PS=0.75U PD=0.755U
* device instance $371 r0 *1 36.85,34.915 nfet
M$371 VGND \$366 \$371 VGND nfet L=0.15U W=0.42U AS=0.0669P AD=0.12495P
+ PS=0.75U PD=1.015U
* device instance $372 r0 *1 37.595,34.915 nfet
M$372 \$370 RESET_B|RST_B VGND VGND nfet L=0.15U W=0.42U AS=0.12495P
+ AD=0.06405P PS=1.015U PD=0.725U
* device instance $373 r0 *1 38.05,34.915 nfet
M$373 \$366 \$365 \$370 VGND nfet L=0.15U W=0.42U AS=0.06405P AD=0.1092P
+ PS=0.725U PD=1.36U
* device instance $374 r0 *1 39.09,34.8 nfet
M$374 A0|DOUT0|Q \$366 VGND VGND nfet L=0.15U W=0.65U AS=0.2087P AD=0.169P
+ PS=2.02U PD=1.82U
* device instance $375 r0 *1 15.395,35.92 nfet
M$375 Y A|CLK|X VGND VGND nfet L=0.15U W=0.65U AS=0.169P AD=0.169P PS=1.82U
+ PD=1.82U
* device instance $376 r0 *1 30.83,35.805 nfet
M$376 VGND A|CLK|X \$383 VGND nfet L=0.15U W=0.42U AS=0.1092P AD=0.0567P
+ PS=1.36U PD=0.69U
* device instance $377 r0 *1 31.25,35.805 nfet
M$377 \$384 \$383 VGND VGND nfet L=0.15U W=0.42U AS=0.0567P AD=0.1092P PS=0.69U
+ PD=1.36U
* device instance $378 r0 *1 33,35.775 nfet
M$378 \$386 \$383 \$385 VGND nfet L=0.15U W=0.36U AS=0.066P AD=0.0594P
+ PS=0.745U PD=0.69U
* device instance $379 r0 *1 33.48,35.775 nfet
M$379 \$390 \$384 \$386 VGND nfet L=0.15U W=0.36U AS=0.0594P AD=0.1401P
+ PS=0.69U PD=1.1U
* device instance $380 r0 *1 35.825,35.775 nfet
M$380 \$388 \$384 \$387 VGND nfet L=0.15U W=0.36U AS=0.0999P AD=0.0711P
+ PS=0.985U PD=0.755U
* device instance $381 r0 *1 36.37,35.775 nfet
M$381 \$393 \$383 \$388 VGND nfet L=0.15U W=0.36U AS=0.0711P AD=0.0669P
+ PS=0.755U PD=0.75U
* device instance $382 r0 *1 32.525,35.805 nfet
M$382 \$385 D|X$6 VGND VGND nfet L=0.15U W=0.42U AS=0.2205P AD=0.066P PS=1.89U
+ PD=0.745U
* device instance $383 r0 *1 34.31,35.805 nfet
M$383 \$391 \$387 \$390 VGND nfet L=0.15U W=0.42U AS=0.1401P AD=0.0441P PS=1.1U
+ PD=0.63U
* device instance $384 r0 *1 34.67,35.805 nfet
M$384 VGND RESET_B|RST_B \$391 VGND nfet L=0.15U W=0.42U AS=0.0441P AD=0.1346P
+ PS=0.63U PD=1.15U
* device instance $385 r0 *1 36.85,35.805 nfet
M$385 VGND \$389 \$393 VGND nfet L=0.15U W=0.42U AS=0.0669P AD=0.12495P
+ PS=0.75U PD=1.015U
* device instance $386 r0 *1 37.595,35.805 nfet
M$386 \$392 RESET_B|RST_B VGND VGND nfet L=0.15U W=0.42U AS=0.12495P
+ AD=0.06405P PS=1.015U PD=0.725U
* device instance $387 r0 *1 38.05,35.805 nfet
M$387 \$389 \$388 \$392 VGND nfet L=0.15U W=0.42U AS=0.06405P AD=0.1092P
+ PS=0.725U PD=1.36U
* device instance $388 r0 *1 35.33,35.915 nfet
M$388 \$387 \$386 VGND VGND nfet L=0.15U W=0.64U AS=0.1346P AD=0.0999P PS=1.15U
+ PD=0.985U
* device instance $389 r0 *1 39.09,35.92 nfet
M$389 A0|DOUT1|Q \$389 VGND VGND nfet L=0.15U W=0.65U AS=0.2087P AD=0.169P
+ PS=2.02U PD=1.82U
* device instance $390 r0 *1 12.975,4.8 pfet
M$390 \$24 D|PH_B6|Q|S VPB|VPWR VPB|VPWR pfet L=0.15U W=0.42U AS=0.15835P
+ AD=0.07665P PS=1.395U PD=0.785U
* device instance $391 r0 *1 13.49,4.8 pfet
M$391 \$1 A0|DOUT6|Q \$24 VPB|VPWR pfet L=0.15U W=0.42U AS=0.07665P AD=0.1932P
+ PS=0.785U PD=1.34U
* device instance $392 r0 *1 14.56,4.8 pfet
M$392 \$25 A1|COMP_OUT \$1 VPB|VPWR pfet L=0.15U W=0.42U AS=0.1932P AD=0.0441P
+ PS=1.34U PD=0.63U
* device instance $393 r0 *1 14.92,4.8 pfet
M$393 VPB|VPWR \$2 \$25 VPB|VPWR pfet L=0.15U W=0.42U AS=0.0441P AD=0.0693P
+ PS=0.63U PD=0.75U
* device instance $394 r0 *1 15.4,4.8 pfet
M$394 \$2 D|PH_B6|Q|S VPB|VPWR VPB|VPWR pfet L=0.15U W=0.42U AS=0.0693P
+ AD=0.1176P PS=0.75U PD=1.4U
* device instance $395 r0 *1 12.43,4.705 pfet
M$395 VPB|VPWR \$1 D|X VPB|VPWR pfet L=0.15U W=1U AS=0.26P AD=0.15835P PS=2.52U
+ PD=1.395U
* device instance $396 r0 *1 39.09,4.705 pfet
M$396 D|PH_B6|Q|S \$8 VPB|VPWR VPB|VPWR pfet L=0.15U W=1U AS=0.3012P AD=0.26P
+ PS=2.66U PD=2.52U
* device instance $397 r0 *1 30.83,4.855 pfet
M$397 VPB|VPWR CLK|X \$3 VPB|VPWR pfet L=0.15U W=0.64U AS=0.1664P AD=0.0864P
+ PS=1.8U PD=0.91U
* device instance $398 r0 *1 31.25,4.855 pfet
M$398 \$4 \$3 VPB|VPWR VPB|VPWR pfet L=0.15U W=0.64U AS=0.0864P AD=0.1664P
+ PS=0.91U PD=1.8U
* device instance $399 r0 *1 35.71,4.785 pfet
M$399 \$18 \$6 VPB|VPWR VPB|VPWR pfet L=0.15U W=0.84U AS=0.2184P AD=0.12915P
+ PS=2.2U PD=1.185U
* device instance $400 r0 *1 36.205,4.995 pfet
M$400 \$7 \$3 \$18 VPB|VPWR pfet L=0.15U W=0.42U AS=0.12915P AD=0.0588P
+ PS=1.185U PD=0.7U
* device instance $401 r0 *1 36.635,4.995 pfet
M$401 \$23 \$4 \$7 VPB|VPWR pfet L=0.15U W=0.42U AS=0.0588P AD=0.0567P PS=0.7U
+ PD=0.69U
* device instance $402 r0 *1 37.055,4.995 pfet
M$402 VPB|VPWR \$8 \$23 VPB|VPWR pfet L=0.15U W=0.42U AS=0.0567P AD=0.0819P
+ PS=0.69U PD=0.81U
* device instance $403 r0 *1 37.595,4.995 pfet
M$403 \$8 RESET_B|RST_B VPB|VPWR VPB|VPWR pfet L=0.15U W=0.42U AS=0.0819P
+ AD=0.0567P PS=0.81U PD=0.69U
* device instance $404 r0 *1 38.015,4.995 pfet
M$404 VPB|VPWR \$7 \$8 VPB|VPWR pfet L=0.15U W=0.42U AS=0.0567P AD=0.1134P
+ PS=0.69U PD=1.38U
* device instance $405 r0 *1 32.585,4.995 pfet
M$405 \$5 C|D|PH_B7|Q|S VPB|VPWR VPB|VPWR pfet L=0.15U W=0.42U AS=0.1092P
+ AD=0.0651P PS=1.36U PD=0.73U
* device instance $406 r0 *1 33.045,4.995 pfet
M$406 \$6 \$4 \$5 VPB|VPWR pfet L=0.15U W=0.42U AS=0.0651P AD=0.07245P PS=0.73U
+ PD=0.765U
* device instance $407 r0 *1 33.54,4.995 pfet
M$407 \$21 \$3 \$6 VPB|VPWR pfet L=0.15U W=0.42U AS=0.07245P AD=0.1155P
+ PS=0.765U PD=0.97U
* device instance $408 r0 *1 34.24,4.995 pfet
M$408 VPB|VPWR \$18 \$21 VPB|VPWR pfet L=0.15U W=0.42U AS=0.1155P AD=0.07035P
+ PS=0.97U PD=0.755U
* device instance $409 r0 *1 34.725,4.995 pfet
M$409 \$21 RESET_B|RST_B VPB|VPWR VPB|VPWR pfet L=0.15U W=0.42U AS=0.07035P
+ AD=0.1092P PS=0.755U PD=1.36U
* device instance $410 r0 *1 11.425,5.885 pfet
M$410 \$28 D|X$2 VPB|VPWR VPB|VPWR pfet L=0.15U W=0.42U AS=0.1092P AD=0.0651P
+ PS=1.36U PD=0.73U
* device instance $411 r0 *1 11.885,5.885 pfet
M$411 \$29 \$27 \$28 VPB|VPWR pfet L=0.15U W=0.42U AS=0.0651P AD=0.07245P
+ PS=0.73U PD=0.765U
* device instance $412 r0 *1 12.38,5.885 pfet
M$412 \$30 \$26 \$29 VPB|VPWR pfet L=0.15U W=0.42U AS=0.07245P AD=0.1155P
+ PS=0.765U PD=0.97U
* device instance $413 r0 *1 13.08,5.885 pfet
M$413 VPB|VPWR \$31 \$30 VPB|VPWR pfet L=0.15U W=0.42U AS=0.1155P AD=0.07035P
+ PS=0.97U PD=0.755U
* device instance $414 r0 *1 13.565,5.885 pfet
M$414 \$30 RESET_B|RST_B VPB|VPWR VPB|VPWR pfet L=0.15U W=0.42U AS=0.07035P
+ AD=0.1092P PS=0.755U PD=1.36U
* device instance $415 r0 *1 15.045,5.885 pfet
M$415 \$32 \$26 \$31 VPB|VPWR pfet L=0.15U W=0.42U AS=0.12915P AD=0.0588P
+ PS=1.185U PD=0.7U
* device instance $416 r0 *1 15.475,5.885 pfet
M$416 \$47 \$27 \$32 VPB|VPWR pfet L=0.15U W=0.42U AS=0.0588P AD=0.0567P
+ PS=0.7U PD=0.69U
* device instance $417 r0 *1 15.895,5.885 pfet
M$417 VPB|VPWR \$33 \$47 VPB|VPWR pfet L=0.15U W=0.42U AS=0.0567P AD=0.0819P
+ PS=0.69U PD=0.81U
* device instance $418 r0 *1 16.435,5.885 pfet
M$418 \$33 RESET_B|RST_B VPB|VPWR VPB|VPWR pfet L=0.15U W=0.42U AS=0.0819P
+ AD=0.0567P PS=0.81U PD=0.69U
* device instance $419 r0 *1 16.855,5.885 pfet
M$419 VPB|VPWR \$32 \$33 VPB|VPWR pfet L=0.15U W=0.42U AS=0.0567P AD=0.1134P
+ PS=0.69U PD=1.38U
* device instance $420 r0 *1 14.55,6.095 pfet
M$420 \$31 \$29 VPB|VPWR VPB|VPWR pfet L=0.15U W=0.84U AS=0.2184P AD=0.12915P
+ PS=2.2U PD=1.185U
* device instance $421 r0 *1 17.93,6.175 pfet
M$421 A0|DOUT2|Q \$33 VPB|VPWR VPB|VPWR pfet L=0.15U W=1U AS=0.3012P AD=0.26P
+ PS=2.66U PD=2.52U
* device instance $422 r0 *1 26.775,6.08 pfet
M$422 \$51 C|D|PH_B7|Q|S VPB|VPWR VPB|VPWR pfet L=0.15U W=0.42U AS=0.15835P
+ AD=0.07665P PS=1.395U PD=0.785U
* device instance $423 r0 *1 27.29,6.08 pfet
M$423 \$36 A0|DOUT7|Q \$51 VPB|VPWR pfet L=0.15U W=0.42U AS=0.07665P AD=0.1932P
+ PS=0.785U PD=1.34U
* device instance $424 r0 *1 28.36,6.08 pfet
M$424 \$52 A1|COMP_OUT \$36 VPB|VPWR pfet L=0.15U W=0.42U AS=0.1932P AD=0.0441P
+ PS=1.34U PD=0.63U
* device instance $425 r0 *1 28.72,6.08 pfet
M$425 VPB|VPWR \$38 \$52 VPB|VPWR pfet L=0.15U W=0.42U AS=0.0441P AD=0.0693P
+ PS=0.63U PD=0.75U
* device instance $426 r0 *1 29.2,6.08 pfet
M$426 \$38 C|D|PH_B7|Q|S VPB|VPWR VPB|VPWR pfet L=0.15U W=0.42U AS=0.0693P
+ AD=0.1176P PS=0.75U PD=1.4U
* device instance $427 r0 *1 26.23,6.175 pfet
M$427 VPB|VPWR \$36 D|X$1 VPB|VPWR pfet L=0.15U W=1U AS=0.26P AD=0.15835P
+ PS=2.52U PD=1.395U
* device instance $428 r0 *1 32.585,5.885 pfet
M$428 \$41 D|X$1 VPB|VPWR VPB|VPWR pfet L=0.15U W=0.42U AS=0.1092P AD=0.0651P
+ PS=1.36U PD=0.73U
* device instance $429 r0 *1 33.045,5.885 pfet
M$429 \$42 \$40 \$41 VPB|VPWR pfet L=0.15U W=0.42U AS=0.0651P AD=0.07245P
+ PS=0.73U PD=0.765U
* device instance $430 r0 *1 33.54,5.885 pfet
M$430 \$43 \$39 \$42 VPB|VPWR pfet L=0.15U W=0.42U AS=0.07245P AD=0.1155P
+ PS=0.765U PD=0.97U
* device instance $431 r0 *1 34.24,5.885 pfet
M$431 VPB|VPWR \$44 \$43 VPB|VPWR pfet L=0.15U W=0.42U AS=0.1155P AD=0.07035P
+ PS=0.97U PD=0.755U
* device instance $432 r0 *1 34.725,5.885 pfet
M$432 \$43 RESET_B|RST_B VPB|VPWR VPB|VPWR pfet L=0.15U W=0.42U AS=0.07035P
+ AD=0.1092P PS=0.755U PD=1.36U
* device instance $433 r0 *1 36.205,5.885 pfet
M$433 \$45 \$39 \$44 VPB|VPWR pfet L=0.15U W=0.42U AS=0.12915P AD=0.0588P
+ PS=1.185U PD=0.7U
* device instance $434 r0 *1 36.635,5.885 pfet
M$434 \$48 \$40 \$45 VPB|VPWR pfet L=0.15U W=0.42U AS=0.0588P AD=0.0567P
+ PS=0.7U PD=0.69U
* device instance $435 r0 *1 37.055,5.885 pfet
M$435 VPB|VPWR \$46 \$48 VPB|VPWR pfet L=0.15U W=0.42U AS=0.0567P AD=0.0819P
+ PS=0.69U PD=0.81U
* device instance $436 r0 *1 37.595,5.885 pfet
M$436 \$46 RESET_B|RST_B VPB|VPWR VPB|VPWR pfet L=0.15U W=0.42U AS=0.0819P
+ AD=0.0567P PS=0.81U PD=0.69U
* device instance $437 r0 *1 38.015,5.885 pfet
M$437 VPB|VPWR \$45 \$46 VPB|VPWR pfet L=0.15U W=0.42U AS=0.0567P AD=0.1134P
+ PS=0.69U PD=1.38U
* device instance $438 r0 *1 35.71,6.095 pfet
M$438 \$44 \$42 VPB|VPWR VPB|VPWR pfet L=0.15U W=0.84U AS=0.2184P AD=0.12915P
+ PS=2.2U PD=1.185U
* device instance $439 r0 *1 39.09,6.175 pfet
M$439 A0|DOUT7|Q \$46 VPB|VPWR VPB|VPWR pfet L=0.15U W=1U AS=0.3012P AD=0.26P
+ PS=2.66U PD=2.52U
* device instance $440 r0 *1 9.67,6.025 pfet
M$440 VPB|VPWR CLK|X \$26 VPB|VPWR pfet L=0.15U W=0.64U AS=0.1664P AD=0.0864P
+ PS=1.8U PD=0.91U
* device instance $441 r0 *1 10.09,6.025 pfet
M$441 \$27 \$26 VPB|VPWR VPB|VPWR pfet L=0.15U W=0.64U AS=0.0864P AD=0.1664P
+ PS=0.91U PD=1.8U
* device instance $442 r0 *1 12.975,10.24 pfet
M$442 \$84 D|PH_B2|Q|S VPB|VPWR VPB|VPWR pfet L=0.15U W=0.42U AS=0.15835P
+ AD=0.07665P PS=1.395U PD=0.785U
* device instance $443 r0 *1 13.49,10.24 pfet
M$443 \$65 A0|DOUT2|Q \$84 VPB|VPWR pfet L=0.15U W=0.42U AS=0.07665P AD=0.1932P
+ PS=0.785U PD=1.34U
* device instance $444 r0 *1 14.56,10.24 pfet
M$444 \$85 A1|COMP_OUT \$65 VPB|VPWR pfet L=0.15U W=0.42U AS=0.1932P AD=0.0441P
+ PS=1.34U PD=0.63U
* device instance $445 r0 *1 14.92,10.24 pfet
M$445 VPB|VPWR \$66 \$85 VPB|VPWR pfet L=0.15U W=0.42U AS=0.0441P AD=0.0693P
+ PS=0.63U PD=0.75U
* device instance $446 r0 *1 15.4,10.24 pfet
M$446 \$66 D|PH_B2|Q|S VPB|VPWR VPB|VPWR pfet L=0.15U W=0.42U AS=0.0693P
+ AD=0.1176P PS=0.75U PD=1.4U
* device instance $447 r0 *1 12.43,10.145 pfet
M$447 VPB|VPWR \$65 D|X$2 VPB|VPWR pfet L=0.15U W=1U AS=0.26P AD=0.15835P
+ PS=2.52U PD=1.395U
* device instance $448 r0 *1 27.15,10.295 pfet
M$448 VPB|VPWR CLK|X \$68 VPB|VPWR pfet L=0.15U W=0.64U AS=0.1664P AD=0.0864P
+ PS=1.8U PD=0.91U
* device instance $449 r0 *1 27.57,10.295 pfet
M$449 \$69 \$68 VPB|VPWR VPB|VPWR pfet L=0.15U W=0.64U AS=0.0864P AD=0.1664P
+ PS=0.91U PD=1.8U
* device instance $450 r0 *1 28.905,10.435 pfet
M$450 \$71 D|X$3 VPB|VPWR VPB|VPWR pfet L=0.15U W=0.42U AS=0.1092P AD=0.0651P
+ PS=1.36U PD=0.73U
* device instance $451 r0 *1 29.365,10.435 pfet
M$451 \$72 \$69 \$71 VPB|VPWR pfet L=0.15U W=0.42U AS=0.0651P AD=0.07245P
+ PS=0.73U PD=0.765U
* device instance $452 r0 *1 29.86,10.435 pfet
M$452 \$83 \$68 \$72 VPB|VPWR pfet L=0.15U W=0.42U AS=0.07245P AD=0.1155P
+ PS=0.765U PD=0.97U
* device instance $453 r0 *1 30.56,10.435 pfet
M$453 VPB|VPWR \$73 \$83 VPB|VPWR pfet L=0.15U W=0.42U AS=0.1155P AD=0.07035P
+ PS=0.97U PD=0.755U
* device instance $454 r0 *1 31.045,10.435 pfet
M$454 \$83 RESET_B|RST_B VPB|VPWR VPB|VPWR pfet L=0.15U W=0.42U AS=0.07035P
+ AD=0.1092P PS=0.755U PD=1.36U
* device instance $455 r0 *1 30.83,6.025 pfet
M$455 VPB|VPWR CLK|X \$39 VPB|VPWR pfet L=0.15U W=0.64U AS=0.1664P AD=0.0864P
+ PS=1.8U PD=0.91U
* device instance $456 r0 *1 31.25,6.025 pfet
M$456 \$40 \$39 VPB|VPWR VPB|VPWR pfet L=0.15U W=0.64U AS=0.0864P AD=0.1664P
+ PS=0.91U PD=1.8U
* device instance $457 r0 *1 32.03,10.225 pfet
M$457 \$73 \$72 VPB|VPWR VPB|VPWR pfet L=0.15U W=0.84U AS=0.2184P AD=0.12915P
+ PS=2.2U PD=1.185U
* device instance $458 r0 *1 32.525,10.435 pfet
M$458 \$74 \$68 \$73 VPB|VPWR pfet L=0.15U W=0.42U AS=0.12915P AD=0.0588P
+ PS=1.185U PD=0.7U
* device instance $459 r0 *1 32.955,10.435 pfet
M$459 \$86 \$69 \$74 VPB|VPWR pfet L=0.15U W=0.42U AS=0.0588P AD=0.0567P
+ PS=0.7U PD=0.69U
* device instance $460 r0 *1 33.375,10.435 pfet
M$460 VPB|VPWR \$75 \$86 VPB|VPWR pfet L=0.15U W=0.42U AS=0.0567P AD=0.0819P
+ PS=0.69U PD=0.81U
* device instance $461 r0 *1 33.915,10.435 pfet
M$461 \$75 RESET_B|RST_B VPB|VPWR VPB|VPWR pfet L=0.15U W=0.42U AS=0.0819P
+ AD=0.0567P PS=0.81U PD=0.69U
* device instance $462 r0 *1 34.335,10.435 pfet
M$462 VPB|VPWR \$74 \$75 VPB|VPWR pfet L=0.15U W=0.42U AS=0.0567P AD=0.1134P
+ PS=0.69U PD=1.38U
* device instance $463 r0 *1 35.41,10.145 pfet
M$463 A0|DOUT9|Q \$75 VPB|VPWR VPB|VPWR pfet L=0.15U W=1U AS=0.3012P AD=0.26P
+ PS=2.66U PD=2.52U
* device instance $464 r0 *1 10.13,11.465 pfet
M$464 VPB|VPWR CLK|X \$87 VPB|VPWR pfet L=0.15U W=0.64U AS=0.1664P AD=0.0864P
+ PS=1.8U PD=0.91U
* device instance $465 r0 *1 10.55,11.465 pfet
M$465 \$88 \$87 VPB|VPWR VPB|VPWR pfet L=0.15U W=0.64U AS=0.0864P AD=0.1664P
+ PS=0.91U PD=1.8U
* device instance $466 r0 *1 11.885,11.325 pfet
M$466 \$89 D|X VPB|VPWR VPB|VPWR pfet L=0.15U W=0.42U AS=0.1092P AD=0.0651P
+ PS=1.36U PD=0.73U
* device instance $467 r0 *1 12.345,11.325 pfet
M$467 \$90 \$88 \$89 VPB|VPWR pfet L=0.15U W=0.42U AS=0.0651P AD=0.07245P
+ PS=0.73U PD=0.765U
* device instance $468 r0 *1 12.84,11.325 pfet
M$468 \$91 \$87 \$90 VPB|VPWR pfet L=0.15U W=0.42U AS=0.07245P AD=0.1155P
+ PS=0.765U PD=0.97U
* device instance $469 r0 *1 13.54,11.325 pfet
M$469 VPB|VPWR \$92 \$91 VPB|VPWR pfet L=0.15U W=0.42U AS=0.1155P AD=0.07035P
+ PS=0.97U PD=0.755U
* device instance $470 r0 *1 14.025,11.325 pfet
M$470 \$91 RESET_B|RST_B VPB|VPWR VPB|VPWR pfet L=0.15U W=0.42U AS=0.07035P
+ AD=0.1092P PS=0.755U PD=1.36U
* device instance $471 r0 *1 15.505,11.325 pfet
M$471 \$93 \$87 \$92 VPB|VPWR pfet L=0.15U W=0.42U AS=0.12915P AD=0.0588P
+ PS=1.185U PD=0.7U
* device instance $472 r0 *1 15.935,11.325 pfet
M$472 \$102 \$88 \$93 VPB|VPWR pfet L=0.15U W=0.42U AS=0.0588P AD=0.0567P
+ PS=0.7U PD=0.69U
* device instance $473 r0 *1 16.355,11.325 pfet
M$473 VPB|VPWR \$94 \$102 VPB|VPWR pfet L=0.15U W=0.42U AS=0.0567P AD=0.0819P
+ PS=0.69U PD=0.81U
* device instance $474 r0 *1 16.895,11.325 pfet
M$474 \$94 RESET_B|RST_B VPB|VPWR VPB|VPWR pfet L=0.15U W=0.42U AS=0.0819P
+ AD=0.0567P PS=0.81U PD=0.69U
* device instance $475 r0 *1 17.315,11.325 pfet
M$475 VPB|VPWR \$93 \$94 VPB|VPWR pfet L=0.15U W=0.42U AS=0.0567P AD=0.1134P
+ PS=0.69U PD=1.38U
* device instance $476 r0 *1 15.01,11.535 pfet
M$476 \$92 \$90 VPB|VPWR VPB|VPWR pfet L=0.15U W=0.84U AS=0.2184P AD=0.12915P
+ PS=2.2U PD=1.185U
* device instance $477 r0 *1 18.39,11.615 pfet
M$477 A0|DOUT6|Q \$94 VPB|VPWR VPB|VPWR pfet L=0.15U W=1U AS=0.3012P AD=0.26P
+ PS=2.66U PD=2.52U
* device instance $478 r0 *1 26.775,11.52 pfet
M$478 \$104 B|D|PH_B8|Q|S VPB|VPWR VPB|VPWR pfet L=0.15U W=0.42U AS=0.15835P
+ AD=0.07665P PS=1.395U PD=0.785U
* device instance $479 r0 *1 27.29,11.52 pfet
M$479 \$97 A0|DOUT8|Q \$104 VPB|VPWR pfet L=0.15U W=0.42U AS=0.07665P
+ AD=0.1932P PS=0.785U PD=1.34U
* device instance $480 r0 *1 28.36,11.52 pfet
M$480 \$105 A1|COMP_OUT \$97 VPB|VPWR pfet L=0.15U W=0.42U AS=0.1932P
+ AD=0.0441P PS=1.34U PD=0.63U
* device instance $481 r0 *1 28.72,11.52 pfet
M$481 VPB|VPWR \$98 \$105 VPB|VPWR pfet L=0.15U W=0.42U AS=0.0441P AD=0.0693P
+ PS=0.63U PD=0.75U
* device instance $482 r0 *1 29.2,11.52 pfet
M$482 \$98 B|D|PH_B8|Q|S VPB|VPWR VPB|VPWR pfet L=0.15U W=0.42U AS=0.0693P
+ AD=0.1176P PS=0.75U PD=1.4U
* device instance $483 r0 *1 26.23,11.615 pfet
M$483 VPB|VPWR \$97 D|X$4 VPB|VPWR pfet L=0.15U W=1U AS=0.26P AD=0.15835P
+ PS=2.52U PD=1.395U
* device instance $484 r0 *1 31.375,11.52 pfet
M$484 \$106 A|D|PH_B9|Q|S VPB|VPWR VPB|VPWR pfet L=0.15U W=0.42U AS=0.15835P
+ AD=0.07665P PS=1.395U PD=0.785U
* device instance $485 r0 *1 31.89,11.52 pfet
M$485 \$100 A0|DOUT9|Q \$106 VPB|VPWR pfet L=0.15U W=0.42U AS=0.07665P
+ AD=0.1932P PS=0.785U PD=1.34U
* device instance $486 r0 *1 32.96,11.52 pfet
M$486 \$103 A1|COMP_OUT \$100 VPB|VPWR pfet L=0.15U W=0.42U AS=0.1932P
+ AD=0.0441P PS=1.34U PD=0.63U
* device instance $487 r0 *1 33.32,11.52 pfet
M$487 VPB|VPWR \$101 \$103 VPB|VPWR pfet L=0.15U W=0.42U AS=0.0441P AD=0.0693P
+ PS=0.63U PD=0.75U
* device instance $488 r0 *1 33.8,11.52 pfet
M$488 \$101 A|D|PH_B9|Q|S VPB|VPWR VPB|VPWR pfet L=0.15U W=0.42U AS=0.0693P
+ AD=0.1176P PS=0.75U PD=1.4U
* device instance $489 r0 *1 30.83,11.615 pfet
M$489 VPB|VPWR \$100 D|X$3 VPB|VPWR pfet L=0.15U W=1U AS=0.26P AD=0.15835P
+ PS=2.52U PD=1.395U
* device instance $490 r0 *1 7.37,15.735 pfet
M$490 VPB|VPWR CLK|X \$116 VPB|VPWR pfet L=0.15U W=0.64U AS=0.1664P AD=0.0864P
+ PS=1.8U PD=0.91U
* device instance $491 r0 *1 7.79,15.735 pfet
M$491 \$117 \$116 VPB|VPWR VPB|VPWR pfet L=0.15U W=0.64U AS=0.0864P AD=0.1664P
+ PS=0.91U PD=1.8U
* device instance $492 r0 *1 9.125,15.875 pfet
M$492 \$118 D|X$5 VPB|VPWR VPB|VPWR pfet L=0.15U W=0.42U AS=0.1092P AD=0.0651P
+ PS=1.36U PD=0.73U
* device instance $493 r0 *1 9.585,15.875 pfet
M$493 \$119 \$117 \$118 VPB|VPWR pfet L=0.15U W=0.42U AS=0.0651P AD=0.07245P
+ PS=0.73U PD=0.765U
* device instance $494 r0 *1 10.08,15.875 pfet
M$494 \$143 \$116 \$119 VPB|VPWR pfet L=0.15U W=0.42U AS=0.07245P AD=0.1155P
+ PS=0.765U PD=0.97U
* device instance $495 r0 *1 10.78,15.875 pfet
M$495 VPB|VPWR \$120 \$143 VPB|VPWR pfet L=0.15U W=0.42U AS=0.1155P AD=0.07035P
+ PS=0.97U PD=0.755U
* device instance $496 r0 *1 11.265,15.875 pfet
M$496 \$143 RESET_B|RST_B VPB|VPWR VPB|VPWR pfet L=0.15U W=0.42U AS=0.07035P
+ AD=0.1092P PS=0.755U PD=1.36U
* device instance $497 r0 *1 12.25,15.665 pfet
M$497 \$120 \$119 VPB|VPWR VPB|VPWR pfet L=0.15U W=0.84U AS=0.2184P AD=0.12915P
+ PS=2.2U PD=1.185U
* device instance $498 r0 *1 12.745,15.875 pfet
M$498 \$121 \$116 \$120 VPB|VPWR pfet L=0.15U W=0.42U AS=0.12915P AD=0.0588P
+ PS=1.185U PD=0.7U
* device instance $499 r0 *1 13.175,15.875 pfet
M$499 \$146 \$117 \$121 VPB|VPWR pfet L=0.15U W=0.42U AS=0.0588P AD=0.0567P
+ PS=0.7U PD=0.69U
* device instance $500 r0 *1 13.595,15.875 pfet
M$500 VPB|VPWR \$122 \$146 VPB|VPWR pfet L=0.15U W=0.42U AS=0.0567P AD=0.0819P
+ PS=0.69U PD=0.81U
* device instance $501 r0 *1 14.135,15.875 pfet
M$501 \$122 RESET_B|RST_B VPB|VPWR VPB|VPWR pfet L=0.15U W=0.42U AS=0.0819P
+ AD=0.0567P PS=0.81U PD=0.69U
* device instance $502 r0 *1 14.555,15.875 pfet
M$502 VPB|VPWR \$121 \$122 VPB|VPWR pfet L=0.15U W=0.42U AS=0.0567P AD=0.1134P
+ PS=0.69U PD=1.38U
* device instance $503 r0 *1 15.63,15.585 pfet
M$503 A0|DOUT5|Q \$122 VPB|VPWR VPB|VPWR pfet L=0.15U W=1U AS=0.3012P AD=0.26P
+ PS=2.66U PD=2.52U
* device instance $504 r0 *1 24.39,15.585 pfet
M$504 VPB|VPWR A|X \$124 VPB|VPWR pfet L=0.15U W=1U AS=0.26P AD=0.135P PS=2.52U
+ PD=1.27U
* device instance $505 r0 *1 24.81,15.585 pfet
M$505 CLK|X \$124 VPB|VPWR VPB|VPWR pfet L=0.15U W=1U AS=0.135P AD=0.135P
+ PS=1.27U PD=1.27U
* device instance $506 r0 *1 25.23,15.585 pfet
M$506 VPB|VPWR \$124 CLK|X VPB|VPWR pfet L=0.15U W=1U AS=0.135P AD=0.135P
+ PS=1.27U PD=1.27U
* device instance $507 r0 *1 25.65,15.585 pfet
M$507 CLK|X \$124 VPB|VPWR VPB|VPWR pfet L=0.15U W=1U AS=0.135P AD=0.135P
+ PS=1.27U PD=1.27U
* device instance $508 r0 *1 26.07,15.585 pfet
M$508 VPB|VPWR \$124 CLK|X VPB|VPWR pfet L=0.15U W=1U AS=0.135P AD=0.26P
+ PS=1.27U PD=2.52U
* device instance $509 r0 *1 29.45,15.735 pfet
M$509 VPB|VPWR CLK|X \$125 VPB|VPWR pfet L=0.15U W=0.64U AS=0.1664P AD=0.0864P
+ PS=1.8U PD=0.91U
* device instance $510 r0 *1 29.87,15.735 pfet
M$510 \$126 \$125 VPB|VPWR VPB|VPWR pfet L=0.15U W=0.64U AS=0.0864P AD=0.1664P
+ PS=0.91U PD=1.8U
* device instance $511 r0 *1 31.205,15.875 pfet
M$511 \$128 D|PH_SAMPLE|Y VPB|VPWR VPB|VPWR pfet L=0.15U W=0.42U AS=0.1092P
+ AD=0.0651P PS=1.36U PD=0.73U
* device instance $512 r0 *1 31.665,15.875 pfet
M$512 \$129 \$126 \$128 VPB|VPWR pfet L=0.15U W=0.42U AS=0.0651P AD=0.07245P
+ PS=0.73U PD=0.765U
* device instance $513 r0 *1 32.16,15.875 pfet
M$513 \$144 \$125 \$129 VPB|VPWR pfet L=0.15U W=0.42U AS=0.07245P AD=0.1155P
+ PS=0.765U PD=0.97U
* device instance $514 r0 *1 32.86,15.875 pfet
M$514 VPB|VPWR \$130 \$144 VPB|VPWR pfet L=0.15U W=0.42U AS=0.1155P AD=0.07035P
+ PS=0.97U PD=0.755U
* device instance $515 r0 *1 33.345,15.875 pfet
M$515 \$144 RESET_B|RST_B VPB|VPWR VPB|VPWR pfet L=0.15U W=0.42U AS=0.07035P
+ AD=0.1092P PS=0.755U PD=1.36U
* device instance $516 r0 *1 34.33,15.665 pfet
M$516 \$130 \$129 VPB|VPWR VPB|VPWR pfet L=0.15U W=0.84U AS=0.2184P AD=0.12915P
+ PS=2.2U PD=1.185U
* device instance $517 r0 *1 34.825,15.875 pfet
M$517 \$131 \$125 \$130 VPB|VPWR pfet L=0.15U W=0.42U AS=0.12915P AD=0.0588P
+ PS=1.185U PD=0.7U
* device instance $518 r0 *1 35.255,15.875 pfet
M$518 \$145 \$126 \$131 VPB|VPWR pfet L=0.15U W=0.42U AS=0.0588P AD=0.0567P
+ PS=0.7U PD=0.69U
* device instance $519 r0 *1 35.675,15.875 pfet
M$519 VPB|VPWR \$132 \$145 VPB|VPWR pfet L=0.15U W=0.42U AS=0.0567P AD=0.0819P
+ PS=0.69U PD=0.81U
* device instance $520 r0 *1 36.215,15.875 pfet
M$520 \$132 RESET_B|RST_B VPB|VPWR VPB|VPWR pfet L=0.15U W=0.42U AS=0.0819P
+ AD=0.0567P PS=0.81U PD=0.69U
* device instance $521 r0 *1 36.635,15.875 pfet
M$521 VPB|VPWR \$131 \$132 VPB|VPWR pfet L=0.15U W=0.42U AS=0.0567P AD=0.1134P
+ PS=0.69U PD=1.38U
* device instance $522 r0 *1 37.71,15.585 pfet
M$522 A|D|PH_B9|Q|S \$132 VPB|VPWR VPB|VPWR pfet L=0.15U W=1U AS=0.3012P
+ AD=0.26P PS=2.66U PD=2.52U
* device instance $523 r0 *1 12.515,16.96 pfet
M$523 \$168 A|D|PH_B5|Q|S VPB|VPWR VPB|VPWR pfet L=0.15U W=0.42U AS=0.15835P
+ AD=0.07665P PS=1.395U PD=0.785U
* device instance $524 r0 *1 13.03,16.96 pfet
M$524 \$148 A0|DOUT5|Q \$168 VPB|VPWR pfet L=0.15U W=0.42U AS=0.07665P
+ AD=0.1932P PS=0.785U PD=1.34U
* device instance $525 r0 *1 14.1,16.96 pfet
M$525 \$169 A1|COMP_OUT \$148 VPB|VPWR pfet L=0.15U W=0.42U AS=0.1932P
+ AD=0.0441P PS=1.34U PD=0.63U
* device instance $526 r0 *1 14.46,16.96 pfet
M$526 VPB|VPWR \$149 \$169 VPB|VPWR pfet L=0.15U W=0.42U AS=0.0441P AD=0.0693P
+ PS=0.63U PD=0.75U
* device instance $527 r0 *1 14.94,16.96 pfet
M$527 \$149 A|D|PH_B5|Q|S VPB|VPWR VPB|VPWR pfet L=0.15U W=0.42U AS=0.0693P
+ AD=0.1176P PS=0.75U PD=1.4U
* device instance $528 r0 *1 11.97,17.055 pfet
M$528 VPB|VPWR \$148 D|X$5 VPB|VPWR pfet L=0.15U W=1U AS=0.26P AD=0.15835P
+ PS=2.52U PD=1.395U
* device instance $529 r0 *1 21.17,16.905 pfet
M$529 VPB|VPWR CLK|X \$150 VPB|VPWR pfet L=0.15U W=0.64U AS=0.1664P AD=0.0864P
+ PS=1.8U PD=0.91U
* device instance $530 r0 *1 21.59,16.905 pfet
M$530 \$151 \$150 VPB|VPWR VPB|VPWR pfet L=0.15U W=0.64U AS=0.0864P AD=0.1664P
+ PS=0.91U PD=1.8U
* device instance $531 r0 *1 22.925,16.765 pfet
M$531 \$152 D|X$4 VPB|VPWR VPB|VPWR pfet L=0.15U W=0.42U AS=0.1092P AD=0.0651P
+ PS=1.36U PD=0.73U
* device instance $532 r0 *1 23.385,16.765 pfet
M$532 \$153 \$151 \$152 VPB|VPWR pfet L=0.15U W=0.42U AS=0.0651P AD=0.07245P
+ PS=0.73U PD=0.765U
* device instance $533 r0 *1 23.88,16.765 pfet
M$533 \$154 \$150 \$153 VPB|VPWR pfet L=0.15U W=0.42U AS=0.07245P AD=0.1155P
+ PS=0.765U PD=0.97U
* device instance $534 r0 *1 24.58,16.765 pfet
M$534 VPB|VPWR \$155 \$154 VPB|VPWR pfet L=0.15U W=0.42U AS=0.1155P AD=0.07035P
+ PS=0.97U PD=0.755U
* device instance $535 r0 *1 25.065,16.765 pfet
M$535 \$154 RESET_B|RST_B VPB|VPWR VPB|VPWR pfet L=0.15U W=0.42U AS=0.07035P
+ AD=0.1092P PS=0.755U PD=1.36U
* device instance $536 r0 *1 26.545,16.765 pfet
M$536 \$156 \$150 \$155 VPB|VPWR pfet L=0.15U W=0.42U AS=0.12915P AD=0.0588P
+ PS=1.185U PD=0.7U
* device instance $537 r0 *1 26.975,16.765 pfet
M$537 \$167 \$151 \$156 VPB|VPWR pfet L=0.15U W=0.42U AS=0.0588P AD=0.0567P
+ PS=0.7U PD=0.69U
* device instance $538 r0 *1 27.395,16.765 pfet
M$538 VPB|VPWR \$157 \$167 VPB|VPWR pfet L=0.15U W=0.42U AS=0.0567P AD=0.0819P
+ PS=0.69U PD=0.81U
* device instance $539 r0 *1 27.935,16.765 pfet
M$539 \$157 RESET_B|RST_B VPB|VPWR VPB|VPWR pfet L=0.15U W=0.42U AS=0.0819P
+ AD=0.0567P PS=0.81U PD=0.69U
* device instance $540 r0 *1 28.355,16.765 pfet
M$540 VPB|VPWR \$156 \$157 VPB|VPWR pfet L=0.15U W=0.42U AS=0.0567P AD=0.1134P
+ PS=0.69U PD=1.38U
* device instance $541 r0 *1 26.05,16.975 pfet
M$541 \$155 \$153 VPB|VPWR VPB|VPWR pfet L=0.15U W=0.84U AS=0.2184P AD=0.12915P
+ PS=2.2U PD=1.185U
* device instance $542 r0 *1 29.43,17.055 pfet
M$542 A0|DOUT8|Q \$157 VPB|VPWR VPB|VPWR pfet L=0.15U W=1U AS=0.3012P AD=0.26P
+ PS=2.66U PD=2.52U
* device instance $543 r0 *1 30.83,16.905 pfet
M$543 VPB|VPWR CLK|X \$158 VPB|VPWR pfet L=0.15U W=0.64U AS=0.1664P AD=0.0864P
+ PS=1.8U PD=0.91U
* device instance $544 r0 *1 31.25,16.905 pfet
M$544 \$159 \$158 VPB|VPWR VPB|VPWR pfet L=0.15U W=0.64U AS=0.0864P AD=0.1664P
+ PS=0.91U PD=1.8U
* device instance $545 r0 *1 32.585,16.765 pfet
M$545 \$160 A|D|PH_B9|Q|S VPB|VPWR VPB|VPWR pfet L=0.15U W=0.42U AS=0.1092P
+ AD=0.0651P PS=1.36U PD=0.73U
* device instance $546 r0 *1 33.045,16.765 pfet
M$546 \$161 \$159 \$160 VPB|VPWR pfet L=0.15U W=0.42U AS=0.0651P AD=0.07245P
+ PS=0.73U PD=0.765U
* device instance $547 r0 *1 33.54,16.765 pfet
M$547 \$162 \$158 \$161 VPB|VPWR pfet L=0.15U W=0.42U AS=0.07245P AD=0.1155P
+ PS=0.765U PD=0.97U
* device instance $548 r0 *1 34.24,16.765 pfet
M$548 VPB|VPWR \$163 \$162 VPB|VPWR pfet L=0.15U W=0.42U AS=0.1155P AD=0.07035P
+ PS=0.97U PD=0.755U
* device instance $549 r0 *1 34.725,16.765 pfet
M$549 \$162 RESET_B|RST_B VPB|VPWR VPB|VPWR pfet L=0.15U W=0.42U AS=0.07035P
+ AD=0.1092P PS=0.755U PD=1.36U
* device instance $550 r0 *1 36.205,16.765 pfet
M$550 \$164 \$158 \$163 VPB|VPWR pfet L=0.15U W=0.42U AS=0.12915P AD=0.0588P
+ PS=1.185U PD=0.7U
* device instance $551 r0 *1 36.635,16.765 pfet
M$551 \$166 \$159 \$164 VPB|VPWR pfet L=0.15U W=0.42U AS=0.0588P AD=0.0567P
+ PS=0.7U PD=0.69U
* device instance $552 r0 *1 37.055,16.765 pfet
M$552 VPB|VPWR \$165 \$166 VPB|VPWR pfet L=0.15U W=0.42U AS=0.0567P AD=0.0819P
+ PS=0.69U PD=0.81U
* device instance $553 r0 *1 37.595,16.765 pfet
M$553 \$165 RESET_B|RST_B VPB|VPWR VPB|VPWR pfet L=0.15U W=0.42U AS=0.0819P
+ AD=0.0567P PS=0.81U PD=0.69U
* device instance $554 r0 *1 38.015,16.765 pfet
M$554 VPB|VPWR \$164 \$165 VPB|VPWR pfet L=0.15U W=0.42U AS=0.0567P AD=0.1134P
+ PS=0.69U PD=1.38U
* device instance $555 r0 *1 35.71,16.975 pfet
M$555 \$163 \$161 VPB|VPWR VPB|VPWR pfet L=0.15U W=0.84U AS=0.2184P AD=0.12915P
+ PS=2.2U PD=1.185U
* device instance $556 r0 *1 39.09,17.055 pfet
M$556 B|D|PH_B8|Q|S \$165 VPB|VPWR VPB|VPWR pfet L=0.15U W=1U AS=0.3012P
+ AD=0.26P PS=2.66U PD=2.52U
* device instance $557 r0 *1 7.37,21.175 pfet
M$557 VPB|VPWR A|CLK|X \$180 VPB|VPWR pfet L=0.15U W=0.64U AS=0.1664P
+ AD=0.0864P PS=1.8U PD=0.91U
* device instance $558 r0 *1 7.79,21.175 pfet
M$558 \$181 \$180 VPB|VPWR VPB|VPWR pfet L=0.15U W=0.64U AS=0.0864P AD=0.1664P
+ PS=0.91U PD=1.8U
* device instance $559 r0 *1 9.125,21.315 pfet
M$559 \$182 D|PH_B6|Q|S VPB|VPWR VPB|VPWR pfet L=0.15U W=0.42U AS=0.1092P
+ AD=0.0651P PS=1.36U PD=0.73U
* device instance $560 r0 *1 9.585,21.315 pfet
M$560 \$183 \$181 \$182 VPB|VPWR pfet L=0.15U W=0.42U AS=0.0651P AD=0.07245P
+ PS=0.73U PD=0.765U
* device instance $561 r0 *1 10.08,21.315 pfet
M$561 \$205 \$180 \$183 VPB|VPWR pfet L=0.15U W=0.42U AS=0.07245P AD=0.1155P
+ PS=0.765U PD=0.97U
* device instance $562 r0 *1 10.78,21.315 pfet
M$562 VPB|VPWR \$184 \$205 VPB|VPWR pfet L=0.15U W=0.42U AS=0.1155P AD=0.07035P
+ PS=0.97U PD=0.755U
* device instance $563 r0 *1 11.265,21.315 pfet
M$563 \$205 RESET_B|RST_B VPB|VPWR VPB|VPWR pfet L=0.15U W=0.42U AS=0.07035P
+ AD=0.1092P PS=0.755U PD=1.36U
* device instance $564 r0 *1 11.425,22.205 pfet
M$564 \$211 C|D|PH_B3|Q|S VPB|VPWR VPB|VPWR pfet L=0.15U W=0.42U AS=0.1092P
+ AD=0.0651P PS=1.36U PD=0.73U
* device instance $565 r0 *1 11.885,22.205 pfet
M$565 \$212 \$210 \$211 VPB|VPWR pfet L=0.15U W=0.42U AS=0.0651P AD=0.07245P
+ PS=0.73U PD=0.765U
* device instance $566 r0 *1 12.38,22.205 pfet
M$566 \$213 \$209 \$212 VPB|VPWR pfet L=0.15U W=0.42U AS=0.07245P AD=0.1155P
+ PS=0.765U PD=0.97U
* device instance $567 r0 *1 13.08,22.205 pfet
M$567 VPB|VPWR \$214 \$213 VPB|VPWR pfet L=0.15U W=0.42U AS=0.1155P AD=0.07035P
+ PS=0.97U PD=0.755U
* device instance $568 r0 *1 13.565,22.205 pfet
M$568 \$213 RESET_B|RST_B VPB|VPWR VPB|VPWR pfet L=0.15U W=0.42U AS=0.07035P
+ AD=0.1092P PS=0.755U PD=1.36U
* device instance $569 r0 *1 12.25,21.105 pfet
M$569 \$184 \$183 VPB|VPWR VPB|VPWR pfet L=0.15U W=0.84U AS=0.2184P AD=0.12915P
+ PS=2.2U PD=1.185U
* device instance $570 r0 *1 12.745,21.315 pfet
M$570 \$185 \$180 \$184 VPB|VPWR pfet L=0.15U W=0.42U AS=0.12915P AD=0.0588P
+ PS=1.185U PD=0.7U
* device instance $571 r0 *1 13.175,21.315 pfet
M$571 \$207 \$181 \$185 VPB|VPWR pfet L=0.15U W=0.42U AS=0.0588P AD=0.0567P
+ PS=0.7U PD=0.69U
* device instance $572 r0 *1 13.595,21.315 pfet
M$572 VPB|VPWR \$186 \$207 VPB|VPWR pfet L=0.15U W=0.42U AS=0.0567P AD=0.0819P
+ PS=0.69U PD=0.81U
* device instance $573 r0 *1 14.135,21.315 pfet
M$573 \$186 RESET_B|RST_B VPB|VPWR VPB|VPWR pfet L=0.15U W=0.42U AS=0.0819P
+ AD=0.0567P PS=0.81U PD=0.69U
* device instance $574 r0 *1 14.555,21.315 pfet
M$574 VPB|VPWR \$185 \$186 VPB|VPWR pfet L=0.15U W=0.42U AS=0.0567P AD=0.1134P
+ PS=0.69U PD=1.38U
* device instance $575 r0 *1 15.045,22.205 pfet
M$575 \$215 \$209 \$214 VPB|VPWR pfet L=0.15U W=0.42U AS=0.12915P AD=0.0588P
+ PS=1.185U PD=0.7U
* device instance $576 r0 *1 15.475,22.205 pfet
M$576 \$227 \$210 \$215 VPB|VPWR pfet L=0.15U W=0.42U AS=0.0588P AD=0.0567P
+ PS=0.7U PD=0.69U
* device instance $577 r0 *1 15.895,22.205 pfet
M$577 VPB|VPWR \$216 \$227 VPB|VPWR pfet L=0.15U W=0.42U AS=0.0567P AD=0.0819P
+ PS=0.69U PD=0.81U
* device instance $578 r0 *1 16.435,22.205 pfet
M$578 \$216 RESET_B|RST_B VPB|VPWR VPB|VPWR pfet L=0.15U W=0.42U AS=0.0819P
+ AD=0.0567P PS=0.81U PD=0.69U
* device instance $579 r0 *1 16.855,22.205 pfet
M$579 VPB|VPWR \$215 \$216 VPB|VPWR pfet L=0.15U W=0.42U AS=0.0567P AD=0.1134P
+ PS=0.69U PD=1.38U
* device instance $580 r0 *1 14.55,22.415 pfet
M$580 \$214 \$212 VPB|VPWR VPB|VPWR pfet L=0.15U W=0.84U AS=0.2184P AD=0.12915P
+ PS=2.2U PD=1.185U
* device instance $581 r0 *1 15.63,21.025 pfet
M$581 A|D|PH_B5|Q|S \$186 VPB|VPWR VPB|VPWR pfet L=0.15U W=1U AS=0.3012P
+ AD=0.26P PS=2.66U PD=2.52U
* device instance $582 r0 *1 17.93,22.495 pfet
M$582 D|PH_B2|Q|S \$216 VPB|VPWR VPB|VPWR pfet L=0.15U W=1U AS=0.3012P AD=0.26P
+ PS=2.66U PD=2.52U
* device instance $583 r0 *1 19.33,21.025 pfet
M$583 VPB|VPWR A|CLK \$187 VPB|VPWR pfet L=0.15U W=1U AS=0.26P AD=0.135P
+ PS=2.52U PD=1.27U
* device instance $584 r0 *1 19.75,21.025 pfet
M$584 A|X \$187 VPB|VPWR VPB|VPWR pfet L=0.15U W=1U AS=0.135P AD=0.135P
+ PS=1.27U PD=1.27U
* device instance $585 r0 *1 20.17,21.025 pfet
M$585 VPB|VPWR \$187 A|X VPB|VPWR pfet L=0.15U W=1U AS=0.135P AD=0.135P
+ PS=1.27U PD=1.27U
* device instance $586 r0 *1 20.59,21.025 pfet
M$586 A|X \$187 VPB|VPWR VPB|VPWR pfet L=0.15U W=1U AS=0.135P AD=0.135P
+ PS=1.27U PD=1.27U
* device instance $587 r0 *1 21.01,21.025 pfet
M$587 VPB|VPWR \$187 A|X VPB|VPWR pfet L=0.15U W=1U AS=0.135P AD=0.26P PS=1.27U
+ PD=2.52U
* device instance $588 r0 *1 27.15,21.175 pfet
M$588 VPB|VPWR CLK|X \$188 VPB|VPWR pfet L=0.15U W=0.64U AS=0.1664P AD=0.0864P
+ PS=1.8U PD=0.91U
* device instance $589 r0 *1 27.57,21.175 pfet
M$589 \$189 \$188 VPB|VPWR VPB|VPWR pfet L=0.15U W=0.64U AS=0.0864P AD=0.1664P
+ PS=0.91U PD=1.8U
* device instance $590 r0 *1 28.905,21.315 pfet
M$590 \$190 B|D|PH_B8|Q|S VPB|VPWR VPB|VPWR pfet L=0.15U W=0.42U AS=0.1092P
+ AD=0.0651P PS=1.36U PD=0.73U
* device instance $591 r0 *1 29.365,21.315 pfet
M$591 \$191 \$189 \$190 VPB|VPWR pfet L=0.15U W=0.42U AS=0.0651P AD=0.07245P
+ PS=0.73U PD=0.765U
* device instance $592 r0 *1 29.86,21.315 pfet
M$592 \$206 \$188 \$191 VPB|VPWR pfet L=0.15U W=0.42U AS=0.07245P AD=0.1155P
+ PS=0.765U PD=0.97U
* device instance $593 r0 *1 30.56,21.315 pfet
M$593 VPB|VPWR \$192 \$206 VPB|VPWR pfet L=0.15U W=0.42U AS=0.1155P AD=0.07035P
+ PS=0.97U PD=0.755U
* device instance $594 r0 *1 31.045,21.315 pfet
M$594 \$206 RESET_B|RST_B VPB|VPWR VPB|VPWR pfet L=0.15U W=0.42U AS=0.07035P
+ AD=0.1092P PS=0.755U PD=1.36U
* device instance $595 r0 *1 32.03,21.105 pfet
M$595 \$192 \$191 VPB|VPWR VPB|VPWR pfet L=0.15U W=0.84U AS=0.2184P AD=0.12915P
+ PS=2.2U PD=1.185U
* device instance $596 r0 *1 32.525,21.315 pfet
M$596 \$193 \$188 \$192 VPB|VPWR pfet L=0.15U W=0.42U AS=0.12915P AD=0.0588P
+ PS=1.185U PD=0.7U
* device instance $597 r0 *1 32.955,21.315 pfet
M$597 \$208 \$189 \$193 VPB|VPWR pfet L=0.15U W=0.42U AS=0.0588P AD=0.0567P
+ PS=0.7U PD=0.69U
* device instance $598 r0 *1 33.375,21.315 pfet
M$598 VPB|VPWR \$194 \$208 VPB|VPWR pfet L=0.15U W=0.42U AS=0.0567P AD=0.0819P
+ PS=0.69U PD=0.81U
* device instance $599 r0 *1 33.915,21.315 pfet
M$599 \$194 RESET_B|RST_B VPB|VPWR VPB|VPWR pfet L=0.15U W=0.42U AS=0.0819P
+ AD=0.0567P PS=0.81U PD=0.69U
* device instance $600 r0 *1 34.335,21.315 pfet
M$600 VPB|VPWR \$193 \$194 VPB|VPWR pfet L=0.15U W=0.42U AS=0.0567P AD=0.1134P
+ PS=0.69U PD=1.38U
* device instance $601 r0 *1 32.585,22.205 pfet
M$601 \$220 B|D|PH_B0|Q|S VPB|VPWR VPB|VPWR pfet L=0.15U W=0.42U AS=0.1092P
+ AD=0.0651P PS=1.36U PD=0.73U
* device instance $602 r0 *1 33.045,22.205 pfet
M$602 \$221 \$219 \$220 VPB|VPWR pfet L=0.15U W=0.42U AS=0.0651P AD=0.07245P
+ PS=0.73U PD=0.765U
* device instance $603 r0 *1 33.54,22.205 pfet
M$603 \$222 \$218 \$221 VPB|VPWR pfet L=0.15U W=0.42U AS=0.07245P AD=0.1155P
+ PS=0.765U PD=0.97U
* device instance $604 r0 *1 34.24,22.205 pfet
M$604 VPB|VPWR \$223 \$222 VPB|VPWR pfet L=0.15U W=0.42U AS=0.1155P AD=0.07035P
+ PS=0.97U PD=0.755U
* device instance $605 r0 *1 34.725,22.205 pfet
M$605 \$222 RESET_B|RST_B VPB|VPWR VPB|VPWR pfet L=0.15U W=0.42U AS=0.07035P
+ AD=0.1092P PS=0.755U PD=1.36U
* device instance $606 r0 *1 35.41,21.025 pfet
M$606 C|D|PH_B7|Q|S \$194 VPB|VPWR VPB|VPWR pfet L=0.15U W=1U AS=0.3012P
+ AD=0.26P PS=2.66U PD=2.52U
* device instance $607 r0 *1 36.205,22.205 pfet
M$607 \$224 \$218 \$223 VPB|VPWR pfet L=0.15U W=0.42U AS=0.12915P AD=0.0588P
+ PS=1.185U PD=0.7U
* device instance $608 r0 *1 36.635,22.205 pfet
M$608 \$228 \$219 \$224 VPB|VPWR pfet L=0.15U W=0.42U AS=0.0588P AD=0.0567P
+ PS=0.7U PD=0.69U
* device instance $609 r0 *1 37.055,22.205 pfet
M$609 VPB|VPWR \$225 \$228 VPB|VPWR pfet L=0.15U W=0.42U AS=0.0567P AD=0.0819P
+ PS=0.69U PD=0.81U
* device instance $610 r0 *1 37.595,22.205 pfet
M$610 \$225 RESET_B|RST_B VPB|VPWR VPB|VPWR pfet L=0.15U W=0.42U AS=0.0819P
+ AD=0.0567P PS=0.81U PD=0.69U
* device instance $611 r0 *1 38.015,22.205 pfet
M$611 VPB|VPWR \$224 \$225 VPB|VPWR pfet L=0.15U W=0.42U AS=0.0567P AD=0.1134P
+ PS=0.69U PD=1.38U
* device instance $612 r0 *1 35.71,22.415 pfet
M$612 \$223 \$221 VPB|VPWR VPB|VPWR pfet L=0.15U W=0.84U AS=0.2184P AD=0.12915P
+ PS=2.2U PD=1.185U
* device instance $613 r0 *1 39.09,22.495 pfet
M$613 C|PH_EOC|Q \$225 VPB|VPWR VPB|VPWR pfet L=0.15U W=1U AS=0.3012P AD=0.26P
+ PS=2.66U PD=2.52U
* device instance $614 r0 *1 7.37,26.615 pfet
M$614 VPB|VPWR A|CLK|X \$243 VPB|VPWR pfet L=0.15U W=0.64U AS=0.1664P
+ AD=0.0864P PS=1.8U PD=0.91U
* device instance $615 r0 *1 7.79,26.615 pfet
M$615 \$244 \$243 VPB|VPWR VPB|VPWR pfet L=0.15U W=0.64U AS=0.0864P AD=0.1664P
+ PS=0.91U PD=1.8U
* device instance $616 r0 *1 9.67,22.345 pfet
M$616 VPB|VPWR A|CLK|X \$209 VPB|VPWR pfet L=0.15U W=0.64U AS=0.1664P
+ AD=0.0864P PS=1.8U PD=0.91U
* device instance $617 r0 *1 10.09,22.345 pfet
M$617 \$210 \$209 VPB|VPWR VPB|VPWR pfet L=0.15U W=0.64U AS=0.0864P AD=0.1664P
+ PS=0.91U PD=1.8U
* device instance $618 r0 *1 12.25,26.545 pfet
M$618 \$265 \$246 VPB|VPWR VPB|VPWR pfet L=0.15U W=0.84U AS=0.2184P AD=0.12915P
+ PS=2.2U PD=1.185U
* device instance $619 r0 *1 12.745,26.755 pfet
M$619 \$247 \$243 \$265 VPB|VPWR pfet L=0.15U W=0.42U AS=0.12915P AD=0.0588P
+ PS=1.185U PD=0.7U
* device instance $620 r0 *1 13.175,26.755 pfet
M$620 \$274 \$244 \$247 VPB|VPWR pfet L=0.15U W=0.42U AS=0.0588P AD=0.0567P
+ PS=0.7U PD=0.69U
* device instance $621 r0 *1 13.595,26.755 pfet
M$621 VPB|VPWR \$248 \$274 VPB|VPWR pfet L=0.15U W=0.42U AS=0.0567P AD=0.0819P
+ PS=0.69U PD=0.81U
* device instance $622 r0 *1 14.135,26.755 pfet
M$622 \$248 RESET_B|RST_B VPB|VPWR VPB|VPWR pfet L=0.15U W=0.42U AS=0.0819P
+ AD=0.0567P PS=0.81U PD=0.69U
* device instance $623 r0 *1 14.555,26.755 pfet
M$623 VPB|VPWR \$247 \$248 VPB|VPWR pfet L=0.15U W=0.42U AS=0.0567P AD=0.1134P
+ PS=0.69U PD=1.38U
* device instance $624 r0 *1 15.63,26.465 pfet
M$624 B|D|PH_B4|Q|S \$248 VPB|VPWR VPB|VPWR pfet L=0.15U W=1U AS=0.3012P
+ AD=0.26P PS=2.66U PD=2.52U
* device instance $625 r0 *1 26.775,26.56 pfet
M$625 \$275 A|D|PH_B1|Q|S VPB|VPWR VPB|VPWR pfet L=0.15U W=0.42U AS=0.15835P
+ AD=0.07665P PS=1.395U PD=0.785U
* device instance $626 r0 *1 27.29,26.56 pfet
M$626 \$251 A0|DOUT1|Q \$275 VPB|VPWR pfet L=0.15U W=0.42U AS=0.07665P
+ AD=0.1932P PS=0.785U PD=1.34U
* device instance $627 r0 *1 28.36,26.56 pfet
M$627 \$273 A1|COMP_OUT \$251 VPB|VPWR pfet L=0.15U W=0.42U AS=0.1932P
+ AD=0.0441P PS=1.34U PD=0.63U
* device instance $628 r0 *1 28.72,26.56 pfet
M$628 VPB|VPWR \$253 \$273 VPB|VPWR pfet L=0.15U W=0.42U AS=0.0441P AD=0.0693P
+ PS=0.63U PD=0.75U
* device instance $629 r0 *1 29.2,26.56 pfet
M$629 \$253 A|D|PH_B1|Q|S VPB|VPWR VPB|VPWR pfet L=0.15U W=0.42U AS=0.0693P
+ AD=0.1176P PS=0.75U PD=1.4U
* device instance $630 r0 *1 26.23,26.465 pfet
M$630 VPB|VPWR \$251 D|X$6 VPB|VPWR pfet L=0.15U W=1U AS=0.26P AD=0.15835P
+ PS=2.52U PD=1.395U
* device instance $631 r0 *1 27.61,22.785 pfet
M$631 \$232 D|PH_B6|Q|S \$230 VPB|VPWR pfet L=0.15U W=0.42U AS=0.1092P
+ AD=0.0693P PS=1.36U PD=0.75U
* device instance $632 r0 *1 28.09,22.785 pfet
M$632 \$233 C|D|PH_B7|Q|S \$232 VPB|VPWR pfet L=0.15U W=0.42U AS=0.0693P
+ AD=0.0441P PS=0.75U PD=0.63U
* device instance $633 r0 *1 28.45,22.785 pfet
M$633 \$234 B|D|PH_B8|Q|S \$233 VPB|VPWR pfet L=0.15U W=0.42U AS=0.0441P
+ AD=0.0693P PS=0.63U PD=0.75U
* device instance $634 r0 *1 28.93,22.785 pfet
M$634 \$234 A|D|PH_B9|Q|S VPB|VPWR VPB|VPWR pfet L=0.15U W=0.42U AS=0.14825P
+ AD=0.0693P PS=1.34U PD=0.75U
* device instance $635 r0 *1 29.42,22.495 pfet
M$635 A|X$1 \$230 VPB|VPWR VPB|VPWR pfet L=0.15U W=1U AS=0.14825P AD=0.27P
+ PS=1.34U PD=2.54U
* device instance $636 r0 *1 30.37,26.175 pfet
M$636 \$272 D|PH_B2|Q|S \$254 VPB|VPWR pfet L=0.15U W=0.42U AS=0.1092P
+ AD=0.0693P PS=1.36U PD=0.75U
* device instance $637 r0 *1 30.85,26.175 pfet
M$637 \$271 C|D|PH_B3|Q|S \$272 VPB|VPWR pfet L=0.15U W=0.42U AS=0.0693P
+ AD=0.0441P PS=0.75U PD=0.63U
* device instance $638 r0 *1 31.21,26.175 pfet
M$638 \$270 B|D|PH_B4|Q|S \$271 VPB|VPWR pfet L=0.15U W=0.42U AS=0.0441P
+ AD=0.0693P PS=0.63U PD=0.75U
* device instance $639 r0 *1 31.69,26.175 pfet
M$639 VPB|VPWR A|D|PH_B5|Q|S \$270 VPB|VPWR pfet L=0.15U W=0.42U AS=0.0693P
+ AD=0.14825P PS=0.75U PD=1.34U
* device instance $640 r0 *1 32.18,26.465 pfet
M$640 B|X \$254 VPB|VPWR VPB|VPWR pfet L=0.15U W=1U AS=0.14825P AD=0.27P
+ PS=1.34U PD=2.54U
* device instance $641 r0 *1 30.83,22.345 pfet
M$641 VPB|VPWR CLK|X \$218 VPB|VPWR pfet L=0.15U W=0.64U AS=0.1664P AD=0.0864P
+ PS=1.8U PD=0.91U
* device instance $642 r0 *1 31.25,22.345 pfet
M$642 \$219 \$218 VPB|VPWR VPB|VPWR pfet L=0.15U W=0.64U AS=0.0864P AD=0.1664P
+ PS=0.91U PD=1.8U
* device instance $643 r0 *1 33.14,26.175 pfet
M$643 \$269 C|X \$256 VPB|VPWR pfet L=0.15U W=0.42U AS=0.1092P AD=0.0441P
+ PS=1.36U PD=0.63U
* device instance $644 r0 *1 33.5,26.175 pfet
M$644 \$268 B|X \$269 VPB|VPWR pfet L=0.15U W=0.42U AS=0.0441P AD=0.0693P
+ PS=0.63U PD=0.75U
* device instance $645 r0 *1 33.98,26.175 pfet
M$645 VPB|VPWR A|X$1 \$268 VPB|VPWR pfet L=0.15U W=0.42U AS=0.0693P AD=0.14825P
+ PS=0.75U PD=1.34U
* device instance $646 r0 *1 34.47,26.465 pfet
M$646 A|BUSY|X \$256 VPB|VPWR VPB|VPWR pfet L=0.15U W=1U AS=0.14825P AD=0.28P
+ PS=1.34U PD=2.56U
* device instance $647 r0 *1 9.125,26.755 pfet
M$647 \$245 A|D|PH_B5|Q|S VPB|VPWR VPB|VPWR pfet L=0.15U W=0.42U AS=0.1092P
+ AD=0.0651P PS=1.36U PD=0.73U
* device instance $648 r0 *1 9.585,26.755 pfet
M$648 \$246 \$244 \$245 VPB|VPWR pfet L=0.15U W=0.42U AS=0.0651P AD=0.07245P
+ PS=0.73U PD=0.765U
* device instance $649 r0 *1 10.08,26.755 pfet
M$649 \$267 \$243 \$246 VPB|VPWR pfet L=0.15U W=0.42U AS=0.07245P AD=0.1155P
+ PS=0.765U PD=0.97U
* device instance $650 r0 *1 10.78,26.755 pfet
M$650 VPB|VPWR \$265 \$267 VPB|VPWR pfet L=0.15U W=0.42U AS=0.1155P AD=0.07035P
+ PS=0.97U PD=0.755U
* device instance $651 r0 *1 11.265,26.755 pfet
M$651 \$267 RESET_B|RST_B VPB|VPWR VPB|VPWR pfet L=0.15U W=0.42U AS=0.07035P
+ AD=0.1092P PS=0.755U PD=1.36U
* device instance $652 r0 *1 11.595,27.84 pfet
M$652 \$296 B|D|PH_B4|Q|S VPB|VPWR VPB|VPWR pfet L=0.15U W=0.42U AS=0.15835P
+ AD=0.07665P PS=1.395U PD=0.785U
* device instance $653 r0 *1 12.11,27.84 pfet
M$653 \$277 A0|DOUT4|Q \$296 VPB|VPWR pfet L=0.15U W=0.42U AS=0.07665P
+ AD=0.1932P PS=0.785U PD=1.34U
* device instance $654 r0 *1 13.18,27.84 pfet
M$654 \$297 A1|COMP_OUT \$277 VPB|VPWR pfet L=0.15U W=0.42U AS=0.1932P
+ AD=0.0441P PS=1.34U PD=0.63U
* device instance $655 r0 *1 13.54,27.84 pfet
M$655 VPB|VPWR \$279 \$297 VPB|VPWR pfet L=0.15U W=0.42U AS=0.0441P AD=0.0693P
+ PS=0.63U PD=0.75U
* device instance $656 r0 *1 14.02,27.84 pfet
M$656 \$279 B|D|PH_B4|Q|S VPB|VPWR VPB|VPWR pfet L=0.15U W=0.42U AS=0.0693P
+ AD=0.1176P PS=0.75U PD=1.4U
* device instance $657 r0 *1 11.05,27.935 pfet
M$657 VPB|VPWR \$277 D|X$7 VPB|VPWR pfet L=0.15U W=1U AS=0.26P AD=0.15835P
+ PS=2.52U PD=1.395U
* device instance $658 r0 *1 16.945,27.645 pfet
M$658 \$282 D|PH_B2|Q|S VPB|VPWR VPB|VPWR pfet L=0.15U W=0.42U AS=0.1092P
+ AD=0.0651P PS=1.36U PD=0.73U
* device instance $659 r0 *1 17.405,27.645 pfet
M$659 \$283 \$281 \$282 VPB|VPWR pfet L=0.15U W=0.42U AS=0.0651P AD=0.07245P
+ PS=0.73U PD=0.765U
* device instance $660 r0 *1 17.9,27.645 pfet
M$660 \$284 \$280 \$283 VPB|VPWR pfet L=0.15U W=0.42U AS=0.07245P AD=0.1155P
+ PS=0.765U PD=0.97U
* device instance $661 r0 *1 18.6,27.645 pfet
M$661 VPB|VPWR \$285 \$284 VPB|VPWR pfet L=0.15U W=0.42U AS=0.1155P AD=0.07035P
+ PS=0.97U PD=0.755U
* device instance $662 r0 *1 19.085,27.645 pfet
M$662 \$284 RESET_B|RST_B VPB|VPWR VPB|VPWR pfet L=0.15U W=0.42U AS=0.07035P
+ AD=0.1092P PS=0.755U PD=1.36U
* device instance $663 r0 *1 20.565,27.645 pfet
M$663 \$286 \$280 \$285 VPB|VPWR pfet L=0.15U W=0.42U AS=0.12915P AD=0.0588P
+ PS=1.185U PD=0.7U
* device instance $664 r0 *1 20.995,27.645 pfet
M$664 \$300 \$281 \$286 VPB|VPWR pfet L=0.15U W=0.42U AS=0.0588P AD=0.0567P
+ PS=0.7U PD=0.69U
* device instance $665 r0 *1 21.415,27.645 pfet
M$665 VPB|VPWR \$287 \$300 VPB|VPWR pfet L=0.15U W=0.42U AS=0.0567P AD=0.0819P
+ PS=0.69U PD=0.81U
* device instance $666 r0 *1 21.955,27.645 pfet
M$666 \$287 RESET_B|RST_B VPB|VPWR VPB|VPWR pfet L=0.15U W=0.42U AS=0.0819P
+ AD=0.0567P PS=0.81U PD=0.69U
* device instance $667 r0 *1 22.375,27.645 pfet
M$667 VPB|VPWR \$286 \$287 VPB|VPWR pfet L=0.15U W=0.42U AS=0.0567P AD=0.1134P
+ PS=0.69U PD=1.38U
* device instance $668 r0 *1 20.07,27.855 pfet
M$668 \$285 \$283 VPB|VPWR VPB|VPWR pfet L=0.15U W=0.84U AS=0.2184P AD=0.12915P
+ PS=2.2U PD=1.185U
* device instance $669 r0 *1 23.45,27.935 pfet
M$669 A|D|PH_B1|Q|S \$287 VPB|VPWR VPB|VPWR pfet L=0.15U W=1U AS=0.3012P
+ AD=0.26P PS=2.66U PD=2.52U
* device instance $670 r0 *1 26.775,27.84 pfet
M$670 \$301 C|D|PH_B3|Q|S VPB|VPWR VPB|VPWR pfet L=0.15U W=0.42U AS=0.15835P
+ AD=0.07665P PS=1.395U PD=0.785U
* device instance $671 r0 *1 27.29,27.84 pfet
M$671 \$289 A0|DOUT3|Q \$301 VPB|VPWR pfet L=0.15U W=0.42U AS=0.07665P
+ AD=0.1932P PS=0.785U PD=1.34U
* device instance $672 r0 *1 28.36,27.84 pfet
M$672 \$302 A1|COMP_OUT \$289 VPB|VPWR pfet L=0.15U W=0.42U AS=0.1932P
+ AD=0.0441P PS=1.34U PD=0.63U
* device instance $673 r0 *1 28.72,27.84 pfet
M$673 VPB|VPWR \$290 \$302 VPB|VPWR pfet L=0.15U W=0.42U AS=0.0441P AD=0.0693P
+ PS=0.63U PD=0.75U
* device instance $674 r0 *1 29.2,27.84 pfet
M$674 \$290 C|D|PH_B3|Q|S VPB|VPWR VPB|VPWR pfet L=0.15U W=0.42U AS=0.0693P
+ AD=0.1176P PS=0.75U PD=1.4U
* device instance $675 r0 *1 26.23,27.935 pfet
M$675 VPB|VPWR \$289 D|X$8 VPB|VPWR pfet L=0.15U W=1U AS=0.26P AD=0.15835P
+ PS=2.52U PD=1.395U
* device instance $676 r0 *1 33.335,27.935 pfet
M$676 D|PH_SAMPLE|Y A|BUSY|X VPB|VPWR VPB|VPWR pfet L=0.15U W=1U AS=0.26P
+ AD=0.26P PS=2.52U PD=2.52U
* device instance $677 r0 *1 35.055,27.84 pfet
M$677 \$299 B|D|PH_B0|Q|S VPB|VPWR VPB|VPWR pfet L=0.15U W=0.42U AS=0.15835P
+ AD=0.07665P PS=1.395U PD=0.785U
* device instance $678 r0 *1 35.57,27.84 pfet
M$678 \$292 A0|DOUT0|Q \$299 VPB|VPWR pfet L=0.15U W=0.42U AS=0.07665P
+ AD=0.1932P PS=0.785U PD=1.34U
* device instance $679 r0 *1 36.64,27.84 pfet
M$679 \$298 A1|COMP_OUT \$292 VPB|VPWR pfet L=0.15U W=0.42U AS=0.1932P
+ AD=0.0441P PS=1.34U PD=0.63U
* device instance $680 r0 *1 37,27.84 pfet
M$680 VPB|VPWR \$293 \$298 VPB|VPWR pfet L=0.15U W=0.42U AS=0.0441P AD=0.0693P
+ PS=0.63U PD=0.75U
* device instance $681 r0 *1 37.48,27.84 pfet
M$681 \$293 B|D|PH_B0|Q|S VPB|VPWR VPB|VPWR pfet L=0.15U W=0.42U AS=0.0693P
+ AD=0.1176P PS=0.75U PD=1.4U
* device instance $682 r0 *1 34.51,27.935 pfet
M$682 VPB|VPWR \$292 D|X$9 VPB|VPWR pfet L=0.15U W=1U AS=0.26P AD=0.15835P
+ PS=2.52U PD=1.395U
* device instance $683 r0 *1 15.19,27.785 pfet
M$683 VPB|VPWR A|CLK|X \$280 VPB|VPWR pfet L=0.15U W=0.64U AS=0.1664P
+ AD=0.0864P PS=1.8U PD=0.91U
* device instance $684 r0 *1 15.61,27.785 pfet
M$684 \$281 \$280 VPB|VPWR VPB|VPWR pfet L=0.15U W=0.64U AS=0.0864P AD=0.1664P
+ PS=0.91U PD=1.8U
* device instance $685 r0 *1 15.63,31.905 pfet
M$685 C|D|PH_B3|Q|S \$321 VPB|VPWR VPB|VPWR pfet L=0.15U W=1U AS=0.3012P
+ AD=0.26P PS=2.66U PD=2.52U
* device instance $686 r0 *1 17.03,31.905 pfet
M$686 VPB|VPWR A|X \$322 VPB|VPWR pfet L=0.15U W=1U AS=0.26P AD=0.135P PS=2.52U
+ PD=1.27U
* device instance $687 r0 *1 17.45,31.905 pfet
M$687 A|CLK|X \$322 VPB|VPWR VPB|VPWR pfet L=0.15U W=1U AS=0.135P AD=0.135P
+ PS=1.27U PD=1.27U
* device instance $688 r0 *1 17.87,31.905 pfet
M$688 VPB|VPWR \$322 A|CLK|X VPB|VPWR pfet L=0.15U W=1U AS=0.135P AD=0.135P
+ PS=1.27U PD=1.27U
* device instance $689 r0 *1 18.29,31.905 pfet
M$689 A|CLK|X \$322 VPB|VPWR VPB|VPWR pfet L=0.15U W=1U AS=0.135P AD=0.135P
+ PS=1.27U PD=1.27U
* device instance $690 r0 *1 18.71,31.905 pfet
M$690 VPB|VPWR \$322 A|CLK|X VPB|VPWR pfet L=0.15U W=1U AS=0.135P AD=0.26P
+ PS=1.27U PD=2.52U
* device instance $691 r0 *1 30.84,28.225 pfet
M$691 \$303 C|PH_EOC|Q \$294 VPB|VPWR pfet L=0.15U W=0.42U AS=0.1092P
+ AD=0.0441P PS=1.36U PD=0.63U
* device instance $692 r0 *1 31.2,28.225 pfet
M$692 \$304 B|D|PH_B0|Q|S \$303 VPB|VPWR pfet L=0.15U W=0.42U AS=0.0441P
+ AD=0.0693P PS=0.63U PD=0.75U
* device instance $693 r0 *1 31.68,28.225 pfet
M$693 \$304 A|D|PH_B1|Q|S VPB|VPWR VPB|VPWR pfet L=0.15U W=0.42U AS=0.14825P
+ AD=0.0693P PS=1.34U PD=0.75U
* device instance $694 r0 *1 32.17,27.935 pfet
M$694 C|X \$294 VPB|VPWR VPB|VPWR pfet L=0.15U W=1U AS=0.14825P AD=0.28P
+ PS=1.34U PD=2.56U
* device instance $695 r0 *1 34.03,31.905 pfet
M$695 A0|DOUT3|Q \$328 VPB|VPWR VPB|VPWR pfet L=0.15U W=1U AS=0.3012P AD=0.26P
+ PS=2.66U PD=2.52U
* device instance $696 r0 *1 7.37,32.055 pfet
M$696 VPB|VPWR A|CLK|X \$316 VPB|VPWR pfet L=0.15U W=0.64U AS=0.1664P
+ AD=0.0864P PS=1.8U PD=0.91U
* device instance $697 r0 *1 7.79,32.055 pfet
M$697 \$317 \$316 VPB|VPWR VPB|VPWR pfet L=0.15U W=0.64U AS=0.0864P AD=0.1664P
+ PS=0.91U PD=1.8U
* device instance $698 r0 *1 9.125,32.195 pfet
M$698 \$318 B|D|PH_B4|Q|S VPB|VPWR VPB|VPWR pfet L=0.15U W=0.42U AS=0.1092P
+ AD=0.0651P PS=1.36U PD=0.73U
* device instance $699 r0 *1 9.585,32.195 pfet
M$699 \$319 \$317 \$318 VPB|VPWR pfet L=0.15U W=0.42U AS=0.0651P AD=0.07245P
+ PS=0.73U PD=0.765U
* device instance $700 r0 *1 10.08,32.195 pfet
M$700 \$339 \$316 \$319 VPB|VPWR pfet L=0.15U W=0.42U AS=0.07245P AD=0.1155P
+ PS=0.765U PD=0.97U
* device instance $701 r0 *1 10.78,32.195 pfet
M$701 VPB|VPWR \$337 \$339 VPB|VPWR pfet L=0.15U W=0.42U AS=0.1155P AD=0.07035P
+ PS=0.97U PD=0.755U
* device instance $702 r0 *1 11.265,32.195 pfet
M$702 \$339 RESET_B|RST_B VPB|VPWR VPB|VPWR pfet L=0.15U W=0.42U AS=0.07035P
+ AD=0.1092P PS=0.755U PD=1.36U
* device instance $703 r0 *1 12.25,31.985 pfet
M$703 \$337 \$319 VPB|VPWR VPB|VPWR pfet L=0.15U W=0.84U AS=0.2184P AD=0.12915P
+ PS=2.2U PD=1.185U
* device instance $704 r0 *1 12.745,32.195 pfet
M$704 \$320 \$316 \$337 VPB|VPWR pfet L=0.15U W=0.42U AS=0.12915P AD=0.0588P
+ PS=1.185U PD=0.7U
* device instance $705 r0 *1 13.175,32.195 pfet
M$705 \$342 \$317 \$320 VPB|VPWR pfet L=0.15U W=0.42U AS=0.0588P AD=0.0567P
+ PS=0.7U PD=0.69U
* device instance $706 r0 *1 13.595,32.195 pfet
M$706 VPB|VPWR \$321 \$342 VPB|VPWR pfet L=0.15U W=0.42U AS=0.0567P AD=0.0819P
+ PS=0.69U PD=0.81U
* device instance $707 r0 *1 14.135,32.195 pfet
M$707 \$321 RESET_B|RST_B VPB|VPWR VPB|VPWR pfet L=0.15U W=0.42U AS=0.0819P
+ AD=0.0567P PS=0.81U PD=0.69U
* device instance $708 r0 *1 14.555,32.195 pfet
M$708 VPB|VPWR \$320 \$321 VPB|VPWR pfet L=0.15U W=0.42U AS=0.0567P AD=0.1134P
+ PS=0.69U PD=1.38U
* device instance $709 r0 *1 25.77,32.055 pfet
M$709 VPB|VPWR A|CLK|X \$323 VPB|VPWR pfet L=0.15U W=0.64U AS=0.1664P
+ AD=0.0864P PS=1.8U PD=0.91U
* device instance $710 r0 *1 26.19,32.055 pfet
M$710 \$324 \$323 VPB|VPWR VPB|VPWR pfet L=0.15U W=0.64U AS=0.0864P AD=0.1664P
+ PS=0.91U PD=1.8U
* device instance $711 r0 *1 27.525,32.195 pfet
M$711 \$325 D|X$8 VPB|VPWR VPB|VPWR pfet L=0.15U W=0.42U AS=0.1092P AD=0.0651P
+ PS=1.36U PD=0.73U
* device instance $712 r0 *1 27.985,32.195 pfet
M$712 \$326 \$324 \$325 VPB|VPWR pfet L=0.15U W=0.42U AS=0.0651P AD=0.07245P
+ PS=0.73U PD=0.765U
* device instance $713 r0 *1 28.48,32.195 pfet
M$713 \$340 \$323 \$326 VPB|VPWR pfet L=0.15U W=0.42U AS=0.07245P AD=0.1155P
+ PS=0.765U PD=0.97U
* device instance $714 r0 *1 29.18,32.195 pfet
M$714 VPB|VPWR \$338 \$340 VPB|VPWR pfet L=0.15U W=0.42U AS=0.1155P AD=0.07035P
+ PS=0.97U PD=0.755U
* device instance $715 r0 *1 29.665,32.195 pfet
M$715 \$340 RESET_B|RST_B VPB|VPWR VPB|VPWR pfet L=0.15U W=0.42U AS=0.07035P
+ AD=0.1092P PS=0.755U PD=1.36U
* device instance $716 r0 *1 30.65,31.985 pfet
M$716 \$338 \$326 VPB|VPWR VPB|VPWR pfet L=0.15U W=0.84U AS=0.2184P AD=0.12915P
+ PS=2.2U PD=1.185U
* device instance $717 r0 *1 31.145,32.195 pfet
M$717 \$327 \$323 \$338 VPB|VPWR pfet L=0.15U W=0.42U AS=0.12915P AD=0.0588P
+ PS=1.185U PD=0.7U
* device instance $718 r0 *1 31.575,32.195 pfet
M$718 \$341 \$324 \$327 VPB|VPWR pfet L=0.15U W=0.42U AS=0.0588P AD=0.0567P
+ PS=0.7U PD=0.69U
* device instance $719 r0 *1 31.995,32.195 pfet
M$719 VPB|VPWR \$328 \$341 VPB|VPWR pfet L=0.15U W=0.42U AS=0.0567P AD=0.0819P
+ PS=0.69U PD=0.81U
* device instance $720 r0 *1 32.535,32.195 pfet
M$720 \$328 RESET_B|RST_B VPB|VPWR VPB|VPWR pfet L=0.15U W=0.42U AS=0.0819P
+ AD=0.0567P PS=0.81U PD=0.69U
* device instance $721 r0 *1 32.955,32.195 pfet
M$721 VPB|VPWR \$327 \$328 VPB|VPWR pfet L=0.15U W=0.42U AS=0.0567P AD=0.1134P
+ PS=0.69U PD=1.38U
* device instance $722 r0 *1 10.505,33.085 pfet
M$722 \$345 D|X$7 VPB|VPWR VPB|VPWR pfet L=0.15U W=0.42U AS=0.1092P AD=0.0651P
+ PS=1.36U PD=0.73U
* device instance $723 r0 *1 10.965,33.085 pfet
M$723 \$346 \$344 \$345 VPB|VPWR pfet L=0.15U W=0.42U AS=0.0651P AD=0.07245P
+ PS=0.73U PD=0.765U
* device instance $724 r0 *1 11.46,33.085 pfet
M$724 \$347 \$343 \$346 VPB|VPWR pfet L=0.15U W=0.42U AS=0.07245P AD=0.1155P
+ PS=0.765U PD=0.97U
* device instance $725 r0 *1 12.16,33.085 pfet
M$725 VPB|VPWR \$348 \$347 VPB|VPWR pfet L=0.15U W=0.42U AS=0.1155P AD=0.07035P
+ PS=0.97U PD=0.755U
* device instance $726 r0 *1 12.645,33.085 pfet
M$726 \$347 RESET_B|RST_B VPB|VPWR VPB|VPWR pfet L=0.15U W=0.42U AS=0.07035P
+ AD=0.1092P PS=0.755U PD=1.36U
* device instance $727 r0 *1 14.125,33.085 pfet
M$727 \$349 \$343 \$348 VPB|VPWR pfet L=0.15U W=0.42U AS=0.12915P AD=0.0588P
+ PS=1.185U PD=0.7U
* device instance $728 r0 *1 14.555,33.085 pfet
M$728 \$367 \$344 \$349 VPB|VPWR pfet L=0.15U W=0.42U AS=0.0588P AD=0.0567P
+ PS=0.7U PD=0.69U
* device instance $729 r0 *1 14.975,33.085 pfet
M$729 VPB|VPWR \$350 \$367 VPB|VPWR pfet L=0.15U W=0.42U AS=0.0567P AD=0.0819P
+ PS=0.69U PD=0.81U
* device instance $730 r0 *1 15.515,33.085 pfet
M$730 \$350 RESET_B|RST_B VPB|VPWR VPB|VPWR pfet L=0.15U W=0.42U AS=0.0819P
+ AD=0.0567P PS=0.81U PD=0.69U
* device instance $731 r0 *1 15.935,33.085 pfet
M$731 VPB|VPWR \$349 \$350 VPB|VPWR pfet L=0.15U W=0.42U AS=0.0567P AD=0.1134P
+ PS=0.69U PD=1.38U
* device instance $732 r0 *1 13.63,33.295 pfet
M$732 \$348 \$346 VPB|VPWR VPB|VPWR pfet L=0.15U W=0.84U AS=0.2184P AD=0.12915P
+ PS=2.2U PD=1.185U
* device instance $733 r0 *1 17.01,33.375 pfet
M$733 A0|DOUT4|Q \$350 VPB|VPWR VPB|VPWR pfet L=0.15U W=1U AS=0.3012P AD=0.26P
+ PS=2.66U PD=2.52U
* device instance $734 r0 *1 22.925,33.085 pfet
M$734 \$353 A|D|PH_B1|Q|S VPB|VPWR VPB|VPWR pfet L=0.15U W=0.42U AS=0.1092P
+ AD=0.0651P PS=1.36U PD=0.73U
* device instance $735 r0 *1 23.385,33.085 pfet
M$735 \$354 \$352 \$353 VPB|VPWR pfet L=0.15U W=0.42U AS=0.0651P AD=0.07245P
+ PS=0.73U PD=0.765U
* device instance $736 r0 *1 23.88,33.085 pfet
M$736 \$355 \$351 \$354 VPB|VPWR pfet L=0.15U W=0.42U AS=0.07245P AD=0.1155P
+ PS=0.765U PD=0.97U
* device instance $737 r0 *1 24.58,33.085 pfet
M$737 VPB|VPWR \$356 \$355 VPB|VPWR pfet L=0.15U W=0.42U AS=0.1155P AD=0.07035P
+ PS=0.97U PD=0.755U
* device instance $738 r0 *1 25.065,33.085 pfet
M$738 \$355 RESET_B|RST_B VPB|VPWR VPB|VPWR pfet L=0.15U W=0.42U AS=0.07035P
+ AD=0.1092P PS=0.755U PD=1.36U
* device instance $739 r0 *1 26.545,33.085 pfet
M$739 \$357 \$351 \$356 VPB|VPWR pfet L=0.15U W=0.42U AS=0.12915P AD=0.0588P
+ PS=1.185U PD=0.7U
* device instance $740 r0 *1 26.975,33.085 pfet
M$740 \$369 \$352 \$357 VPB|VPWR pfet L=0.15U W=0.42U AS=0.0588P AD=0.0567P
+ PS=0.7U PD=0.69U
* device instance $741 r0 *1 27.395,33.085 pfet
M$741 VPB|VPWR \$358 \$369 VPB|VPWR pfet L=0.15U W=0.42U AS=0.0567P AD=0.0819P
+ PS=0.69U PD=0.81U
* device instance $742 r0 *1 27.935,33.085 pfet
M$742 \$358 RESET_B|RST_B VPB|VPWR VPB|VPWR pfet L=0.15U W=0.42U AS=0.0819P
+ AD=0.0567P PS=0.81U PD=0.69U
* device instance $743 r0 *1 28.355,33.085 pfet
M$743 VPB|VPWR \$357 \$358 VPB|VPWR pfet L=0.15U W=0.42U AS=0.0567P AD=0.1134P
+ PS=0.69U PD=1.38U
* device instance $744 r0 *1 26.05,33.295 pfet
M$744 \$356 \$354 VPB|VPWR VPB|VPWR pfet L=0.15U W=0.84U AS=0.2184P AD=0.12915P
+ PS=2.2U PD=1.185U
* device instance $745 r0 *1 29.43,33.375 pfet
M$745 B|D|PH_B0|Q|S \$358 VPB|VPWR VPB|VPWR pfet L=0.15U W=1U AS=0.3012P
+ AD=0.26P PS=2.66U PD=2.52U
* device instance $746 r0 *1 32.585,33.085 pfet
M$746 \$361 D|X$9 VPB|VPWR VPB|VPWR pfet L=0.15U W=0.42U AS=0.1092P AD=0.0651P
+ PS=1.36U PD=0.73U
* device instance $747 r0 *1 33.045,33.085 pfet
M$747 \$362 \$360 \$361 VPB|VPWR pfet L=0.15U W=0.42U AS=0.0651P AD=0.07245P
+ PS=0.73U PD=0.765U
* device instance $748 r0 *1 33.54,33.085 pfet
M$748 \$363 \$359 \$362 VPB|VPWR pfet L=0.15U W=0.42U AS=0.07245P AD=0.1155P
+ PS=0.765U PD=0.97U
* device instance $749 r0 *1 34.24,33.085 pfet
M$749 VPB|VPWR \$364 \$363 VPB|VPWR pfet L=0.15U W=0.42U AS=0.1155P AD=0.07035P
+ PS=0.97U PD=0.755U
* device instance $750 r0 *1 34.725,33.085 pfet
M$750 \$363 RESET_B|RST_B VPB|VPWR VPB|VPWR pfet L=0.15U W=0.42U AS=0.07035P
+ AD=0.1092P PS=0.755U PD=1.36U
* device instance $751 r0 *1 36.205,33.085 pfet
M$751 \$365 \$359 \$364 VPB|VPWR pfet L=0.15U W=0.42U AS=0.12915P AD=0.0588P
+ PS=1.185U PD=0.7U
* device instance $752 r0 *1 36.635,33.085 pfet
M$752 \$368 \$360 \$365 VPB|VPWR pfet L=0.15U W=0.42U AS=0.0588P AD=0.0567P
+ PS=0.7U PD=0.69U
* device instance $753 r0 *1 37.055,33.085 pfet
M$753 VPB|VPWR \$366 \$368 VPB|VPWR pfet L=0.15U W=0.42U AS=0.0567P AD=0.0819P
+ PS=0.69U PD=0.81U
* device instance $754 r0 *1 37.595,33.085 pfet
M$754 \$366 RESET_B|RST_B VPB|VPWR VPB|VPWR pfet L=0.15U W=0.42U AS=0.0819P
+ AD=0.0567P PS=0.81U PD=0.69U
* device instance $755 r0 *1 38.015,33.085 pfet
M$755 VPB|VPWR \$365 \$366 VPB|VPWR pfet L=0.15U W=0.42U AS=0.0567P AD=0.1134P
+ PS=0.69U PD=1.38U
* device instance $756 r0 *1 35.71,33.295 pfet
M$756 \$364 \$362 VPB|VPWR VPB|VPWR pfet L=0.15U W=0.84U AS=0.2184P AD=0.12915P
+ PS=2.2U PD=1.185U
* device instance $757 r0 *1 39.09,33.375 pfet
M$757 A0|DOUT0|Q \$366 VPB|VPWR VPB|VPWR pfet L=0.15U W=1U AS=0.3012P AD=0.26P
+ PS=2.66U PD=2.52U
* device instance $758 r0 *1 8.75,33.225 pfet
M$758 VPB|VPWR A|CLK|X \$343 VPB|VPWR pfet L=0.15U W=0.64U AS=0.1664P
+ AD=0.0864P PS=1.8U PD=0.91U
* device instance $759 r0 *1 9.17,33.225 pfet
M$759 \$344 \$343 VPB|VPWR VPB|VPWR pfet L=0.15U W=0.64U AS=0.0864P AD=0.1664P
+ PS=0.91U PD=1.8U
* device instance $760 r0 *1 15.395,37.345 pfet
M$760 Y A|CLK|X VPB|VPWR VPB|VPWR pfet L=0.15U W=1U AS=0.26P AD=0.26P PS=2.52U
+ PD=2.52U
* device instance $761 r0 *1 21.17,33.225 pfet
M$761 VPB|VPWR A|CLK|X \$351 VPB|VPWR pfet L=0.15U W=0.64U AS=0.1664P
+ AD=0.0864P PS=1.8U PD=0.91U
* device instance $762 r0 *1 21.59,33.225 pfet
M$762 \$352 \$351 VPB|VPWR VPB|VPWR pfet L=0.15U W=0.64U AS=0.0864P AD=0.1664P
+ PS=0.91U PD=1.8U
* device instance $763 r0 *1 30.83,33.225 pfet
M$763 VPB|VPWR A|CLK|X \$359 VPB|VPWR pfet L=0.15U W=0.64U AS=0.1664P
+ AD=0.0864P PS=1.8U PD=0.91U
* device instance $764 r0 *1 31.25,33.225 pfet
M$764 \$360 \$359 VPB|VPWR VPB|VPWR pfet L=0.15U W=0.64U AS=0.0864P AD=0.1664P
+ PS=0.91U PD=1.8U
* device instance $765 r0 *1 30.83,37.495 pfet
M$765 VPB|VPWR A|CLK|X \$383 VPB|VPWR pfet L=0.15U W=0.64U AS=0.1664P
+ AD=0.0864P PS=1.8U PD=0.91U
* device instance $766 r0 *1 31.25,37.495 pfet
M$766 \$384 \$383 VPB|VPWR VPB|VPWR pfet L=0.15U W=0.64U AS=0.0864P AD=0.1664P
+ PS=0.91U PD=1.8U
* device instance $767 r0 *1 32.585,37.635 pfet
M$767 \$385 D|X$6 VPB|VPWR VPB|VPWR pfet L=0.15U W=0.42U AS=0.1092P AD=0.0651P
+ PS=1.36U PD=0.73U
* device instance $768 r0 *1 33.045,37.635 pfet
M$768 \$386 \$384 \$385 VPB|VPWR pfet L=0.15U W=0.42U AS=0.0651P AD=0.07245P
+ PS=0.73U PD=0.765U
* device instance $769 r0 *1 33.54,37.635 pfet
M$769 \$394 \$383 \$386 VPB|VPWR pfet L=0.15U W=0.42U AS=0.07245P AD=0.1155P
+ PS=0.765U PD=0.97U
* device instance $770 r0 *1 34.24,37.635 pfet
M$770 VPB|VPWR \$387 \$394 VPB|VPWR pfet L=0.15U W=0.42U AS=0.1155P AD=0.07035P
+ PS=0.97U PD=0.755U
* device instance $771 r0 *1 34.725,37.635 pfet
M$771 \$394 RESET_B|RST_B VPB|VPWR VPB|VPWR pfet L=0.15U W=0.42U AS=0.07035P
+ AD=0.1092P PS=0.755U PD=1.36U
* device instance $772 r0 *1 35.71,37.425 pfet
M$772 \$387 \$386 VPB|VPWR VPB|VPWR pfet L=0.15U W=0.84U AS=0.2184P AD=0.12915P
+ PS=2.2U PD=1.185U
* device instance $773 r0 *1 36.205,37.635 pfet
M$773 \$388 \$383 \$387 VPB|VPWR pfet L=0.15U W=0.42U AS=0.12915P AD=0.0588P
+ PS=1.185U PD=0.7U
* device instance $774 r0 *1 36.635,37.635 pfet
M$774 \$395 \$384 \$388 VPB|VPWR pfet L=0.15U W=0.42U AS=0.0588P AD=0.0567P
+ PS=0.7U PD=0.69U
* device instance $775 r0 *1 37.055,37.635 pfet
M$775 VPB|VPWR \$389 \$395 VPB|VPWR pfet L=0.15U W=0.42U AS=0.0567P AD=0.0819P
+ PS=0.69U PD=0.81U
* device instance $776 r0 *1 37.595,37.635 pfet
M$776 \$389 RESET_B|RST_B VPB|VPWR VPB|VPWR pfet L=0.15U W=0.42U AS=0.0819P
+ AD=0.0567P PS=0.81U PD=0.69U
* device instance $777 r0 *1 38.015,37.635 pfet
M$777 VPB|VPWR \$388 \$389 VPB|VPWR pfet L=0.15U W=0.42U AS=0.0567P AD=0.1134P
+ PS=0.69U PD=1.38U
* device instance $778 r0 *1 39.09,37.345 pfet
M$778 A0|DOUT1|Q \$389 VPB|VPWR VPB|VPWR pfet L=0.15U W=1U AS=0.3012P AD=0.26P
+ PS=2.66U PD=2.52U
.ENDS sar_sequencer
