* LVS reference for the SAR logic/sequencer sub-block (issue #102).
*
* Mechanically generated -- DO NOT HAND-EDIT. Regenerate with:
*   layout/sar-sequencer/bin/generate-lvs-reference.py [netlist.v]
*
* Topology source: sar-sequencer/reports/20260825-124031-1a2f7c1/sar_sequencer_post_route.v
* (klt place-and-route's own post-route `write_verilog` dump -- see
* layout/sar-sequencer/README.md, 'LVS reference provenance', for
* why the LVS reference has to be the *post-route* netlist, not the
* pre-P&R structural netlist).
*
* Flat, transistor-level (klt extract --deck sky130 is a flat
* extractor), device classes generalized to nfet/pfet (matching that
* deck's own generalization of every drawn NMOS/PMOS regardless of
* flavor). Device models: the sky130 PDK's own official CDL
* (libs.ref/sky130_fd_sc_hd/cdl/sky130_fd_sc_hd.cdl), Apache-2.0
* licensed, SkyWater's own release -- not reverse-engineered.
.SUBCKT sar_sequencer CLK RST_B COMP_OUT PH_B9 PH_B8 PH_B7 PH_B6 PH_B5 PH_B4 PH_B3 PH_B2 PH_B1 PH_B0 PH_EOC PH_SAMPLE BUSY DOUT9 DOUT8 DOUT7 DOUT6 DOUT5 DOUT4 DOUT3 DOUT2 DOUT1 DOUT0
Mclkbuf_0_CLK_MMIN1 clkbuf_0_CLK_Ab CLK VGND VGND nfet L=0.15U W=0.65U
Mclkbuf_0_CLK_MMIN2 clknet_0_CLK clkbuf_0_CLK_Ab VGND VGND nfet L=0.15U W=0.65U
Mclkbuf_0_CLK_MMIP1 clkbuf_0_CLK_Ab CLK VPWR VPWR pfet L=0.15U W=1.0U
Mclkbuf_0_CLK_MMIP2 clknet_0_CLK clkbuf_0_CLK_Ab VPWR VPWR pfet L=0.15U W=1.0U
Mclkbuf_1_0__f_CLK_MMIN1 clkbuf_1_0__f_CLK_Ab clknet_0_CLK VGND VGND nfet L=0.15U W=0.65U
Mclkbuf_1_0__f_CLK_MMIN2 clknet_1_0__leaf_CLK clkbuf_1_0__f_CLK_Ab VGND VGND nfet L=0.15U W=0.65U
Mclkbuf_1_0__f_CLK_MMIP1 clkbuf_1_0__f_CLK_Ab clknet_0_CLK VPWR VPWR pfet L=0.15U W=1.0U
Mclkbuf_1_0__f_CLK_MMIP2 clknet_1_0__leaf_CLK clkbuf_1_0__f_CLK_Ab VPWR VPWR pfet L=0.15U W=1.0U
Mclkbuf_1_1__f_CLK_MMIN1 clkbuf_1_1__f_CLK_Ab clknet_0_CLK VGND VGND nfet L=0.15U W=0.65U
Mclkbuf_1_1__f_CLK_MMIN2 clknet_1_1__leaf_CLK clkbuf_1_1__f_CLK_Ab VGND VGND nfet L=0.15U W=0.65U
Mclkbuf_1_1__f_CLK_MMIP1 clkbuf_1_1__f_CLK_Ab clknet_0_CLK VPWR VPWR pfet L=0.15U W=1.0U
Mclkbuf_1_1__f_CLK_MMIP2 clknet_1_1__leaf_CLK clkbuf_1_1__f_CLK_Ab VPWR VPWR pfet L=0.15U W=1.0U
Mclkload0_MMIN1 clkload0_Y clknet_1_0__leaf_CLK VGND VGND nfet L=0.15U W=0.65U
Mclkload0_MMIP1 clkload0_Y clknet_1_0__leaf_CLK VPWR VPWR pfet L=0.15U W=1.0U
Mxbreg0_MI46 xbreg0_clkpos xbreg0_clkneg VGND VGND nfet L=0.15U W=0.42U
Mxbreg0_MI42 xbreg0_db xbreg0_clkneg xbreg0_M0 VGND nfet L=0.15U W=0.36U
Mxbreg0_MI656 xbreg0_net82 xbreg0_s0 xbreg0_net108 VGND nfet L=0.15U W=0.42U
Mxbreg0_MI657 xbreg0_net108 RST_B VGND VGND nfet L=0.15U W=0.42U
Mxbreg0_MI33 xbreg0_net101 RST_B VGND VGND nfet L=0.15U W=0.42U
Mxbreg0_MI4 xbreg0_M0 xbreg0_clkpos xbreg0_net93 VGND nfet L=0.15U W=0.36U
Mxbreg0_MI34 xbreg0_net93 xbreg0_M1 xbreg0_net101 VGND nfet L=0.15U W=0.42U
Mxbreg0_MI655 xbreg0_s0 xbreg0_clkneg xbreg0_net81 VGND nfet L=0.15U W=0.36U
Mxbreg0_MI653 DOUT0 xbreg0_net82 VGND VGND nfet L=0.15U W=0.65U
Mxbreg0_MI654 xbreg0_net81 xbreg0_net82 VGND VGND nfet L=0.15U W=0.42U
Mxbreg0_MI44 xbreg0_clkneg clknet_1_1__leaf_CLK VGND VGND nfet L=0.15U W=0.42U
Mxbreg0_MI647 xbreg0_M1 xbreg0_M0 VGND VGND nfet L=0.15U W=0.64U
Mxbreg0_MI39 xbreg0_db MUXOUT0 VGND VGND nfet L=0.15U W=0.42U
Mxbreg0_MI649 xbreg0_M1 xbreg0_clkpos xbreg0_s0 VGND nfet L=0.15U W=0.36U
Mxbreg0_MI47 xbreg0_clkpos xbreg0_clkneg VPWR VPWR pfet L=0.15U W=0.64U
Mxbreg0_MI43 xbreg0_db xbreg0_clkpos xbreg0_M0 VPWR pfet L=0.15U W=0.42U
Mxbreg0_MI662 xbreg0_net165 xbreg0_net82 VPWR VPWR pfet L=0.15U W=0.42U
Mxbreg0_MI659 xbreg0_net82 RST_B VPWR VPWR pfet L=0.15U W=0.42U
Mxbreg0_MI664 xbreg0_s0 xbreg0_clkpos xbreg0_net165 VPWR pfet L=0.15U W=0.42U
Mxbreg0_MI658 xbreg0_net82 xbreg0_s0 VPWR VPWR pfet L=0.15U W=0.42U
Mxbreg0_MI30 xbreg0_net144 xbreg0_M1 VPWR VPWR pfet L=0.15U W=0.42U
Mxbreg0_MI31 xbreg0_M0 xbreg0_clkneg xbreg0_net144 VPWR pfet L=0.15U W=0.42U
Mxbreg0_MI32 xbreg0_net144 RST_B VPWR VPWR pfet L=0.15U W=0.42U
Mxbreg0_MI660 DOUT0 xbreg0_net82 VPWR VPWR pfet L=0.15U W=1.0U
Mxbreg0_MI45 xbreg0_clkneg clknet_1_1__leaf_CLK VPWR VPWR pfet L=0.15U W=0.64U
Mxbreg0_MI648 xbreg0_M1 xbreg0_M0 VPWR VPWR pfet L=0.15U W=0.84U
Mxbreg0_MI40 xbreg0_db MUXOUT0 VPWR VPWR pfet L=0.15U W=0.42U
Mxbreg0_MI650 xbreg0_M1 xbreg0_clkneg xbreg0_s0 VPWR pfet L=0.15U W=0.42U
Mxbreg1_MI46 xbreg1_clkpos xbreg1_clkneg VGND VGND nfet L=0.15U W=0.42U
Mxbreg1_MI42 xbreg1_db xbreg1_clkneg xbreg1_M0 VGND nfet L=0.15U W=0.36U
Mxbreg1_MI656 xbreg1_net82 xbreg1_s0 xbreg1_net108 VGND nfet L=0.15U W=0.42U
Mxbreg1_MI657 xbreg1_net108 RST_B VGND VGND nfet L=0.15U W=0.42U
Mxbreg1_MI33 xbreg1_net101 RST_B VGND VGND nfet L=0.15U W=0.42U
Mxbreg1_MI4 xbreg1_M0 xbreg1_clkpos xbreg1_net93 VGND nfet L=0.15U W=0.36U
Mxbreg1_MI34 xbreg1_net93 xbreg1_M1 xbreg1_net101 VGND nfet L=0.15U W=0.42U
Mxbreg1_MI655 xbreg1_s0 xbreg1_clkneg xbreg1_net81 VGND nfet L=0.15U W=0.36U
Mxbreg1_MI653 DOUT1 xbreg1_net82 VGND VGND nfet L=0.15U W=0.65U
Mxbreg1_MI654 xbreg1_net81 xbreg1_net82 VGND VGND nfet L=0.15U W=0.42U
Mxbreg1_MI44 xbreg1_clkneg clknet_1_1__leaf_CLK VGND VGND nfet L=0.15U W=0.42U
Mxbreg1_MI647 xbreg1_M1 xbreg1_M0 VGND VGND nfet L=0.15U W=0.64U
Mxbreg1_MI39 xbreg1_db MUXOUT1 VGND VGND nfet L=0.15U W=0.42U
Mxbreg1_MI649 xbreg1_M1 xbreg1_clkpos xbreg1_s0 VGND nfet L=0.15U W=0.36U
Mxbreg1_MI47 xbreg1_clkpos xbreg1_clkneg VPWR VPWR pfet L=0.15U W=0.64U
Mxbreg1_MI43 xbreg1_db xbreg1_clkpos xbreg1_M0 VPWR pfet L=0.15U W=0.42U
Mxbreg1_MI662 xbreg1_net165 xbreg1_net82 VPWR VPWR pfet L=0.15U W=0.42U
Mxbreg1_MI659 xbreg1_net82 RST_B VPWR VPWR pfet L=0.15U W=0.42U
Mxbreg1_MI664 xbreg1_s0 xbreg1_clkpos xbreg1_net165 VPWR pfet L=0.15U W=0.42U
Mxbreg1_MI658 xbreg1_net82 xbreg1_s0 VPWR VPWR pfet L=0.15U W=0.42U
Mxbreg1_MI30 xbreg1_net144 xbreg1_M1 VPWR VPWR pfet L=0.15U W=0.42U
Mxbreg1_MI31 xbreg1_M0 xbreg1_clkneg xbreg1_net144 VPWR pfet L=0.15U W=0.42U
Mxbreg1_MI32 xbreg1_net144 RST_B VPWR VPWR pfet L=0.15U W=0.42U
Mxbreg1_MI660 DOUT1 xbreg1_net82 VPWR VPWR pfet L=0.15U W=1.0U
Mxbreg1_MI45 xbreg1_clkneg clknet_1_1__leaf_CLK VPWR VPWR pfet L=0.15U W=0.64U
Mxbreg1_MI648 xbreg1_M1 xbreg1_M0 VPWR VPWR pfet L=0.15U W=0.84U
Mxbreg1_MI40 xbreg1_db MUXOUT1 VPWR VPWR pfet L=0.15U W=0.42U
Mxbreg1_MI650 xbreg1_M1 xbreg1_clkneg xbreg1_s0 VPWR pfet L=0.15U W=0.42U
Mxbreg2_MI46 xbreg2_clkpos xbreg2_clkneg VGND VGND nfet L=0.15U W=0.42U
Mxbreg2_MI42 xbreg2_db xbreg2_clkneg xbreg2_M0 VGND nfet L=0.15U W=0.36U
Mxbreg2_MI656 xbreg2_net82 xbreg2_s0 xbreg2_net108 VGND nfet L=0.15U W=0.42U
Mxbreg2_MI657 xbreg2_net108 RST_B VGND VGND nfet L=0.15U W=0.42U
Mxbreg2_MI33 xbreg2_net101 RST_B VGND VGND nfet L=0.15U W=0.42U
Mxbreg2_MI4 xbreg2_M0 xbreg2_clkpos xbreg2_net93 VGND nfet L=0.15U W=0.36U
Mxbreg2_MI34 xbreg2_net93 xbreg2_M1 xbreg2_net101 VGND nfet L=0.15U W=0.42U
Mxbreg2_MI655 xbreg2_s0 xbreg2_clkneg xbreg2_net81 VGND nfet L=0.15U W=0.36U
Mxbreg2_MI653 DOUT2 xbreg2_net82 VGND VGND nfet L=0.15U W=0.65U
Mxbreg2_MI654 xbreg2_net81 xbreg2_net82 VGND VGND nfet L=0.15U W=0.42U
Mxbreg2_MI44 xbreg2_clkneg clknet_1_1__leaf_CLK VGND VGND nfet L=0.15U W=0.42U
Mxbreg2_MI647 xbreg2_M1 xbreg2_M0 VGND VGND nfet L=0.15U W=0.64U
Mxbreg2_MI39 xbreg2_db MUXOUT2 VGND VGND nfet L=0.15U W=0.42U
Mxbreg2_MI649 xbreg2_M1 xbreg2_clkpos xbreg2_s0 VGND nfet L=0.15U W=0.36U
Mxbreg2_MI47 xbreg2_clkpos xbreg2_clkneg VPWR VPWR pfet L=0.15U W=0.64U
Mxbreg2_MI43 xbreg2_db xbreg2_clkpos xbreg2_M0 VPWR pfet L=0.15U W=0.42U
Mxbreg2_MI662 xbreg2_net165 xbreg2_net82 VPWR VPWR pfet L=0.15U W=0.42U
Mxbreg2_MI659 xbreg2_net82 RST_B VPWR VPWR pfet L=0.15U W=0.42U
Mxbreg2_MI664 xbreg2_s0 xbreg2_clkpos xbreg2_net165 VPWR pfet L=0.15U W=0.42U
Mxbreg2_MI658 xbreg2_net82 xbreg2_s0 VPWR VPWR pfet L=0.15U W=0.42U
Mxbreg2_MI30 xbreg2_net144 xbreg2_M1 VPWR VPWR pfet L=0.15U W=0.42U
Mxbreg2_MI31 xbreg2_M0 xbreg2_clkneg xbreg2_net144 VPWR pfet L=0.15U W=0.42U
Mxbreg2_MI32 xbreg2_net144 RST_B VPWR VPWR pfet L=0.15U W=0.42U
Mxbreg2_MI660 DOUT2 xbreg2_net82 VPWR VPWR pfet L=0.15U W=1.0U
Mxbreg2_MI45 xbreg2_clkneg clknet_1_1__leaf_CLK VPWR VPWR pfet L=0.15U W=0.64U
Mxbreg2_MI648 xbreg2_M1 xbreg2_M0 VPWR VPWR pfet L=0.15U W=0.84U
Mxbreg2_MI40 xbreg2_db MUXOUT2 VPWR VPWR pfet L=0.15U W=0.42U
Mxbreg2_MI650 xbreg2_M1 xbreg2_clkneg xbreg2_s0 VPWR pfet L=0.15U W=0.42U
Mxbreg3_MI46 xbreg3_clkpos xbreg3_clkneg VGND VGND nfet L=0.15U W=0.42U
Mxbreg3_MI42 xbreg3_db xbreg3_clkneg xbreg3_M0 VGND nfet L=0.15U W=0.36U
Mxbreg3_MI656 xbreg3_net82 xbreg3_s0 xbreg3_net108 VGND nfet L=0.15U W=0.42U
Mxbreg3_MI657 xbreg3_net108 RST_B VGND VGND nfet L=0.15U W=0.42U
Mxbreg3_MI33 xbreg3_net101 RST_B VGND VGND nfet L=0.15U W=0.42U
Mxbreg3_MI4 xbreg3_M0 xbreg3_clkpos xbreg3_net93 VGND nfet L=0.15U W=0.36U
Mxbreg3_MI34 xbreg3_net93 xbreg3_M1 xbreg3_net101 VGND nfet L=0.15U W=0.42U
Mxbreg3_MI655 xbreg3_s0 xbreg3_clkneg xbreg3_net81 VGND nfet L=0.15U W=0.36U
Mxbreg3_MI653 DOUT3 xbreg3_net82 VGND VGND nfet L=0.15U W=0.65U
Mxbreg3_MI654 xbreg3_net81 xbreg3_net82 VGND VGND nfet L=0.15U W=0.42U
Mxbreg3_MI44 xbreg3_clkneg clknet_1_1__leaf_CLK VGND VGND nfet L=0.15U W=0.42U
Mxbreg3_MI647 xbreg3_M1 xbreg3_M0 VGND VGND nfet L=0.15U W=0.64U
Mxbreg3_MI39 xbreg3_db MUXOUT3 VGND VGND nfet L=0.15U W=0.42U
Mxbreg3_MI649 xbreg3_M1 xbreg3_clkpos xbreg3_s0 VGND nfet L=0.15U W=0.36U
Mxbreg3_MI47 xbreg3_clkpos xbreg3_clkneg VPWR VPWR pfet L=0.15U W=0.64U
Mxbreg3_MI43 xbreg3_db xbreg3_clkpos xbreg3_M0 VPWR pfet L=0.15U W=0.42U
Mxbreg3_MI662 xbreg3_net165 xbreg3_net82 VPWR VPWR pfet L=0.15U W=0.42U
Mxbreg3_MI659 xbreg3_net82 RST_B VPWR VPWR pfet L=0.15U W=0.42U
Mxbreg3_MI664 xbreg3_s0 xbreg3_clkpos xbreg3_net165 VPWR pfet L=0.15U W=0.42U
Mxbreg3_MI658 xbreg3_net82 xbreg3_s0 VPWR VPWR pfet L=0.15U W=0.42U
Mxbreg3_MI30 xbreg3_net144 xbreg3_M1 VPWR VPWR pfet L=0.15U W=0.42U
Mxbreg3_MI31 xbreg3_M0 xbreg3_clkneg xbreg3_net144 VPWR pfet L=0.15U W=0.42U
Mxbreg3_MI32 xbreg3_net144 RST_B VPWR VPWR pfet L=0.15U W=0.42U
Mxbreg3_MI660 DOUT3 xbreg3_net82 VPWR VPWR pfet L=0.15U W=1.0U
Mxbreg3_MI45 xbreg3_clkneg clknet_1_1__leaf_CLK VPWR VPWR pfet L=0.15U W=0.64U
Mxbreg3_MI648 xbreg3_M1 xbreg3_M0 VPWR VPWR pfet L=0.15U W=0.84U
Mxbreg3_MI40 xbreg3_db MUXOUT3 VPWR VPWR pfet L=0.15U W=0.42U
Mxbreg3_MI650 xbreg3_M1 xbreg3_clkneg xbreg3_s0 VPWR pfet L=0.15U W=0.42U
Mxbreg4_MI46 xbreg4_clkpos xbreg4_clkneg VGND VGND nfet L=0.15U W=0.42U
Mxbreg4_MI42 xbreg4_db xbreg4_clkneg xbreg4_M0 VGND nfet L=0.15U W=0.36U
Mxbreg4_MI656 xbreg4_net82 xbreg4_s0 xbreg4_net108 VGND nfet L=0.15U W=0.42U
Mxbreg4_MI657 xbreg4_net108 RST_B VGND VGND nfet L=0.15U W=0.42U
Mxbreg4_MI33 xbreg4_net101 RST_B VGND VGND nfet L=0.15U W=0.42U
Mxbreg4_MI4 xbreg4_M0 xbreg4_clkpos xbreg4_net93 VGND nfet L=0.15U W=0.36U
Mxbreg4_MI34 xbreg4_net93 xbreg4_M1 xbreg4_net101 VGND nfet L=0.15U W=0.42U
Mxbreg4_MI655 xbreg4_s0 xbreg4_clkneg xbreg4_net81 VGND nfet L=0.15U W=0.36U
Mxbreg4_MI653 DOUT4 xbreg4_net82 VGND VGND nfet L=0.15U W=0.65U
Mxbreg4_MI654 xbreg4_net81 xbreg4_net82 VGND VGND nfet L=0.15U W=0.42U
Mxbreg4_MI44 xbreg4_clkneg clknet_1_1__leaf_CLK VGND VGND nfet L=0.15U W=0.42U
Mxbreg4_MI647 xbreg4_M1 xbreg4_M0 VGND VGND nfet L=0.15U W=0.64U
Mxbreg4_MI39 xbreg4_db MUXOUT4 VGND VGND nfet L=0.15U W=0.42U
Mxbreg4_MI649 xbreg4_M1 xbreg4_clkpos xbreg4_s0 VGND nfet L=0.15U W=0.36U
Mxbreg4_MI47 xbreg4_clkpos xbreg4_clkneg VPWR VPWR pfet L=0.15U W=0.64U
Mxbreg4_MI43 xbreg4_db xbreg4_clkpos xbreg4_M0 VPWR pfet L=0.15U W=0.42U
Mxbreg4_MI662 xbreg4_net165 xbreg4_net82 VPWR VPWR pfet L=0.15U W=0.42U
Mxbreg4_MI659 xbreg4_net82 RST_B VPWR VPWR pfet L=0.15U W=0.42U
Mxbreg4_MI664 xbreg4_s0 xbreg4_clkpos xbreg4_net165 VPWR pfet L=0.15U W=0.42U
Mxbreg4_MI658 xbreg4_net82 xbreg4_s0 VPWR VPWR pfet L=0.15U W=0.42U
Mxbreg4_MI30 xbreg4_net144 xbreg4_M1 VPWR VPWR pfet L=0.15U W=0.42U
Mxbreg4_MI31 xbreg4_M0 xbreg4_clkneg xbreg4_net144 VPWR pfet L=0.15U W=0.42U
Mxbreg4_MI32 xbreg4_net144 RST_B VPWR VPWR pfet L=0.15U W=0.42U
Mxbreg4_MI660 DOUT4 xbreg4_net82 VPWR VPWR pfet L=0.15U W=1.0U
Mxbreg4_MI45 xbreg4_clkneg clknet_1_1__leaf_CLK VPWR VPWR pfet L=0.15U W=0.64U
Mxbreg4_MI648 xbreg4_M1 xbreg4_M0 VPWR VPWR pfet L=0.15U W=0.84U
Mxbreg4_MI40 xbreg4_db MUXOUT4 VPWR VPWR pfet L=0.15U W=0.42U
Mxbreg4_MI650 xbreg4_M1 xbreg4_clkneg xbreg4_s0 VPWR pfet L=0.15U W=0.42U
Mxbreg5_MI46 xbreg5_clkpos xbreg5_clkneg VGND VGND nfet L=0.15U W=0.42U
Mxbreg5_MI42 xbreg5_db xbreg5_clkneg xbreg5_M0 VGND nfet L=0.15U W=0.36U
Mxbreg5_MI656 xbreg5_net82 xbreg5_s0 xbreg5_net108 VGND nfet L=0.15U W=0.42U
Mxbreg5_MI657 xbreg5_net108 RST_B VGND VGND nfet L=0.15U W=0.42U
Mxbreg5_MI33 xbreg5_net101 RST_B VGND VGND nfet L=0.15U W=0.42U
Mxbreg5_MI4 xbreg5_M0 xbreg5_clkpos xbreg5_net93 VGND nfet L=0.15U W=0.36U
Mxbreg5_MI34 xbreg5_net93 xbreg5_M1 xbreg5_net101 VGND nfet L=0.15U W=0.42U
Mxbreg5_MI655 xbreg5_s0 xbreg5_clkneg xbreg5_net81 VGND nfet L=0.15U W=0.36U
Mxbreg5_MI653 DOUT5 xbreg5_net82 VGND VGND nfet L=0.15U W=0.65U
Mxbreg5_MI654 xbreg5_net81 xbreg5_net82 VGND VGND nfet L=0.15U W=0.42U
Mxbreg5_MI44 xbreg5_clkneg clknet_1_0__leaf_CLK VGND VGND nfet L=0.15U W=0.42U
Mxbreg5_MI647 xbreg5_M1 xbreg5_M0 VGND VGND nfet L=0.15U W=0.64U
Mxbreg5_MI39 xbreg5_db MUXOUT5 VGND VGND nfet L=0.15U W=0.42U
Mxbreg5_MI649 xbreg5_M1 xbreg5_clkpos xbreg5_s0 VGND nfet L=0.15U W=0.36U
Mxbreg5_MI47 xbreg5_clkpos xbreg5_clkneg VPWR VPWR pfet L=0.15U W=0.64U
Mxbreg5_MI43 xbreg5_db xbreg5_clkpos xbreg5_M0 VPWR pfet L=0.15U W=0.42U
Mxbreg5_MI662 xbreg5_net165 xbreg5_net82 VPWR VPWR pfet L=0.15U W=0.42U
Mxbreg5_MI659 xbreg5_net82 RST_B VPWR VPWR pfet L=0.15U W=0.42U
Mxbreg5_MI664 xbreg5_s0 xbreg5_clkpos xbreg5_net165 VPWR pfet L=0.15U W=0.42U
Mxbreg5_MI658 xbreg5_net82 xbreg5_s0 VPWR VPWR pfet L=0.15U W=0.42U
Mxbreg5_MI30 xbreg5_net144 xbreg5_M1 VPWR VPWR pfet L=0.15U W=0.42U
Mxbreg5_MI31 xbreg5_M0 xbreg5_clkneg xbreg5_net144 VPWR pfet L=0.15U W=0.42U
Mxbreg5_MI32 xbreg5_net144 RST_B VPWR VPWR pfet L=0.15U W=0.42U
Mxbreg5_MI660 DOUT5 xbreg5_net82 VPWR VPWR pfet L=0.15U W=1.0U
Mxbreg5_MI45 xbreg5_clkneg clknet_1_0__leaf_CLK VPWR VPWR pfet L=0.15U W=0.64U
Mxbreg5_MI648 xbreg5_M1 xbreg5_M0 VPWR VPWR pfet L=0.15U W=0.84U
Mxbreg5_MI40 xbreg5_db MUXOUT5 VPWR VPWR pfet L=0.15U W=0.42U
Mxbreg5_MI650 xbreg5_M1 xbreg5_clkneg xbreg5_s0 VPWR pfet L=0.15U W=0.42U
Mxbreg6_MI46 xbreg6_clkpos xbreg6_clkneg VGND VGND nfet L=0.15U W=0.42U
Mxbreg6_MI42 xbreg6_db xbreg6_clkneg xbreg6_M0 VGND nfet L=0.15U W=0.36U
Mxbreg6_MI656 xbreg6_net82 xbreg6_s0 xbreg6_net108 VGND nfet L=0.15U W=0.42U
Mxbreg6_MI657 xbreg6_net108 RST_B VGND VGND nfet L=0.15U W=0.42U
Mxbreg6_MI33 xbreg6_net101 RST_B VGND VGND nfet L=0.15U W=0.42U
Mxbreg6_MI4 xbreg6_M0 xbreg6_clkpos xbreg6_net93 VGND nfet L=0.15U W=0.36U
Mxbreg6_MI34 xbreg6_net93 xbreg6_M1 xbreg6_net101 VGND nfet L=0.15U W=0.42U
Mxbreg6_MI655 xbreg6_s0 xbreg6_clkneg xbreg6_net81 VGND nfet L=0.15U W=0.36U
Mxbreg6_MI653 DOUT6 xbreg6_net82 VGND VGND nfet L=0.15U W=0.65U
Mxbreg6_MI654 xbreg6_net81 xbreg6_net82 VGND VGND nfet L=0.15U W=0.42U
Mxbreg6_MI44 xbreg6_clkneg clknet_1_0__leaf_CLK VGND VGND nfet L=0.15U W=0.42U
Mxbreg6_MI647 xbreg6_M1 xbreg6_M0 VGND VGND nfet L=0.15U W=0.64U
Mxbreg6_MI39 xbreg6_db MUXOUT6 VGND VGND nfet L=0.15U W=0.42U
Mxbreg6_MI649 xbreg6_M1 xbreg6_clkpos xbreg6_s0 VGND nfet L=0.15U W=0.36U
Mxbreg6_MI47 xbreg6_clkpos xbreg6_clkneg VPWR VPWR pfet L=0.15U W=0.64U
Mxbreg6_MI43 xbreg6_db xbreg6_clkpos xbreg6_M0 VPWR pfet L=0.15U W=0.42U
Mxbreg6_MI662 xbreg6_net165 xbreg6_net82 VPWR VPWR pfet L=0.15U W=0.42U
Mxbreg6_MI659 xbreg6_net82 RST_B VPWR VPWR pfet L=0.15U W=0.42U
Mxbreg6_MI664 xbreg6_s0 xbreg6_clkpos xbreg6_net165 VPWR pfet L=0.15U W=0.42U
Mxbreg6_MI658 xbreg6_net82 xbreg6_s0 VPWR VPWR pfet L=0.15U W=0.42U
Mxbreg6_MI30 xbreg6_net144 xbreg6_M1 VPWR VPWR pfet L=0.15U W=0.42U
Mxbreg6_MI31 xbreg6_M0 xbreg6_clkneg xbreg6_net144 VPWR pfet L=0.15U W=0.42U
Mxbreg6_MI32 xbreg6_net144 RST_B VPWR VPWR pfet L=0.15U W=0.42U
Mxbreg6_MI660 DOUT6 xbreg6_net82 VPWR VPWR pfet L=0.15U W=1.0U
Mxbreg6_MI45 xbreg6_clkneg clknet_1_0__leaf_CLK VPWR VPWR pfet L=0.15U W=0.64U
Mxbreg6_MI648 xbreg6_M1 xbreg6_M0 VPWR VPWR pfet L=0.15U W=0.84U
Mxbreg6_MI40 xbreg6_db MUXOUT6 VPWR VPWR pfet L=0.15U W=0.42U
Mxbreg6_MI650 xbreg6_M1 xbreg6_clkneg xbreg6_s0 VPWR pfet L=0.15U W=0.42U
Mxbreg7_MI46 xbreg7_clkpos xbreg7_clkneg VGND VGND nfet L=0.15U W=0.42U
Mxbreg7_MI42 xbreg7_db xbreg7_clkneg xbreg7_M0 VGND nfet L=0.15U W=0.36U
Mxbreg7_MI656 xbreg7_net82 xbreg7_s0 xbreg7_net108 VGND nfet L=0.15U W=0.42U
Mxbreg7_MI657 xbreg7_net108 RST_B VGND VGND nfet L=0.15U W=0.42U
Mxbreg7_MI33 xbreg7_net101 RST_B VGND VGND nfet L=0.15U W=0.42U
Mxbreg7_MI4 xbreg7_M0 xbreg7_clkpos xbreg7_net93 VGND nfet L=0.15U W=0.36U
Mxbreg7_MI34 xbreg7_net93 xbreg7_M1 xbreg7_net101 VGND nfet L=0.15U W=0.42U
Mxbreg7_MI655 xbreg7_s0 xbreg7_clkneg xbreg7_net81 VGND nfet L=0.15U W=0.36U
Mxbreg7_MI653 DOUT7 xbreg7_net82 VGND VGND nfet L=0.15U W=0.65U
Mxbreg7_MI654 xbreg7_net81 xbreg7_net82 VGND VGND nfet L=0.15U W=0.42U
Mxbreg7_MI44 xbreg7_clkneg clknet_1_0__leaf_CLK VGND VGND nfet L=0.15U W=0.42U
Mxbreg7_MI647 xbreg7_M1 xbreg7_M0 VGND VGND nfet L=0.15U W=0.64U
Mxbreg7_MI39 xbreg7_db MUXOUT7 VGND VGND nfet L=0.15U W=0.42U
Mxbreg7_MI649 xbreg7_M1 xbreg7_clkpos xbreg7_s0 VGND nfet L=0.15U W=0.36U
Mxbreg7_MI47 xbreg7_clkpos xbreg7_clkneg VPWR VPWR pfet L=0.15U W=0.64U
Mxbreg7_MI43 xbreg7_db xbreg7_clkpos xbreg7_M0 VPWR pfet L=0.15U W=0.42U
Mxbreg7_MI662 xbreg7_net165 xbreg7_net82 VPWR VPWR pfet L=0.15U W=0.42U
Mxbreg7_MI659 xbreg7_net82 RST_B VPWR VPWR pfet L=0.15U W=0.42U
Mxbreg7_MI664 xbreg7_s0 xbreg7_clkpos xbreg7_net165 VPWR pfet L=0.15U W=0.42U
Mxbreg7_MI658 xbreg7_net82 xbreg7_s0 VPWR VPWR pfet L=0.15U W=0.42U
Mxbreg7_MI30 xbreg7_net144 xbreg7_M1 VPWR VPWR pfet L=0.15U W=0.42U
Mxbreg7_MI31 xbreg7_M0 xbreg7_clkneg xbreg7_net144 VPWR pfet L=0.15U W=0.42U
Mxbreg7_MI32 xbreg7_net144 RST_B VPWR VPWR pfet L=0.15U W=0.42U
Mxbreg7_MI660 DOUT7 xbreg7_net82 VPWR VPWR pfet L=0.15U W=1.0U
Mxbreg7_MI45 xbreg7_clkneg clknet_1_0__leaf_CLK VPWR VPWR pfet L=0.15U W=0.64U
Mxbreg7_MI648 xbreg7_M1 xbreg7_M0 VPWR VPWR pfet L=0.15U W=0.84U
Mxbreg7_MI40 xbreg7_db MUXOUT7 VPWR VPWR pfet L=0.15U W=0.42U
Mxbreg7_MI650 xbreg7_M1 xbreg7_clkneg xbreg7_s0 VPWR pfet L=0.15U W=0.42U
Mxbreg8_MI46 xbreg8_clkpos xbreg8_clkneg VGND VGND nfet L=0.15U W=0.42U
Mxbreg8_MI42 xbreg8_db xbreg8_clkneg xbreg8_M0 VGND nfet L=0.15U W=0.36U
Mxbreg8_MI656 xbreg8_net82 xbreg8_s0 xbreg8_net108 VGND nfet L=0.15U W=0.42U
Mxbreg8_MI657 xbreg8_net108 RST_B VGND VGND nfet L=0.15U W=0.42U
Mxbreg8_MI33 xbreg8_net101 RST_B VGND VGND nfet L=0.15U W=0.42U
Mxbreg8_MI4 xbreg8_M0 xbreg8_clkpos xbreg8_net93 VGND nfet L=0.15U W=0.36U
Mxbreg8_MI34 xbreg8_net93 xbreg8_M1 xbreg8_net101 VGND nfet L=0.15U W=0.42U
Mxbreg8_MI655 xbreg8_s0 xbreg8_clkneg xbreg8_net81 VGND nfet L=0.15U W=0.36U
Mxbreg8_MI653 DOUT8 xbreg8_net82 VGND VGND nfet L=0.15U W=0.65U
Mxbreg8_MI654 xbreg8_net81 xbreg8_net82 VGND VGND nfet L=0.15U W=0.42U
Mxbreg8_MI44 xbreg8_clkneg clknet_1_1__leaf_CLK VGND VGND nfet L=0.15U W=0.42U
Mxbreg8_MI647 xbreg8_M1 xbreg8_M0 VGND VGND nfet L=0.15U W=0.64U
Mxbreg8_MI39 xbreg8_db MUXOUT8 VGND VGND nfet L=0.15U W=0.42U
Mxbreg8_MI649 xbreg8_M1 xbreg8_clkpos xbreg8_s0 VGND nfet L=0.15U W=0.36U
Mxbreg8_MI47 xbreg8_clkpos xbreg8_clkneg VPWR VPWR pfet L=0.15U W=0.64U
Mxbreg8_MI43 xbreg8_db xbreg8_clkpos xbreg8_M0 VPWR pfet L=0.15U W=0.42U
Mxbreg8_MI662 xbreg8_net165 xbreg8_net82 VPWR VPWR pfet L=0.15U W=0.42U
Mxbreg8_MI659 xbreg8_net82 RST_B VPWR VPWR pfet L=0.15U W=0.42U
Mxbreg8_MI664 xbreg8_s0 xbreg8_clkpos xbreg8_net165 VPWR pfet L=0.15U W=0.42U
Mxbreg8_MI658 xbreg8_net82 xbreg8_s0 VPWR VPWR pfet L=0.15U W=0.42U
Mxbreg8_MI30 xbreg8_net144 xbreg8_M1 VPWR VPWR pfet L=0.15U W=0.42U
Mxbreg8_MI31 xbreg8_M0 xbreg8_clkneg xbreg8_net144 VPWR pfet L=0.15U W=0.42U
Mxbreg8_MI32 xbreg8_net144 RST_B VPWR VPWR pfet L=0.15U W=0.42U
Mxbreg8_MI660 DOUT8 xbreg8_net82 VPWR VPWR pfet L=0.15U W=1.0U
Mxbreg8_MI45 xbreg8_clkneg clknet_1_1__leaf_CLK VPWR VPWR pfet L=0.15U W=0.64U
Mxbreg8_MI648 xbreg8_M1 xbreg8_M0 VPWR VPWR pfet L=0.15U W=0.84U
Mxbreg8_MI40 xbreg8_db MUXOUT8 VPWR VPWR pfet L=0.15U W=0.42U
Mxbreg8_MI650 xbreg8_M1 xbreg8_clkneg xbreg8_s0 VPWR pfet L=0.15U W=0.42U
Mxbreg9_MI46 xbreg9_clkpos xbreg9_clkneg VGND VGND nfet L=0.15U W=0.42U
Mxbreg9_MI42 xbreg9_db xbreg9_clkneg xbreg9_M0 VGND nfet L=0.15U W=0.36U
Mxbreg9_MI656 xbreg9_net82 xbreg9_s0 xbreg9_net108 VGND nfet L=0.15U W=0.42U
Mxbreg9_MI657 xbreg9_net108 RST_B VGND VGND nfet L=0.15U W=0.42U
Mxbreg9_MI33 xbreg9_net101 RST_B VGND VGND nfet L=0.15U W=0.42U
Mxbreg9_MI4 xbreg9_M0 xbreg9_clkpos xbreg9_net93 VGND nfet L=0.15U W=0.36U
Mxbreg9_MI34 xbreg9_net93 xbreg9_M1 xbreg9_net101 VGND nfet L=0.15U W=0.42U
Mxbreg9_MI655 xbreg9_s0 xbreg9_clkneg xbreg9_net81 VGND nfet L=0.15U W=0.36U
Mxbreg9_MI653 DOUT9 xbreg9_net82 VGND VGND nfet L=0.15U W=0.65U
Mxbreg9_MI654 xbreg9_net81 xbreg9_net82 VGND VGND nfet L=0.15U W=0.42U
Mxbreg9_MI44 xbreg9_clkneg clknet_1_0__leaf_CLK VGND VGND nfet L=0.15U W=0.42U
Mxbreg9_MI647 xbreg9_M1 xbreg9_M0 VGND VGND nfet L=0.15U W=0.64U
Mxbreg9_MI39 xbreg9_db MUXOUT9 VGND VGND nfet L=0.15U W=0.42U
Mxbreg9_MI649 xbreg9_M1 xbreg9_clkpos xbreg9_s0 VGND nfet L=0.15U W=0.36U
Mxbreg9_MI47 xbreg9_clkpos xbreg9_clkneg VPWR VPWR pfet L=0.15U W=0.64U
Mxbreg9_MI43 xbreg9_db xbreg9_clkpos xbreg9_M0 VPWR pfet L=0.15U W=0.42U
Mxbreg9_MI662 xbreg9_net165 xbreg9_net82 VPWR VPWR pfet L=0.15U W=0.42U
Mxbreg9_MI659 xbreg9_net82 RST_B VPWR VPWR pfet L=0.15U W=0.42U
Mxbreg9_MI664 xbreg9_s0 xbreg9_clkpos xbreg9_net165 VPWR pfet L=0.15U W=0.42U
Mxbreg9_MI658 xbreg9_net82 xbreg9_s0 VPWR VPWR pfet L=0.15U W=0.42U
Mxbreg9_MI30 xbreg9_net144 xbreg9_M1 VPWR VPWR pfet L=0.15U W=0.42U
Mxbreg9_MI31 xbreg9_M0 xbreg9_clkneg xbreg9_net144 VPWR pfet L=0.15U W=0.42U
Mxbreg9_MI32 xbreg9_net144 RST_B VPWR VPWR pfet L=0.15U W=0.42U
Mxbreg9_MI660 DOUT9 xbreg9_net82 VPWR VPWR pfet L=0.15U W=1.0U
Mxbreg9_MI45 xbreg9_clkneg clknet_1_0__leaf_CLK VPWR VPWR pfet L=0.15U W=0.64U
Mxbreg9_MI648 xbreg9_M1 xbreg9_M0 VPWR VPWR pfet L=0.15U W=0.84U
Mxbreg9_MI40 xbreg9_db MUXOUT9 VPWR VPWR pfet L=0.15U W=0.42U
Mxbreg9_MI650 xbreg9_M1 xbreg9_clkneg xbreg9_s0 VPWR pfet L=0.15U W=0.42U
Mxinv_sample_MMIN1 PH_SAMPLE BUSY VGND VGND nfet L=0.15U W=0.65U
Mxinv_sample_MMIP1 PH_SAMPLE BUSY VPWR VPWR pfet L=0.15U W=1.0U
Mxmux0_MMNA00 xmux0_xb DOUT0 xmux0_smdNA0 VGND nfet L=0.15U W=0.42U
Mxmux0_MMNA01 xmux0_smdNA0 xmux0_Sb VGND VGND nfet L=0.15U W=0.42U
Mxmux0_MMNA10 xmux0_xb COMP_OUT xmux0_sndNA1 VGND nfet L=0.15U W=0.42U
Mxmux0_MMNA11 xmux0_sndNA1 PH_B0 VGND VGND nfet L=0.15U W=0.42U
Mxmux0_MMIN1 xmux0_Sb PH_B0 VGND VGND nfet L=0.15U W=0.42U
Mxmux0_MMIN2 MUXOUT0 xmux0_xb VGND VGND nfet L=0.15U W=0.65U
Mxmux0_MMPA00 VPWR PH_B0 xmux0_sndPS VPWR pfet L=0.15U W=0.42U
Mxmux0_MMPA01 xmux0_sndPS DOUT0 xmux0_xb VPWR pfet L=0.15U W=0.42U
Mxmux0_MMPA10 VPWR xmux0_Sb xmux0_sndPSb VPWR pfet L=0.15U W=0.42U
Mxmux0_MMPA11 xmux0_sndPSb COMP_OUT xmux0_xb VPWR pfet L=0.15U W=0.42U
Mxmux0_MMIP1 xmux0_Sb PH_B0 VPWR VPWR pfet L=0.15U W=0.42U
Mxmux0_MMIP2 MUXOUT0 xmux0_xb VPWR VPWR pfet L=0.15U W=1.0U
Mxmux1_MMNA00 xmux1_xb DOUT1 xmux1_smdNA0 VGND nfet L=0.15U W=0.42U
Mxmux1_MMNA01 xmux1_smdNA0 xmux1_Sb VGND VGND nfet L=0.15U W=0.42U
Mxmux1_MMNA10 xmux1_xb COMP_OUT xmux1_sndNA1 VGND nfet L=0.15U W=0.42U
Mxmux1_MMNA11 xmux1_sndNA1 PH_B1 VGND VGND nfet L=0.15U W=0.42U
Mxmux1_MMIN1 xmux1_Sb PH_B1 VGND VGND nfet L=0.15U W=0.42U
Mxmux1_MMIN2 MUXOUT1 xmux1_xb VGND VGND nfet L=0.15U W=0.65U
Mxmux1_MMPA00 VPWR PH_B1 xmux1_sndPS VPWR pfet L=0.15U W=0.42U
Mxmux1_MMPA01 xmux1_sndPS DOUT1 xmux1_xb VPWR pfet L=0.15U W=0.42U
Mxmux1_MMPA10 VPWR xmux1_Sb xmux1_sndPSb VPWR pfet L=0.15U W=0.42U
Mxmux1_MMPA11 xmux1_sndPSb COMP_OUT xmux1_xb VPWR pfet L=0.15U W=0.42U
Mxmux1_MMIP1 xmux1_Sb PH_B1 VPWR VPWR pfet L=0.15U W=0.42U
Mxmux1_MMIP2 MUXOUT1 xmux1_xb VPWR VPWR pfet L=0.15U W=1.0U
Mxmux2_MMNA00 xmux2_xb DOUT2 xmux2_smdNA0 VGND nfet L=0.15U W=0.42U
Mxmux2_MMNA01 xmux2_smdNA0 xmux2_Sb VGND VGND nfet L=0.15U W=0.42U
Mxmux2_MMNA10 xmux2_xb COMP_OUT xmux2_sndNA1 VGND nfet L=0.15U W=0.42U
Mxmux2_MMNA11 xmux2_sndNA1 PH_B2 VGND VGND nfet L=0.15U W=0.42U
Mxmux2_MMIN1 xmux2_Sb PH_B2 VGND VGND nfet L=0.15U W=0.42U
Mxmux2_MMIN2 MUXOUT2 xmux2_xb VGND VGND nfet L=0.15U W=0.65U
Mxmux2_MMPA00 VPWR PH_B2 xmux2_sndPS VPWR pfet L=0.15U W=0.42U
Mxmux2_MMPA01 xmux2_sndPS DOUT2 xmux2_xb VPWR pfet L=0.15U W=0.42U
Mxmux2_MMPA10 VPWR xmux2_Sb xmux2_sndPSb VPWR pfet L=0.15U W=0.42U
Mxmux2_MMPA11 xmux2_sndPSb COMP_OUT xmux2_xb VPWR pfet L=0.15U W=0.42U
Mxmux2_MMIP1 xmux2_Sb PH_B2 VPWR VPWR pfet L=0.15U W=0.42U
Mxmux2_MMIP2 MUXOUT2 xmux2_xb VPWR VPWR pfet L=0.15U W=1.0U
Mxmux3_MMNA00 xmux3_xb DOUT3 xmux3_smdNA0 VGND nfet L=0.15U W=0.42U
Mxmux3_MMNA01 xmux3_smdNA0 xmux3_Sb VGND VGND nfet L=0.15U W=0.42U
Mxmux3_MMNA10 xmux3_xb COMP_OUT xmux3_sndNA1 VGND nfet L=0.15U W=0.42U
Mxmux3_MMNA11 xmux3_sndNA1 PH_B3 VGND VGND nfet L=0.15U W=0.42U
Mxmux3_MMIN1 xmux3_Sb PH_B3 VGND VGND nfet L=0.15U W=0.42U
Mxmux3_MMIN2 MUXOUT3 xmux3_xb VGND VGND nfet L=0.15U W=0.65U
Mxmux3_MMPA00 VPWR PH_B3 xmux3_sndPS VPWR pfet L=0.15U W=0.42U
Mxmux3_MMPA01 xmux3_sndPS DOUT3 xmux3_xb VPWR pfet L=0.15U W=0.42U
Mxmux3_MMPA10 VPWR xmux3_Sb xmux3_sndPSb VPWR pfet L=0.15U W=0.42U
Mxmux3_MMPA11 xmux3_sndPSb COMP_OUT xmux3_xb VPWR pfet L=0.15U W=0.42U
Mxmux3_MMIP1 xmux3_Sb PH_B3 VPWR VPWR pfet L=0.15U W=0.42U
Mxmux3_MMIP2 MUXOUT3 xmux3_xb VPWR VPWR pfet L=0.15U W=1.0U
Mxmux4_MMNA00 xmux4_xb DOUT4 xmux4_smdNA0 VGND nfet L=0.15U W=0.42U
Mxmux4_MMNA01 xmux4_smdNA0 xmux4_Sb VGND VGND nfet L=0.15U W=0.42U
Mxmux4_MMNA10 xmux4_xb COMP_OUT xmux4_sndNA1 VGND nfet L=0.15U W=0.42U
Mxmux4_MMNA11 xmux4_sndNA1 PH_B4 VGND VGND nfet L=0.15U W=0.42U
Mxmux4_MMIN1 xmux4_Sb PH_B4 VGND VGND nfet L=0.15U W=0.42U
Mxmux4_MMIN2 MUXOUT4 xmux4_xb VGND VGND nfet L=0.15U W=0.65U
Mxmux4_MMPA00 VPWR PH_B4 xmux4_sndPS VPWR pfet L=0.15U W=0.42U
Mxmux4_MMPA01 xmux4_sndPS DOUT4 xmux4_xb VPWR pfet L=0.15U W=0.42U
Mxmux4_MMPA10 VPWR xmux4_Sb xmux4_sndPSb VPWR pfet L=0.15U W=0.42U
Mxmux4_MMPA11 xmux4_sndPSb COMP_OUT xmux4_xb VPWR pfet L=0.15U W=0.42U
Mxmux4_MMIP1 xmux4_Sb PH_B4 VPWR VPWR pfet L=0.15U W=0.42U
Mxmux4_MMIP2 MUXOUT4 xmux4_xb VPWR VPWR pfet L=0.15U W=1.0U
Mxmux5_MMNA00 xmux5_xb DOUT5 xmux5_smdNA0 VGND nfet L=0.15U W=0.42U
Mxmux5_MMNA01 xmux5_smdNA0 xmux5_Sb VGND VGND nfet L=0.15U W=0.42U
Mxmux5_MMNA10 xmux5_xb COMP_OUT xmux5_sndNA1 VGND nfet L=0.15U W=0.42U
Mxmux5_MMNA11 xmux5_sndNA1 PH_B5 VGND VGND nfet L=0.15U W=0.42U
Mxmux5_MMIN1 xmux5_Sb PH_B5 VGND VGND nfet L=0.15U W=0.42U
Mxmux5_MMIN2 MUXOUT5 xmux5_xb VGND VGND nfet L=0.15U W=0.65U
Mxmux5_MMPA00 VPWR PH_B5 xmux5_sndPS VPWR pfet L=0.15U W=0.42U
Mxmux5_MMPA01 xmux5_sndPS DOUT5 xmux5_xb VPWR pfet L=0.15U W=0.42U
Mxmux5_MMPA10 VPWR xmux5_Sb xmux5_sndPSb VPWR pfet L=0.15U W=0.42U
Mxmux5_MMPA11 xmux5_sndPSb COMP_OUT xmux5_xb VPWR pfet L=0.15U W=0.42U
Mxmux5_MMIP1 xmux5_Sb PH_B5 VPWR VPWR pfet L=0.15U W=0.42U
Mxmux5_MMIP2 MUXOUT5 xmux5_xb VPWR VPWR pfet L=0.15U W=1.0U
Mxmux6_MMNA00 xmux6_xb DOUT6 xmux6_smdNA0 VGND nfet L=0.15U W=0.42U
Mxmux6_MMNA01 xmux6_smdNA0 xmux6_Sb VGND VGND nfet L=0.15U W=0.42U
Mxmux6_MMNA10 xmux6_xb COMP_OUT xmux6_sndNA1 VGND nfet L=0.15U W=0.42U
Mxmux6_MMNA11 xmux6_sndNA1 PH_B6 VGND VGND nfet L=0.15U W=0.42U
Mxmux6_MMIN1 xmux6_Sb PH_B6 VGND VGND nfet L=0.15U W=0.42U
Mxmux6_MMIN2 MUXOUT6 xmux6_xb VGND VGND nfet L=0.15U W=0.65U
Mxmux6_MMPA00 VPWR PH_B6 xmux6_sndPS VPWR pfet L=0.15U W=0.42U
Mxmux6_MMPA01 xmux6_sndPS DOUT6 xmux6_xb VPWR pfet L=0.15U W=0.42U
Mxmux6_MMPA10 VPWR xmux6_Sb xmux6_sndPSb VPWR pfet L=0.15U W=0.42U
Mxmux6_MMPA11 xmux6_sndPSb COMP_OUT xmux6_xb VPWR pfet L=0.15U W=0.42U
Mxmux6_MMIP1 xmux6_Sb PH_B6 VPWR VPWR pfet L=0.15U W=0.42U
Mxmux6_MMIP2 MUXOUT6 xmux6_xb VPWR VPWR pfet L=0.15U W=1.0U
Mxmux7_MMNA00 xmux7_xb DOUT7 xmux7_smdNA0 VGND nfet L=0.15U W=0.42U
Mxmux7_MMNA01 xmux7_smdNA0 xmux7_Sb VGND VGND nfet L=0.15U W=0.42U
Mxmux7_MMNA10 xmux7_xb COMP_OUT xmux7_sndNA1 VGND nfet L=0.15U W=0.42U
Mxmux7_MMNA11 xmux7_sndNA1 PH_B7 VGND VGND nfet L=0.15U W=0.42U
Mxmux7_MMIN1 xmux7_Sb PH_B7 VGND VGND nfet L=0.15U W=0.42U
Mxmux7_MMIN2 MUXOUT7 xmux7_xb VGND VGND nfet L=0.15U W=0.65U
Mxmux7_MMPA00 VPWR PH_B7 xmux7_sndPS VPWR pfet L=0.15U W=0.42U
Mxmux7_MMPA01 xmux7_sndPS DOUT7 xmux7_xb VPWR pfet L=0.15U W=0.42U
Mxmux7_MMPA10 VPWR xmux7_Sb xmux7_sndPSb VPWR pfet L=0.15U W=0.42U
Mxmux7_MMPA11 xmux7_sndPSb COMP_OUT xmux7_xb VPWR pfet L=0.15U W=0.42U
Mxmux7_MMIP1 xmux7_Sb PH_B7 VPWR VPWR pfet L=0.15U W=0.42U
Mxmux7_MMIP2 MUXOUT7 xmux7_xb VPWR VPWR pfet L=0.15U W=1.0U
Mxmux8_MMNA00 xmux8_xb DOUT8 xmux8_smdNA0 VGND nfet L=0.15U W=0.42U
Mxmux8_MMNA01 xmux8_smdNA0 xmux8_Sb VGND VGND nfet L=0.15U W=0.42U
Mxmux8_MMNA10 xmux8_xb COMP_OUT xmux8_sndNA1 VGND nfet L=0.15U W=0.42U
Mxmux8_MMNA11 xmux8_sndNA1 PH_B8 VGND VGND nfet L=0.15U W=0.42U
Mxmux8_MMIN1 xmux8_Sb PH_B8 VGND VGND nfet L=0.15U W=0.42U
Mxmux8_MMIN2 MUXOUT8 xmux8_xb VGND VGND nfet L=0.15U W=0.65U
Mxmux8_MMPA00 VPWR PH_B8 xmux8_sndPS VPWR pfet L=0.15U W=0.42U
Mxmux8_MMPA01 xmux8_sndPS DOUT8 xmux8_xb VPWR pfet L=0.15U W=0.42U
Mxmux8_MMPA10 VPWR xmux8_Sb xmux8_sndPSb VPWR pfet L=0.15U W=0.42U
Mxmux8_MMPA11 xmux8_sndPSb COMP_OUT xmux8_xb VPWR pfet L=0.15U W=0.42U
Mxmux8_MMIP1 xmux8_Sb PH_B8 VPWR VPWR pfet L=0.15U W=0.42U
Mxmux8_MMIP2 MUXOUT8 xmux8_xb VPWR VPWR pfet L=0.15U W=1.0U
Mxmux9_MMNA00 xmux9_xb DOUT9 xmux9_smdNA0 VGND nfet L=0.15U W=0.42U
Mxmux9_MMNA01 xmux9_smdNA0 xmux9_Sb VGND VGND nfet L=0.15U W=0.42U
Mxmux9_MMNA10 xmux9_xb COMP_OUT xmux9_sndNA1 VGND nfet L=0.15U W=0.42U
Mxmux9_MMNA11 xmux9_sndNA1 PH_B9 VGND VGND nfet L=0.15U W=0.42U
Mxmux9_MMIN1 xmux9_Sb PH_B9 VGND VGND nfet L=0.15U W=0.42U
Mxmux9_MMIN2 MUXOUT9 xmux9_xb VGND VGND nfet L=0.15U W=0.65U
Mxmux9_MMPA00 VPWR PH_B9 xmux9_sndPS VPWR pfet L=0.15U W=0.42U
Mxmux9_MMPA01 xmux9_sndPS DOUT9 xmux9_xb VPWR pfet L=0.15U W=0.42U
Mxmux9_MMPA10 VPWR xmux9_Sb xmux9_sndPSb VPWR pfet L=0.15U W=0.42U
Mxmux9_MMPA11 xmux9_sndPSb COMP_OUT xmux9_xb VPWR pfet L=0.15U W=0.42U
Mxmux9_MMIP1 xmux9_Sb PH_B9 VPWR VPWR pfet L=0.15U W=0.42U
Mxmux9_MMIP2 MUXOUT9 xmux9_xb VPWR VPWR pfet L=0.15U W=1.0U
Mxor_busy_MMP0 VPWR ORG1 xor_busy_sndPA VPWR pfet L=0.15U W=0.42U
Mxor_busy_MMP1 xor_busy_sndPA ORG2 xor_busy_sndPB VPWR pfet L=0.15U W=0.42U
Mxor_busy_MMP2 xor_busy_sndPB ORG3 xor_busy_y VPWR pfet L=0.15U W=0.42U
Mxor_busy_MMIP3 BUSY xor_busy_y VPWR VPWR pfet L=0.15U W=1.0U
Mxor_busy_MMN0 xor_busy_y ORG1 VGND VGND nfet L=0.15U W=0.42U
Mxor_busy_MMN1 xor_busy_y ORG2 VGND VGND nfet L=0.15U W=0.42U
Mxor_busy_MMN2 xor_busy_y ORG3 VGND VGND nfet L=0.15U W=0.42U
Mxor_busy_MMIN3 BUSY xor_busy_y VGND VGND nfet L=0.15U W=0.65U
Mxor_g1_MMP0 VPWR PH_B9 xor_g1_sndPA VPWR pfet L=0.15U W=0.42U
Mxor_g1_MMP1 xor_g1_sndPA PH_B8 xor_g1_sndPB VPWR pfet L=0.15U W=0.42U
Mxor_g1_MMP2 xor_g1_sndPB PH_B7 xor_g1_sndPC VPWR pfet L=0.15U W=0.42U
Mxor_g1_MMP3 xor_g1_sndPC PH_B6 xor_g1_y VPWR pfet L=0.15U W=0.42U
Mxor_g1_MMIP4 ORG1 xor_g1_y VPWR VPWR pfet L=0.15U W=1.0U
Mxor_g1_MMN0 xor_g1_y PH_B9 VGND VGND nfet L=0.15U W=0.42U
Mxor_g1_MMN1 xor_g1_y PH_B8 VGND VGND nfet L=0.15U W=0.42U
Mxor_g1_MMN2 xor_g1_y PH_B7 VGND VGND nfet L=0.15U W=0.42U
Mxor_g1_MMN3 xor_g1_y PH_B6 VGND VGND nfet L=0.15U W=0.42U
Mxor_g1_MMIN4 ORG1 xor_g1_y VGND VGND nfet L=0.15U W=0.65U
Mxor_g2_MMP0 VPWR PH_B5 xor_g2_sndPA VPWR pfet L=0.15U W=0.42U
Mxor_g2_MMP1 xor_g2_sndPA PH_B4 xor_g2_sndPB VPWR pfet L=0.15U W=0.42U
Mxor_g2_MMP2 xor_g2_sndPB PH_B3 xor_g2_sndPC VPWR pfet L=0.15U W=0.42U
Mxor_g2_MMP3 xor_g2_sndPC PH_B2 xor_g2_y VPWR pfet L=0.15U W=0.42U
Mxor_g2_MMIP4 ORG2 xor_g2_y VPWR VPWR pfet L=0.15U W=1.0U
Mxor_g2_MMN0 xor_g2_y PH_B5 VGND VGND nfet L=0.15U W=0.42U
Mxor_g2_MMN1 xor_g2_y PH_B4 VGND VGND nfet L=0.15U W=0.42U
Mxor_g2_MMN2 xor_g2_y PH_B3 VGND VGND nfet L=0.15U W=0.42U
Mxor_g2_MMN3 xor_g2_y PH_B2 VGND VGND nfet L=0.15U W=0.42U
Mxor_g2_MMIN4 ORG2 xor_g2_y VGND VGND nfet L=0.15U W=0.65U
Mxor_g3_MMP0 VPWR PH_B1 xor_g3_sndPA VPWR pfet L=0.15U W=0.42U
Mxor_g3_MMP1 xor_g3_sndPA PH_B0 xor_g3_sndPB VPWR pfet L=0.15U W=0.42U
Mxor_g3_MMP2 xor_g3_sndPB PH_EOC xor_g3_y VPWR pfet L=0.15U W=0.42U
Mxor_g3_MMIP3 ORG3 xor_g3_y VPWR VPWR pfet L=0.15U W=1.0U
Mxor_g3_MMN0 xor_g3_y PH_B1 VGND VGND nfet L=0.15U W=0.42U
Mxor_g3_MMN1 xor_g3_y PH_B0 VGND VGND nfet L=0.15U W=0.42U
Mxor_g3_MMN2 xor_g3_y PH_EOC VGND VGND nfet L=0.15U W=0.42U
Mxor_g3_MMIN3 ORG3 xor_g3_y VGND VGND nfet L=0.15U W=0.65U
Mxringb0_MI46 xringb0_clkpos xringb0_clkneg VGND VGND nfet L=0.15U W=0.42U
Mxringb0_MI42 xringb0_db xringb0_clkneg xringb0_M0 VGND nfet L=0.15U W=0.36U
Mxringb0_MI656 xringb0_net82 xringb0_s0 xringb0_net108 VGND nfet L=0.15U W=0.42U
Mxringb0_MI657 xringb0_net108 RST_B VGND VGND nfet L=0.15U W=0.42U
Mxringb0_MI33 xringb0_net101 RST_B VGND VGND nfet L=0.15U W=0.42U
Mxringb0_MI4 xringb0_M0 xringb0_clkpos xringb0_net93 VGND nfet L=0.15U W=0.36U
Mxringb0_MI34 xringb0_net93 xringb0_M1 xringb0_net101 VGND nfet L=0.15U W=0.42U
Mxringb0_MI655 xringb0_s0 xringb0_clkneg xringb0_net81 VGND nfet L=0.15U W=0.36U
Mxringb0_MI653 PH_B0 xringb0_net82 VGND VGND nfet L=0.15U W=0.65U
Mxringb0_MI654 xringb0_net81 xringb0_net82 VGND VGND nfet L=0.15U W=0.42U
Mxringb0_MI44 xringb0_clkneg clknet_1_1__leaf_CLK VGND VGND nfet L=0.15U W=0.42U
Mxringb0_MI647 xringb0_M1 xringb0_M0 VGND VGND nfet L=0.15U W=0.64U
Mxringb0_MI39 xringb0_db PH_B1 VGND VGND nfet L=0.15U W=0.42U
Mxringb0_MI649 xringb0_M1 xringb0_clkpos xringb0_s0 VGND nfet L=0.15U W=0.36U
Mxringb0_MI47 xringb0_clkpos xringb0_clkneg VPWR VPWR pfet L=0.15U W=0.64U
Mxringb0_MI43 xringb0_db xringb0_clkpos xringb0_M0 VPWR pfet L=0.15U W=0.42U
Mxringb0_MI662 xringb0_net165 xringb0_net82 VPWR VPWR pfet L=0.15U W=0.42U
Mxringb0_MI659 xringb0_net82 RST_B VPWR VPWR pfet L=0.15U W=0.42U
Mxringb0_MI664 xringb0_s0 xringb0_clkpos xringb0_net165 VPWR pfet L=0.15U W=0.42U
Mxringb0_MI658 xringb0_net82 xringb0_s0 VPWR VPWR pfet L=0.15U W=0.42U
Mxringb0_MI30 xringb0_net144 xringb0_M1 VPWR VPWR pfet L=0.15U W=0.42U
Mxringb0_MI31 xringb0_M0 xringb0_clkneg xringb0_net144 VPWR pfet L=0.15U W=0.42U
Mxringb0_MI32 xringb0_net144 RST_B VPWR VPWR pfet L=0.15U W=0.42U
Mxringb0_MI660 PH_B0 xringb0_net82 VPWR VPWR pfet L=0.15U W=1.0U
Mxringb0_MI45 xringb0_clkneg clknet_1_1__leaf_CLK VPWR VPWR pfet L=0.15U W=0.64U
Mxringb0_MI648 xringb0_M1 xringb0_M0 VPWR VPWR pfet L=0.15U W=0.84U
Mxringb0_MI40 xringb0_db PH_B1 VPWR VPWR pfet L=0.15U W=0.42U
Mxringb0_MI650 xringb0_M1 xringb0_clkneg xringb0_s0 VPWR pfet L=0.15U W=0.42U
Mxringb1_MI46 xringb1_clkpos xringb1_clkneg VGND VGND nfet L=0.15U W=0.42U
Mxringb1_MI42 xringb1_db xringb1_clkneg xringb1_M0 VGND nfet L=0.15U W=0.36U
Mxringb1_MI656 xringb1_net82 xringb1_s0 xringb1_net108 VGND nfet L=0.15U W=0.42U
Mxringb1_MI657 xringb1_net108 RST_B VGND VGND nfet L=0.15U W=0.42U
Mxringb1_MI33 xringb1_net101 RST_B VGND VGND nfet L=0.15U W=0.42U
Mxringb1_MI4 xringb1_M0 xringb1_clkpos xringb1_net93 VGND nfet L=0.15U W=0.36U
Mxringb1_MI34 xringb1_net93 xringb1_M1 xringb1_net101 VGND nfet L=0.15U W=0.42U
Mxringb1_MI655 xringb1_s0 xringb1_clkneg xringb1_net81 VGND nfet L=0.15U W=0.36U
Mxringb1_MI653 PH_B1 xringb1_net82 VGND VGND nfet L=0.15U W=0.65U
Mxringb1_MI654 xringb1_net81 xringb1_net82 VGND VGND nfet L=0.15U W=0.42U
Mxringb1_MI44 xringb1_clkneg clknet_1_1__leaf_CLK VGND VGND nfet L=0.15U W=0.42U
Mxringb1_MI647 xringb1_M1 xringb1_M0 VGND VGND nfet L=0.15U W=0.64U
Mxringb1_MI39 xringb1_db PH_B2 VGND VGND nfet L=0.15U W=0.42U
Mxringb1_MI649 xringb1_M1 xringb1_clkpos xringb1_s0 VGND nfet L=0.15U W=0.36U
Mxringb1_MI47 xringb1_clkpos xringb1_clkneg VPWR VPWR pfet L=0.15U W=0.64U
Mxringb1_MI43 xringb1_db xringb1_clkpos xringb1_M0 VPWR pfet L=0.15U W=0.42U
Mxringb1_MI662 xringb1_net165 xringb1_net82 VPWR VPWR pfet L=0.15U W=0.42U
Mxringb1_MI659 xringb1_net82 RST_B VPWR VPWR pfet L=0.15U W=0.42U
Mxringb1_MI664 xringb1_s0 xringb1_clkpos xringb1_net165 VPWR pfet L=0.15U W=0.42U
Mxringb1_MI658 xringb1_net82 xringb1_s0 VPWR VPWR pfet L=0.15U W=0.42U
Mxringb1_MI30 xringb1_net144 xringb1_M1 VPWR VPWR pfet L=0.15U W=0.42U
Mxringb1_MI31 xringb1_M0 xringb1_clkneg xringb1_net144 VPWR pfet L=0.15U W=0.42U
Mxringb1_MI32 xringb1_net144 RST_B VPWR VPWR pfet L=0.15U W=0.42U
Mxringb1_MI660 PH_B1 xringb1_net82 VPWR VPWR pfet L=0.15U W=1.0U
Mxringb1_MI45 xringb1_clkneg clknet_1_1__leaf_CLK VPWR VPWR pfet L=0.15U W=0.64U
Mxringb1_MI648 xringb1_M1 xringb1_M0 VPWR VPWR pfet L=0.15U W=0.84U
Mxringb1_MI40 xringb1_db PH_B2 VPWR VPWR pfet L=0.15U W=0.42U
Mxringb1_MI650 xringb1_M1 xringb1_clkneg xringb1_s0 VPWR pfet L=0.15U W=0.42U
Mxringb2_MI46 xringb2_clkpos xringb2_clkneg VGND VGND nfet L=0.15U W=0.42U
Mxringb2_MI42 xringb2_db xringb2_clkneg xringb2_M0 VGND nfet L=0.15U W=0.36U
Mxringb2_MI656 xringb2_net82 xringb2_s0 xringb2_net108 VGND nfet L=0.15U W=0.42U
Mxringb2_MI657 xringb2_net108 RST_B VGND VGND nfet L=0.15U W=0.42U
Mxringb2_MI33 xringb2_net101 RST_B VGND VGND nfet L=0.15U W=0.42U
Mxringb2_MI4 xringb2_M0 xringb2_clkpos xringb2_net93 VGND nfet L=0.15U W=0.36U
Mxringb2_MI34 xringb2_net93 xringb2_M1 xringb2_net101 VGND nfet L=0.15U W=0.42U
Mxringb2_MI655 xringb2_s0 xringb2_clkneg xringb2_net81 VGND nfet L=0.15U W=0.36U
Mxringb2_MI653 PH_B2 xringb2_net82 VGND VGND nfet L=0.15U W=0.65U
Mxringb2_MI654 xringb2_net81 xringb2_net82 VGND VGND nfet L=0.15U W=0.42U
Mxringb2_MI44 xringb2_clkneg clknet_1_1__leaf_CLK VGND VGND nfet L=0.15U W=0.42U
Mxringb2_MI647 xringb2_M1 xringb2_M0 VGND VGND nfet L=0.15U W=0.64U
Mxringb2_MI39 xringb2_db PH_B3 VGND VGND nfet L=0.15U W=0.42U
Mxringb2_MI649 xringb2_M1 xringb2_clkpos xringb2_s0 VGND nfet L=0.15U W=0.36U
Mxringb2_MI47 xringb2_clkpos xringb2_clkneg VPWR VPWR pfet L=0.15U W=0.64U
Mxringb2_MI43 xringb2_db xringb2_clkpos xringb2_M0 VPWR pfet L=0.15U W=0.42U
Mxringb2_MI662 xringb2_net165 xringb2_net82 VPWR VPWR pfet L=0.15U W=0.42U
Mxringb2_MI659 xringb2_net82 RST_B VPWR VPWR pfet L=0.15U W=0.42U
Mxringb2_MI664 xringb2_s0 xringb2_clkpos xringb2_net165 VPWR pfet L=0.15U W=0.42U
Mxringb2_MI658 xringb2_net82 xringb2_s0 VPWR VPWR pfet L=0.15U W=0.42U
Mxringb2_MI30 xringb2_net144 xringb2_M1 VPWR VPWR pfet L=0.15U W=0.42U
Mxringb2_MI31 xringb2_M0 xringb2_clkneg xringb2_net144 VPWR pfet L=0.15U W=0.42U
Mxringb2_MI32 xringb2_net144 RST_B VPWR VPWR pfet L=0.15U W=0.42U
Mxringb2_MI660 PH_B2 xringb2_net82 VPWR VPWR pfet L=0.15U W=1.0U
Mxringb2_MI45 xringb2_clkneg clknet_1_1__leaf_CLK VPWR VPWR pfet L=0.15U W=0.64U
Mxringb2_MI648 xringb2_M1 xringb2_M0 VPWR VPWR pfet L=0.15U W=0.84U
Mxringb2_MI40 xringb2_db PH_B3 VPWR VPWR pfet L=0.15U W=0.42U
Mxringb2_MI650 xringb2_M1 xringb2_clkneg xringb2_s0 VPWR pfet L=0.15U W=0.42U
Mxringb3_MI46 xringb3_clkpos xringb3_clkneg VGND VGND nfet L=0.15U W=0.42U
Mxringb3_MI42 xringb3_db xringb3_clkneg xringb3_M0 VGND nfet L=0.15U W=0.36U
Mxringb3_MI656 xringb3_net82 xringb3_s0 xringb3_net108 VGND nfet L=0.15U W=0.42U
Mxringb3_MI657 xringb3_net108 RST_B VGND VGND nfet L=0.15U W=0.42U
Mxringb3_MI33 xringb3_net101 RST_B VGND VGND nfet L=0.15U W=0.42U
Mxringb3_MI4 xringb3_M0 xringb3_clkpos xringb3_net93 VGND nfet L=0.15U W=0.36U
Mxringb3_MI34 xringb3_net93 xringb3_M1 xringb3_net101 VGND nfet L=0.15U W=0.42U
Mxringb3_MI655 xringb3_s0 xringb3_clkneg xringb3_net81 VGND nfet L=0.15U W=0.36U
Mxringb3_MI653 PH_B3 xringb3_net82 VGND VGND nfet L=0.15U W=0.65U
Mxringb3_MI654 xringb3_net81 xringb3_net82 VGND VGND nfet L=0.15U W=0.42U
Mxringb3_MI44 xringb3_clkneg clknet_1_1__leaf_CLK VGND VGND nfet L=0.15U W=0.42U
Mxringb3_MI647 xringb3_M1 xringb3_M0 VGND VGND nfet L=0.15U W=0.64U
Mxringb3_MI39 xringb3_db PH_B4 VGND VGND nfet L=0.15U W=0.42U
Mxringb3_MI649 xringb3_M1 xringb3_clkpos xringb3_s0 VGND nfet L=0.15U W=0.36U
Mxringb3_MI47 xringb3_clkpos xringb3_clkneg VPWR VPWR pfet L=0.15U W=0.64U
Mxringb3_MI43 xringb3_db xringb3_clkpos xringb3_M0 VPWR pfet L=0.15U W=0.42U
Mxringb3_MI662 xringb3_net165 xringb3_net82 VPWR VPWR pfet L=0.15U W=0.42U
Mxringb3_MI659 xringb3_net82 RST_B VPWR VPWR pfet L=0.15U W=0.42U
Mxringb3_MI664 xringb3_s0 xringb3_clkpos xringb3_net165 VPWR pfet L=0.15U W=0.42U
Mxringb3_MI658 xringb3_net82 xringb3_s0 VPWR VPWR pfet L=0.15U W=0.42U
Mxringb3_MI30 xringb3_net144 xringb3_M1 VPWR VPWR pfet L=0.15U W=0.42U
Mxringb3_MI31 xringb3_M0 xringb3_clkneg xringb3_net144 VPWR pfet L=0.15U W=0.42U
Mxringb3_MI32 xringb3_net144 RST_B VPWR VPWR pfet L=0.15U W=0.42U
Mxringb3_MI660 PH_B3 xringb3_net82 VPWR VPWR pfet L=0.15U W=1.0U
Mxringb3_MI45 xringb3_clkneg clknet_1_1__leaf_CLK VPWR VPWR pfet L=0.15U W=0.64U
Mxringb3_MI648 xringb3_M1 xringb3_M0 VPWR VPWR pfet L=0.15U W=0.84U
Mxringb3_MI40 xringb3_db PH_B4 VPWR VPWR pfet L=0.15U W=0.42U
Mxringb3_MI650 xringb3_M1 xringb3_clkneg xringb3_s0 VPWR pfet L=0.15U W=0.42U
Mxringb4_MI46 xringb4_clkpos xringb4_clkneg VGND VGND nfet L=0.15U W=0.42U
Mxringb4_MI42 xringb4_db xringb4_clkneg xringb4_M0 VGND nfet L=0.15U W=0.36U
Mxringb4_MI656 xringb4_net82 xringb4_s0 xringb4_net108 VGND nfet L=0.15U W=0.42U
Mxringb4_MI657 xringb4_net108 RST_B VGND VGND nfet L=0.15U W=0.42U
Mxringb4_MI33 xringb4_net101 RST_B VGND VGND nfet L=0.15U W=0.42U
Mxringb4_MI4 xringb4_M0 xringb4_clkpos xringb4_net93 VGND nfet L=0.15U W=0.36U
Mxringb4_MI34 xringb4_net93 xringb4_M1 xringb4_net101 VGND nfet L=0.15U W=0.42U
Mxringb4_MI655 xringb4_s0 xringb4_clkneg xringb4_net81 VGND nfet L=0.15U W=0.36U
Mxringb4_MI653 PH_B4 xringb4_net82 VGND VGND nfet L=0.15U W=0.65U
Mxringb4_MI654 xringb4_net81 xringb4_net82 VGND VGND nfet L=0.15U W=0.42U
Mxringb4_MI44 xringb4_clkneg clknet_1_1__leaf_CLK VGND VGND nfet L=0.15U W=0.42U
Mxringb4_MI647 xringb4_M1 xringb4_M0 VGND VGND nfet L=0.15U W=0.64U
Mxringb4_MI39 xringb4_db PH_B5 VGND VGND nfet L=0.15U W=0.42U
Mxringb4_MI649 xringb4_M1 xringb4_clkpos xringb4_s0 VGND nfet L=0.15U W=0.36U
Mxringb4_MI47 xringb4_clkpos xringb4_clkneg VPWR VPWR pfet L=0.15U W=0.64U
Mxringb4_MI43 xringb4_db xringb4_clkpos xringb4_M0 VPWR pfet L=0.15U W=0.42U
Mxringb4_MI662 xringb4_net165 xringb4_net82 VPWR VPWR pfet L=0.15U W=0.42U
Mxringb4_MI659 xringb4_net82 RST_B VPWR VPWR pfet L=0.15U W=0.42U
Mxringb4_MI664 xringb4_s0 xringb4_clkpos xringb4_net165 VPWR pfet L=0.15U W=0.42U
Mxringb4_MI658 xringb4_net82 xringb4_s0 VPWR VPWR pfet L=0.15U W=0.42U
Mxringb4_MI30 xringb4_net144 xringb4_M1 VPWR VPWR pfet L=0.15U W=0.42U
Mxringb4_MI31 xringb4_M0 xringb4_clkneg xringb4_net144 VPWR pfet L=0.15U W=0.42U
Mxringb4_MI32 xringb4_net144 RST_B VPWR VPWR pfet L=0.15U W=0.42U
Mxringb4_MI660 PH_B4 xringb4_net82 VPWR VPWR pfet L=0.15U W=1.0U
Mxringb4_MI45 xringb4_clkneg clknet_1_1__leaf_CLK VPWR VPWR pfet L=0.15U W=0.64U
Mxringb4_MI648 xringb4_M1 xringb4_M0 VPWR VPWR pfet L=0.15U W=0.84U
Mxringb4_MI40 xringb4_db PH_B5 VPWR VPWR pfet L=0.15U W=0.42U
Mxringb4_MI650 xringb4_M1 xringb4_clkneg xringb4_s0 VPWR pfet L=0.15U W=0.42U
Mxringb5_MI46 xringb5_clkpos xringb5_clkneg VGND VGND nfet L=0.15U W=0.42U
Mxringb5_MI42 xringb5_db xringb5_clkneg xringb5_M0 VGND nfet L=0.15U W=0.36U
Mxringb5_MI656 xringb5_net82 xringb5_s0 xringb5_net108 VGND nfet L=0.15U W=0.42U
Mxringb5_MI657 xringb5_net108 RST_B VGND VGND nfet L=0.15U W=0.42U
Mxringb5_MI33 xringb5_net101 RST_B VGND VGND nfet L=0.15U W=0.42U
Mxringb5_MI4 xringb5_M0 xringb5_clkpos xringb5_net93 VGND nfet L=0.15U W=0.36U
Mxringb5_MI34 xringb5_net93 xringb5_M1 xringb5_net101 VGND nfet L=0.15U W=0.42U
Mxringb5_MI655 xringb5_s0 xringb5_clkneg xringb5_net81 VGND nfet L=0.15U W=0.36U
Mxringb5_MI653 PH_B5 xringb5_net82 VGND VGND nfet L=0.15U W=0.65U
Mxringb5_MI654 xringb5_net81 xringb5_net82 VGND VGND nfet L=0.15U W=0.42U
Mxringb5_MI44 xringb5_clkneg clknet_1_0__leaf_CLK VGND VGND nfet L=0.15U W=0.42U
Mxringb5_MI647 xringb5_M1 xringb5_M0 VGND VGND nfet L=0.15U W=0.64U
Mxringb5_MI39 xringb5_db PH_B6 VGND VGND nfet L=0.15U W=0.42U
Mxringb5_MI649 xringb5_M1 xringb5_clkpos xringb5_s0 VGND nfet L=0.15U W=0.36U
Mxringb5_MI47 xringb5_clkpos xringb5_clkneg VPWR VPWR pfet L=0.15U W=0.64U
Mxringb5_MI43 xringb5_db xringb5_clkpos xringb5_M0 VPWR pfet L=0.15U W=0.42U
Mxringb5_MI662 xringb5_net165 xringb5_net82 VPWR VPWR pfet L=0.15U W=0.42U
Mxringb5_MI659 xringb5_net82 RST_B VPWR VPWR pfet L=0.15U W=0.42U
Mxringb5_MI664 xringb5_s0 xringb5_clkpos xringb5_net165 VPWR pfet L=0.15U W=0.42U
Mxringb5_MI658 xringb5_net82 xringb5_s0 VPWR VPWR pfet L=0.15U W=0.42U
Mxringb5_MI30 xringb5_net144 xringb5_M1 VPWR VPWR pfet L=0.15U W=0.42U
Mxringb5_MI31 xringb5_M0 xringb5_clkneg xringb5_net144 VPWR pfet L=0.15U W=0.42U
Mxringb5_MI32 xringb5_net144 RST_B VPWR VPWR pfet L=0.15U W=0.42U
Mxringb5_MI660 PH_B5 xringb5_net82 VPWR VPWR pfet L=0.15U W=1.0U
Mxringb5_MI45 xringb5_clkneg clknet_1_0__leaf_CLK VPWR VPWR pfet L=0.15U W=0.64U
Mxringb5_MI648 xringb5_M1 xringb5_M0 VPWR VPWR pfet L=0.15U W=0.84U
Mxringb5_MI40 xringb5_db PH_B6 VPWR VPWR pfet L=0.15U W=0.42U
Mxringb5_MI650 xringb5_M1 xringb5_clkneg xringb5_s0 VPWR pfet L=0.15U W=0.42U
Mxringb6_MI46 xringb6_clkpos xringb6_clkneg VGND VGND nfet L=0.15U W=0.42U
Mxringb6_MI42 xringb6_db xringb6_clkneg xringb6_M0 VGND nfet L=0.15U W=0.36U
Mxringb6_MI656 xringb6_net82 xringb6_s0 xringb6_net108 VGND nfet L=0.15U W=0.42U
Mxringb6_MI657 xringb6_net108 RST_B VGND VGND nfet L=0.15U W=0.42U
Mxringb6_MI33 xringb6_net101 RST_B VGND VGND nfet L=0.15U W=0.42U
Mxringb6_MI4 xringb6_M0 xringb6_clkpos xringb6_net93 VGND nfet L=0.15U W=0.36U
Mxringb6_MI34 xringb6_net93 xringb6_M1 xringb6_net101 VGND nfet L=0.15U W=0.42U
Mxringb6_MI655 xringb6_s0 xringb6_clkneg xringb6_net81 VGND nfet L=0.15U W=0.36U
Mxringb6_MI653 PH_B6 xringb6_net82 VGND VGND nfet L=0.15U W=0.65U
Mxringb6_MI654 xringb6_net81 xringb6_net82 VGND VGND nfet L=0.15U W=0.42U
Mxringb6_MI44 xringb6_clkneg clknet_1_0__leaf_CLK VGND VGND nfet L=0.15U W=0.42U
Mxringb6_MI647 xringb6_M1 xringb6_M0 VGND VGND nfet L=0.15U W=0.64U
Mxringb6_MI39 xringb6_db PH_B7 VGND VGND nfet L=0.15U W=0.42U
Mxringb6_MI649 xringb6_M1 xringb6_clkpos xringb6_s0 VGND nfet L=0.15U W=0.36U
Mxringb6_MI47 xringb6_clkpos xringb6_clkneg VPWR VPWR pfet L=0.15U W=0.64U
Mxringb6_MI43 xringb6_db xringb6_clkpos xringb6_M0 VPWR pfet L=0.15U W=0.42U
Mxringb6_MI662 xringb6_net165 xringb6_net82 VPWR VPWR pfet L=0.15U W=0.42U
Mxringb6_MI659 xringb6_net82 RST_B VPWR VPWR pfet L=0.15U W=0.42U
Mxringb6_MI664 xringb6_s0 xringb6_clkpos xringb6_net165 VPWR pfet L=0.15U W=0.42U
Mxringb6_MI658 xringb6_net82 xringb6_s0 VPWR VPWR pfet L=0.15U W=0.42U
Mxringb6_MI30 xringb6_net144 xringb6_M1 VPWR VPWR pfet L=0.15U W=0.42U
Mxringb6_MI31 xringb6_M0 xringb6_clkneg xringb6_net144 VPWR pfet L=0.15U W=0.42U
Mxringb6_MI32 xringb6_net144 RST_B VPWR VPWR pfet L=0.15U W=0.42U
Mxringb6_MI660 PH_B6 xringb6_net82 VPWR VPWR pfet L=0.15U W=1.0U
Mxringb6_MI45 xringb6_clkneg clknet_1_0__leaf_CLK VPWR VPWR pfet L=0.15U W=0.64U
Mxringb6_MI648 xringb6_M1 xringb6_M0 VPWR VPWR pfet L=0.15U W=0.84U
Mxringb6_MI40 xringb6_db PH_B7 VPWR VPWR pfet L=0.15U W=0.42U
Mxringb6_MI650 xringb6_M1 xringb6_clkneg xringb6_s0 VPWR pfet L=0.15U W=0.42U
Mxringb7_MI46 xringb7_clkpos xringb7_clkneg VGND VGND nfet L=0.15U W=0.42U
Mxringb7_MI42 xringb7_db xringb7_clkneg xringb7_M0 VGND nfet L=0.15U W=0.36U
Mxringb7_MI656 xringb7_net82 xringb7_s0 xringb7_net108 VGND nfet L=0.15U W=0.42U
Mxringb7_MI657 xringb7_net108 RST_B VGND VGND nfet L=0.15U W=0.42U
Mxringb7_MI33 xringb7_net101 RST_B VGND VGND nfet L=0.15U W=0.42U
Mxringb7_MI4 xringb7_M0 xringb7_clkpos xringb7_net93 VGND nfet L=0.15U W=0.36U
Mxringb7_MI34 xringb7_net93 xringb7_M1 xringb7_net101 VGND nfet L=0.15U W=0.42U
Mxringb7_MI655 xringb7_s0 xringb7_clkneg xringb7_net81 VGND nfet L=0.15U W=0.36U
Mxringb7_MI653 PH_B7 xringb7_net82 VGND VGND nfet L=0.15U W=0.65U
Mxringb7_MI654 xringb7_net81 xringb7_net82 VGND VGND nfet L=0.15U W=0.42U
Mxringb7_MI44 xringb7_clkneg clknet_1_0__leaf_CLK VGND VGND nfet L=0.15U W=0.42U
Mxringb7_MI647 xringb7_M1 xringb7_M0 VGND VGND nfet L=0.15U W=0.64U
Mxringb7_MI39 xringb7_db PH_B8 VGND VGND nfet L=0.15U W=0.42U
Mxringb7_MI649 xringb7_M1 xringb7_clkpos xringb7_s0 VGND nfet L=0.15U W=0.36U
Mxringb7_MI47 xringb7_clkpos xringb7_clkneg VPWR VPWR pfet L=0.15U W=0.64U
Mxringb7_MI43 xringb7_db xringb7_clkpos xringb7_M0 VPWR pfet L=0.15U W=0.42U
Mxringb7_MI662 xringb7_net165 xringb7_net82 VPWR VPWR pfet L=0.15U W=0.42U
Mxringb7_MI659 xringb7_net82 RST_B VPWR VPWR pfet L=0.15U W=0.42U
Mxringb7_MI664 xringb7_s0 xringb7_clkpos xringb7_net165 VPWR pfet L=0.15U W=0.42U
Mxringb7_MI658 xringb7_net82 xringb7_s0 VPWR VPWR pfet L=0.15U W=0.42U
Mxringb7_MI30 xringb7_net144 xringb7_M1 VPWR VPWR pfet L=0.15U W=0.42U
Mxringb7_MI31 xringb7_M0 xringb7_clkneg xringb7_net144 VPWR pfet L=0.15U W=0.42U
Mxringb7_MI32 xringb7_net144 RST_B VPWR VPWR pfet L=0.15U W=0.42U
Mxringb7_MI660 PH_B7 xringb7_net82 VPWR VPWR pfet L=0.15U W=1.0U
Mxringb7_MI45 xringb7_clkneg clknet_1_0__leaf_CLK VPWR VPWR pfet L=0.15U W=0.64U
Mxringb7_MI648 xringb7_M1 xringb7_M0 VPWR VPWR pfet L=0.15U W=0.84U
Mxringb7_MI40 xringb7_db PH_B8 VPWR VPWR pfet L=0.15U W=0.42U
Mxringb7_MI650 xringb7_M1 xringb7_clkneg xringb7_s0 VPWR pfet L=0.15U W=0.42U
Mxringb8_MI46 xringb8_clkpos xringb8_clkneg VGND VGND nfet L=0.15U W=0.42U
Mxringb8_MI42 xringb8_db xringb8_clkneg xringb8_M0 VGND nfet L=0.15U W=0.36U
Mxringb8_MI656 xringb8_net82 xringb8_s0 xringb8_net108 VGND nfet L=0.15U W=0.42U
Mxringb8_MI657 xringb8_net108 RST_B VGND VGND nfet L=0.15U W=0.42U
Mxringb8_MI33 xringb8_net101 RST_B VGND VGND nfet L=0.15U W=0.42U
Mxringb8_MI4 xringb8_M0 xringb8_clkpos xringb8_net93 VGND nfet L=0.15U W=0.36U
Mxringb8_MI34 xringb8_net93 xringb8_M1 xringb8_net101 VGND nfet L=0.15U W=0.42U
Mxringb8_MI655 xringb8_s0 xringb8_clkneg xringb8_net81 VGND nfet L=0.15U W=0.36U
Mxringb8_MI653 PH_B8 xringb8_net82 VGND VGND nfet L=0.15U W=0.65U
Mxringb8_MI654 xringb8_net81 xringb8_net82 VGND VGND nfet L=0.15U W=0.42U
Mxringb8_MI44 xringb8_clkneg clknet_1_0__leaf_CLK VGND VGND nfet L=0.15U W=0.42U
Mxringb8_MI647 xringb8_M1 xringb8_M0 VGND VGND nfet L=0.15U W=0.64U
Mxringb8_MI39 xringb8_db PH_B9 VGND VGND nfet L=0.15U W=0.42U
Mxringb8_MI649 xringb8_M1 xringb8_clkpos xringb8_s0 VGND nfet L=0.15U W=0.36U
Mxringb8_MI47 xringb8_clkpos xringb8_clkneg VPWR VPWR pfet L=0.15U W=0.64U
Mxringb8_MI43 xringb8_db xringb8_clkpos xringb8_M0 VPWR pfet L=0.15U W=0.42U
Mxringb8_MI662 xringb8_net165 xringb8_net82 VPWR VPWR pfet L=0.15U W=0.42U
Mxringb8_MI659 xringb8_net82 RST_B VPWR VPWR pfet L=0.15U W=0.42U
Mxringb8_MI664 xringb8_s0 xringb8_clkpos xringb8_net165 VPWR pfet L=0.15U W=0.42U
Mxringb8_MI658 xringb8_net82 xringb8_s0 VPWR VPWR pfet L=0.15U W=0.42U
Mxringb8_MI30 xringb8_net144 xringb8_M1 VPWR VPWR pfet L=0.15U W=0.42U
Mxringb8_MI31 xringb8_M0 xringb8_clkneg xringb8_net144 VPWR pfet L=0.15U W=0.42U
Mxringb8_MI32 xringb8_net144 RST_B VPWR VPWR pfet L=0.15U W=0.42U
Mxringb8_MI660 PH_B8 xringb8_net82 VPWR VPWR pfet L=0.15U W=1.0U
Mxringb8_MI45 xringb8_clkneg clknet_1_0__leaf_CLK VPWR VPWR pfet L=0.15U W=0.64U
Mxringb8_MI648 xringb8_M1 xringb8_M0 VPWR VPWR pfet L=0.15U W=0.84U
Mxringb8_MI40 xringb8_db PH_B9 VPWR VPWR pfet L=0.15U W=0.42U
Mxringb8_MI650 xringb8_M1 xringb8_clkneg xringb8_s0 VPWR pfet L=0.15U W=0.42U
Mxringb9_MI46 xringb9_clkpos xringb9_clkneg VGND VGND nfet L=0.15U W=0.42U
Mxringb9_MI42 xringb9_db xringb9_clkneg xringb9_M0 VGND nfet L=0.15U W=0.36U
Mxringb9_MI656 xringb9_net82 xringb9_s0 xringb9_net108 VGND nfet L=0.15U W=0.42U
Mxringb9_MI657 xringb9_net108 RST_B VGND VGND nfet L=0.15U W=0.42U
Mxringb9_MI33 xringb9_net101 RST_B VGND VGND nfet L=0.15U W=0.42U
Mxringb9_MI4 xringb9_M0 xringb9_clkpos xringb9_net93 VGND nfet L=0.15U W=0.36U
Mxringb9_MI34 xringb9_net93 xringb9_M1 xringb9_net101 VGND nfet L=0.15U W=0.42U
Mxringb9_MI655 xringb9_s0 xringb9_clkneg xringb9_net81 VGND nfet L=0.15U W=0.36U
Mxringb9_MI653 PH_B9 xringb9_net82 VGND VGND nfet L=0.15U W=0.65U
Mxringb9_MI654 xringb9_net81 xringb9_net82 VGND VGND nfet L=0.15U W=0.42U
Mxringb9_MI44 xringb9_clkneg clknet_1_0__leaf_CLK VGND VGND nfet L=0.15U W=0.42U
Mxringb9_MI647 xringb9_M1 xringb9_M0 VGND VGND nfet L=0.15U W=0.64U
Mxringb9_MI39 xringb9_db PH_SAMPLE VGND VGND nfet L=0.15U W=0.42U
Mxringb9_MI649 xringb9_M1 xringb9_clkpos xringb9_s0 VGND nfet L=0.15U W=0.36U
Mxringb9_MI47 xringb9_clkpos xringb9_clkneg VPWR VPWR pfet L=0.15U W=0.64U
Mxringb9_MI43 xringb9_db xringb9_clkpos xringb9_M0 VPWR pfet L=0.15U W=0.42U
Mxringb9_MI662 xringb9_net165 xringb9_net82 VPWR VPWR pfet L=0.15U W=0.42U
Mxringb9_MI659 xringb9_net82 RST_B VPWR VPWR pfet L=0.15U W=0.42U
Mxringb9_MI664 xringb9_s0 xringb9_clkpos xringb9_net165 VPWR pfet L=0.15U W=0.42U
Mxringb9_MI658 xringb9_net82 xringb9_s0 VPWR VPWR pfet L=0.15U W=0.42U
Mxringb9_MI30 xringb9_net144 xringb9_M1 VPWR VPWR pfet L=0.15U W=0.42U
Mxringb9_MI31 xringb9_M0 xringb9_clkneg xringb9_net144 VPWR pfet L=0.15U W=0.42U
Mxringb9_MI32 xringb9_net144 RST_B VPWR VPWR pfet L=0.15U W=0.42U
Mxringb9_MI660 PH_B9 xringb9_net82 VPWR VPWR pfet L=0.15U W=1.0U
Mxringb9_MI45 xringb9_clkneg clknet_1_0__leaf_CLK VPWR VPWR pfet L=0.15U W=0.64U
Mxringb9_MI648 xringb9_M1 xringb9_M0 VPWR VPWR pfet L=0.15U W=0.84U
Mxringb9_MI40 xringb9_db PH_SAMPLE VPWR VPWR pfet L=0.15U W=0.42U
Mxringb9_MI650 xringb9_M1 xringb9_clkneg xringb9_s0 VPWR pfet L=0.15U W=0.42U
Mxringeoc_MI46 xringeoc_clkpos xringeoc_clkneg VGND VGND nfet L=0.15U W=0.42U
Mxringeoc_MI42 xringeoc_db xringeoc_clkneg xringeoc_M0 VGND nfet L=0.15U W=0.36U
Mxringeoc_MI656 xringeoc_net82 xringeoc_s0 xringeoc_net108 VGND nfet L=0.15U W=0.42U
Mxringeoc_MI657 xringeoc_net108 RST_B VGND VGND nfet L=0.15U W=0.42U
Mxringeoc_MI33 xringeoc_net101 RST_B VGND VGND nfet L=0.15U W=0.42U
Mxringeoc_MI4 xringeoc_M0 xringeoc_clkpos xringeoc_net93 VGND nfet L=0.15U W=0.36U
Mxringeoc_MI34 xringeoc_net93 xringeoc_M1 xringeoc_net101 VGND nfet L=0.15U W=0.42U
Mxringeoc_MI655 xringeoc_s0 xringeoc_clkneg xringeoc_net81 VGND nfet L=0.15U W=0.36U
Mxringeoc_MI653 PH_EOC xringeoc_net82 VGND VGND nfet L=0.15U W=0.65U
Mxringeoc_MI654 xringeoc_net81 xringeoc_net82 VGND VGND nfet L=0.15U W=0.42U
Mxringeoc_MI44 xringeoc_clkneg clknet_1_0__leaf_CLK VGND VGND nfet L=0.15U W=0.42U
Mxringeoc_MI647 xringeoc_M1 xringeoc_M0 VGND VGND nfet L=0.15U W=0.64U
Mxringeoc_MI39 xringeoc_db PH_B0 VGND VGND nfet L=0.15U W=0.42U
Mxringeoc_MI649 xringeoc_M1 xringeoc_clkpos xringeoc_s0 VGND nfet L=0.15U W=0.36U
Mxringeoc_MI47 xringeoc_clkpos xringeoc_clkneg VPWR VPWR pfet L=0.15U W=0.64U
Mxringeoc_MI43 xringeoc_db xringeoc_clkpos xringeoc_M0 VPWR pfet L=0.15U W=0.42U
Mxringeoc_MI662 xringeoc_net165 xringeoc_net82 VPWR VPWR pfet L=0.15U W=0.42U
Mxringeoc_MI659 xringeoc_net82 RST_B VPWR VPWR pfet L=0.15U W=0.42U
Mxringeoc_MI664 xringeoc_s0 xringeoc_clkpos xringeoc_net165 VPWR pfet L=0.15U W=0.42U
Mxringeoc_MI658 xringeoc_net82 xringeoc_s0 VPWR VPWR pfet L=0.15U W=0.42U
Mxringeoc_MI30 xringeoc_net144 xringeoc_M1 VPWR VPWR pfet L=0.15U W=0.42U
Mxringeoc_MI31 xringeoc_M0 xringeoc_clkneg xringeoc_net144 VPWR pfet L=0.15U W=0.42U
Mxringeoc_MI32 xringeoc_net144 RST_B VPWR VPWR pfet L=0.15U W=0.42U
Mxringeoc_MI660 PH_EOC xringeoc_net82 VPWR VPWR pfet L=0.15U W=1.0U
Mxringeoc_MI45 xringeoc_clkneg clknet_1_0__leaf_CLK VPWR VPWR pfet L=0.15U W=0.64U
Mxringeoc_MI648 xringeoc_M1 xringeoc_M0 VPWR VPWR pfet L=0.15U W=0.84U
Mxringeoc_MI40 xringeoc_db PH_B0 VPWR VPWR pfet L=0.15U W=0.42U
Mxringeoc_MI650 xringeoc_M1 xringeoc_clkneg xringeoc_s0 VPWR pfet L=0.15U W=0.42U
.ENDS sar_sequencer
