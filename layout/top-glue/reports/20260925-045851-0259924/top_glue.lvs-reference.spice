* LVS reference for the SAR ADC top-level standard-cell glue bank
* (issue #387).
*
* Mechanically generated -- DO NOT HAND-EDIT. Regenerate with:
*   layout/top-glue/bin/generate-lvs-reference.py [netlist.v]
*
* Topology source: top-glue/reports/20260925-045851-0259924/top_glue_post_route.v
* (klt place-and-route's own post-route `write_verilog` dump, itself
* elaborated from layout/top-glue/netlist/top_glue.v -- hand-derived
* 1:1 from design/sar_adc_top.spice's own top-level instance lines as
* they stand under DR-008/DR-009, NOT from issue #56's superseded
* xinv_seln0..8 inverter bank).
*
* Instance census asserted against design/sar_adc_top.spice on every
* run: inv_1 x3, and2_1 x18, and2b_1 x1, mux2_1 x1, xnor2_1 x1,
* xor2_1 x9 (33 instances, 6 cell types).
*
* Flat, transistor-level (klt extract --deck sky130 is a flat
* extractor), device classes generalized to nfet/pfet. Device
* models: the sky130 PDK's own official CDL
* (libs.ref/sky130_fd_sc_hd/cdl/sky130_fd_sc_hd.cdl), Apache-2.0
* licensed, SkyWater's own release -- not reverse-engineered.
.SUBCKT top_glue CLK DOUT9 DOUT8 DOUT7 DOUT6 DOUT5 DOUT4 DOUT3 DOUT2 DOUT1 DOUT0 PH_B9 BUSY OUTN_NC CLKN SELp8 SELp7 SELp6 SELp5 SELp4 SELp3 SELp2 SELp1 SELp0 SELn8 SELn7 SELn6 SELn5 SELn4 SELn3 SELn2 SELn1 SELn0 ADCOUT8 ADCOUT7 ADCOUT6 ADCOUT5 ADCOUT4 ADCOUT3 ADCOUT2 ADCOUT1 ADCOUT0 HALF_LSB_EN HALF_LSB_ENN DUMLOAD_MUX_NC DUMLOAD_XNOR_NC VPWR VGND
Mxand_halflsb_MMP0 xand_halflsb_y xand_halflsb_A VPWR VPWR pfet L=0.15U W=0.42U
Mxand_halflsb_MMP1 xand_halflsb_y BUSY VPWR VPWR pfet L=0.15U W=0.42U
Mxand_halflsb_MMIP0 xand_halflsb_A PH_B9 VPWR VPWR pfet L=0.15U W=0.42U
Mxand_halflsb_MMIP1 HALF_LSB_EN xand_halflsb_y VPWR VPWR pfet L=0.15U W=1.0U
Mxand_halflsb_MMN0 xand_halflsb_y xand_halflsb_A xand_halflsb_sndA VGND nfet L=0.15U W=0.42U
Mxand_halflsb_MMN1 xand_halflsb_sndA BUSY VGND VGND nfet L=0.15U W=0.42U
Mxand_halflsb_MMIN0 xand_halflsb_A PH_B9 VGND VGND nfet L=0.15U W=0.42U
Mxand_halflsb_MMIN1 HALF_LSB_EN xand_halflsb_y VGND VGND nfet L=0.15U W=0.65U
Mxand_seln0_MMP0 xand_seln0_y DOUT0 VPWR VPWR pfet L=0.15U W=0.42U
Mxand_seln0_MMP1 xand_seln0_y DOUT9N VPWR VPWR pfet L=0.15U W=0.42U
Mxand_seln0_MMIP0 SELn0 xand_seln0_y VPWR VPWR pfet L=0.15U W=1.0U
Mxand_seln0_MMN0 xand_seln0_y DOUT0 xand_seln0_sndA VGND nfet L=0.15U W=0.42U
Mxand_seln0_MMN1 xand_seln0_sndA DOUT9N VGND VGND nfet L=0.15U W=0.42U
Mxand_seln0_MMIN0 SELn0 xand_seln0_y VGND VGND nfet L=0.15U W=0.65U
Mxand_seln1_MMP0 xand_seln1_y DOUT1 VPWR VPWR pfet L=0.15U W=0.42U
Mxand_seln1_MMP1 xand_seln1_y DOUT9N VPWR VPWR pfet L=0.15U W=0.42U
Mxand_seln1_MMIP0 SELn1 xand_seln1_y VPWR VPWR pfet L=0.15U W=1.0U
Mxand_seln1_MMN0 xand_seln1_y DOUT1 xand_seln1_sndA VGND nfet L=0.15U W=0.42U
Mxand_seln1_MMN1 xand_seln1_sndA DOUT9N VGND VGND nfet L=0.15U W=0.42U
Mxand_seln1_MMIN0 SELn1 xand_seln1_y VGND VGND nfet L=0.15U W=0.65U
Mxand_seln2_MMP0 xand_seln2_y DOUT2 VPWR VPWR pfet L=0.15U W=0.42U
Mxand_seln2_MMP1 xand_seln2_y DOUT9N VPWR VPWR pfet L=0.15U W=0.42U
Mxand_seln2_MMIP0 SELn2 xand_seln2_y VPWR VPWR pfet L=0.15U W=1.0U
Mxand_seln2_MMN0 xand_seln2_y DOUT2 xand_seln2_sndA VGND nfet L=0.15U W=0.42U
Mxand_seln2_MMN1 xand_seln2_sndA DOUT9N VGND VGND nfet L=0.15U W=0.42U
Mxand_seln2_MMIN0 SELn2 xand_seln2_y VGND VGND nfet L=0.15U W=0.65U
Mxand_seln3_MMP0 xand_seln3_y DOUT3 VPWR VPWR pfet L=0.15U W=0.42U
Mxand_seln3_MMP1 xand_seln3_y DOUT9N VPWR VPWR pfet L=0.15U W=0.42U
Mxand_seln3_MMIP0 SELn3 xand_seln3_y VPWR VPWR pfet L=0.15U W=1.0U
Mxand_seln3_MMN0 xand_seln3_y DOUT3 xand_seln3_sndA VGND nfet L=0.15U W=0.42U
Mxand_seln3_MMN1 xand_seln3_sndA DOUT9N VGND VGND nfet L=0.15U W=0.42U
Mxand_seln3_MMIN0 SELn3 xand_seln3_y VGND VGND nfet L=0.15U W=0.65U
Mxand_seln4_MMP0 xand_seln4_y DOUT4 VPWR VPWR pfet L=0.15U W=0.42U
Mxand_seln4_MMP1 xand_seln4_y DOUT9N VPWR VPWR pfet L=0.15U W=0.42U
Mxand_seln4_MMIP0 SELn4 xand_seln4_y VPWR VPWR pfet L=0.15U W=1.0U
Mxand_seln4_MMN0 xand_seln4_y DOUT4 xand_seln4_sndA VGND nfet L=0.15U W=0.42U
Mxand_seln4_MMN1 xand_seln4_sndA DOUT9N VGND VGND nfet L=0.15U W=0.42U
Mxand_seln4_MMIN0 SELn4 xand_seln4_y VGND VGND nfet L=0.15U W=0.65U
Mxand_seln5_MMP0 xand_seln5_y DOUT5 VPWR VPWR pfet L=0.15U W=0.42U
Mxand_seln5_MMP1 xand_seln5_y DOUT9N VPWR VPWR pfet L=0.15U W=0.42U
Mxand_seln5_MMIP0 SELn5 xand_seln5_y VPWR VPWR pfet L=0.15U W=1.0U
Mxand_seln5_MMN0 xand_seln5_y DOUT5 xand_seln5_sndA VGND nfet L=0.15U W=0.42U
Mxand_seln5_MMN1 xand_seln5_sndA DOUT9N VGND VGND nfet L=0.15U W=0.42U
Mxand_seln5_MMIN0 SELn5 xand_seln5_y VGND VGND nfet L=0.15U W=0.65U
Mxand_seln6_MMP0 xand_seln6_y DOUT6 VPWR VPWR pfet L=0.15U W=0.42U
Mxand_seln6_MMP1 xand_seln6_y DOUT9N VPWR VPWR pfet L=0.15U W=0.42U
Mxand_seln6_MMIP0 SELn6 xand_seln6_y VPWR VPWR pfet L=0.15U W=1.0U
Mxand_seln6_MMN0 xand_seln6_y DOUT6 xand_seln6_sndA VGND nfet L=0.15U W=0.42U
Mxand_seln6_MMN1 xand_seln6_sndA DOUT9N VGND VGND nfet L=0.15U W=0.42U
Mxand_seln6_MMIN0 SELn6 xand_seln6_y VGND VGND nfet L=0.15U W=0.65U
Mxand_seln7_MMP0 xand_seln7_y DOUT7 VPWR VPWR pfet L=0.15U W=0.42U
Mxand_seln7_MMP1 xand_seln7_y DOUT9N VPWR VPWR pfet L=0.15U W=0.42U
Mxand_seln7_MMIP0 SELn7 xand_seln7_y VPWR VPWR pfet L=0.15U W=1.0U
Mxand_seln7_MMN0 xand_seln7_y DOUT7 xand_seln7_sndA VGND nfet L=0.15U W=0.42U
Mxand_seln7_MMN1 xand_seln7_sndA DOUT9N VGND VGND nfet L=0.15U W=0.42U
Mxand_seln7_MMIN0 SELn7 xand_seln7_y VGND VGND nfet L=0.15U W=0.65U
Mxand_seln8_MMP0 xand_seln8_y DOUT8 VPWR VPWR pfet L=0.15U W=0.42U
Mxand_seln8_MMP1 xand_seln8_y DOUT9N VPWR VPWR pfet L=0.15U W=0.42U
Mxand_seln8_MMIP0 SELn8 xand_seln8_y VPWR VPWR pfet L=0.15U W=1.0U
Mxand_seln8_MMN0 xand_seln8_y DOUT8 xand_seln8_sndA VGND nfet L=0.15U W=0.42U
Mxand_seln8_MMN1 xand_seln8_sndA DOUT9N VGND VGND nfet L=0.15U W=0.42U
Mxand_seln8_MMIN0 SELn8 xand_seln8_y VGND VGND nfet L=0.15U W=0.65U
Mxand_selp0_MMP0 xand_selp0_y DOUT9 VPWR VPWR pfet L=0.15U W=0.42U
Mxand_selp0_MMP1 xand_selp0_y DOUT0 VPWR VPWR pfet L=0.15U W=0.42U
Mxand_selp0_MMIP0 SELp0 xand_selp0_y VPWR VPWR pfet L=0.15U W=1.0U
Mxand_selp0_MMN0 xand_selp0_y DOUT9 xand_selp0_sndA VGND nfet L=0.15U W=0.42U
Mxand_selp0_MMN1 xand_selp0_sndA DOUT0 VGND VGND nfet L=0.15U W=0.42U
Mxand_selp0_MMIN0 SELp0 xand_selp0_y VGND VGND nfet L=0.15U W=0.65U
Mxand_selp1_MMP0 xand_selp1_y DOUT9 VPWR VPWR pfet L=0.15U W=0.42U
Mxand_selp1_MMP1 xand_selp1_y DOUT1 VPWR VPWR pfet L=0.15U W=0.42U
Mxand_selp1_MMIP0 SELp1 xand_selp1_y VPWR VPWR pfet L=0.15U W=1.0U
Mxand_selp1_MMN0 xand_selp1_y DOUT9 xand_selp1_sndA VGND nfet L=0.15U W=0.42U
Mxand_selp1_MMN1 xand_selp1_sndA DOUT1 VGND VGND nfet L=0.15U W=0.42U
Mxand_selp1_MMIN0 SELp1 xand_selp1_y VGND VGND nfet L=0.15U W=0.65U
Mxand_selp2_MMP0 xand_selp2_y DOUT9 VPWR VPWR pfet L=0.15U W=0.42U
Mxand_selp2_MMP1 xand_selp2_y DOUT2 VPWR VPWR pfet L=0.15U W=0.42U
Mxand_selp2_MMIP0 SELp2 xand_selp2_y VPWR VPWR pfet L=0.15U W=1.0U
Mxand_selp2_MMN0 xand_selp2_y DOUT9 xand_selp2_sndA VGND nfet L=0.15U W=0.42U
Mxand_selp2_MMN1 xand_selp2_sndA DOUT2 VGND VGND nfet L=0.15U W=0.42U
Mxand_selp2_MMIN0 SELp2 xand_selp2_y VGND VGND nfet L=0.15U W=0.65U
Mxand_selp3_MMP0 xand_selp3_y DOUT9 VPWR VPWR pfet L=0.15U W=0.42U
Mxand_selp3_MMP1 xand_selp3_y DOUT3 VPWR VPWR pfet L=0.15U W=0.42U
Mxand_selp3_MMIP0 SELp3 xand_selp3_y VPWR VPWR pfet L=0.15U W=1.0U
Mxand_selp3_MMN0 xand_selp3_y DOUT9 xand_selp3_sndA VGND nfet L=0.15U W=0.42U
Mxand_selp3_MMN1 xand_selp3_sndA DOUT3 VGND VGND nfet L=0.15U W=0.42U
Mxand_selp3_MMIN0 SELp3 xand_selp3_y VGND VGND nfet L=0.15U W=0.65U
Mxand_selp4_MMP0 xand_selp4_y DOUT9 VPWR VPWR pfet L=0.15U W=0.42U
Mxand_selp4_MMP1 xand_selp4_y DOUT4 VPWR VPWR pfet L=0.15U W=0.42U
Mxand_selp4_MMIP0 SELp4 xand_selp4_y VPWR VPWR pfet L=0.15U W=1.0U
Mxand_selp4_MMN0 xand_selp4_y DOUT9 xand_selp4_sndA VGND nfet L=0.15U W=0.42U
Mxand_selp4_MMN1 xand_selp4_sndA DOUT4 VGND VGND nfet L=0.15U W=0.42U
Mxand_selp4_MMIN0 SELp4 xand_selp4_y VGND VGND nfet L=0.15U W=0.65U
Mxand_selp5_MMP0 xand_selp5_y DOUT9 VPWR VPWR pfet L=0.15U W=0.42U
Mxand_selp5_MMP1 xand_selp5_y DOUT5 VPWR VPWR pfet L=0.15U W=0.42U
Mxand_selp5_MMIP0 SELp5 xand_selp5_y VPWR VPWR pfet L=0.15U W=1.0U
Mxand_selp5_MMN0 xand_selp5_y DOUT9 xand_selp5_sndA VGND nfet L=0.15U W=0.42U
Mxand_selp5_MMN1 xand_selp5_sndA DOUT5 VGND VGND nfet L=0.15U W=0.42U
Mxand_selp5_MMIN0 SELp5 xand_selp5_y VGND VGND nfet L=0.15U W=0.65U
Mxand_selp6_MMP0 xand_selp6_y DOUT9 VPWR VPWR pfet L=0.15U W=0.42U
Mxand_selp6_MMP1 xand_selp6_y DOUT6 VPWR VPWR pfet L=0.15U W=0.42U
Mxand_selp6_MMIP0 SELp6 xand_selp6_y VPWR VPWR pfet L=0.15U W=1.0U
Mxand_selp6_MMN0 xand_selp6_y DOUT9 xand_selp6_sndA VGND nfet L=0.15U W=0.42U
Mxand_selp6_MMN1 xand_selp6_sndA DOUT6 VGND VGND nfet L=0.15U W=0.42U
Mxand_selp6_MMIN0 SELp6 xand_selp6_y VGND VGND nfet L=0.15U W=0.65U
Mxand_selp7_MMP0 xand_selp7_y DOUT9 VPWR VPWR pfet L=0.15U W=0.42U
Mxand_selp7_MMP1 xand_selp7_y DOUT7 VPWR VPWR pfet L=0.15U W=0.42U
Mxand_selp7_MMIP0 SELp7 xand_selp7_y VPWR VPWR pfet L=0.15U W=1.0U
Mxand_selp7_MMN0 xand_selp7_y DOUT9 xand_selp7_sndA VGND nfet L=0.15U W=0.42U
Mxand_selp7_MMN1 xand_selp7_sndA DOUT7 VGND VGND nfet L=0.15U W=0.42U
Mxand_selp7_MMIN0 SELp7 xand_selp7_y VGND VGND nfet L=0.15U W=0.65U
Mxand_selp8_MMP0 xand_selp8_y DOUT9 VPWR VPWR pfet L=0.15U W=0.42U
Mxand_selp8_MMP1 xand_selp8_y DOUT8 VPWR VPWR pfet L=0.15U W=0.42U
Mxand_selp8_MMIP0 SELp8 xand_selp8_y VPWR VPWR pfet L=0.15U W=1.0U
Mxand_selp8_MMN0 xand_selp8_y DOUT9 xand_selp8_sndA VGND nfet L=0.15U W=0.42U
Mxand_selp8_MMN1 xand_selp8_sndA DOUT8 VGND VGND nfet L=0.15U W=0.42U
Mxand_selp8_MMIN0 SELp8 xand_selp8_y VGND VGND nfet L=0.15U W=0.65U
Mxdum_mux_n_MMNA00 xdum_mux_n_xb DOUT9 xdum_mux_n_smdNA0 VGND nfet L=0.15U W=0.42U
Mxdum_mux_n_MMNA01 xdum_mux_n_smdNA0 xdum_mux_n_Sb VGND VGND nfet L=0.15U W=0.42U
Mxdum_mux_n_MMNA10 xdum_mux_n_xb OUTN_NC xdum_mux_n_sndNA1 VGND nfet L=0.15U W=0.42U
Mxdum_mux_n_MMNA11 xdum_mux_n_sndNA1 PH_B9 VGND VGND nfet L=0.15U W=0.42U
Mxdum_mux_n_MMIN1 xdum_mux_n_Sb PH_B9 VGND VGND nfet L=0.15U W=0.42U
Mxdum_mux_n_MMIN2 DUMLOAD_MUX_NC xdum_mux_n_xb VGND VGND nfet L=0.15U W=0.65U
Mxdum_mux_n_MMPA00 VPWR PH_B9 xdum_mux_n_sndPS VPWR pfet L=0.15U W=0.42U
Mxdum_mux_n_MMPA01 xdum_mux_n_sndPS DOUT9 xdum_mux_n_xb VPWR pfet L=0.15U W=0.42U
Mxdum_mux_n_MMPA10 VPWR xdum_mux_n_Sb xdum_mux_n_sndPSb VPWR pfet L=0.15U W=0.42U
Mxdum_mux_n_MMPA11 xdum_mux_n_sndPSb OUTN_NC xdum_mux_n_xb VPWR pfet L=0.15U W=0.42U
Mxdum_mux_n_MMIP1 xdum_mux_n_Sb PH_B9 VPWR VPWR pfet L=0.15U W=0.42U
Mxdum_mux_n_MMIP2 DUMLOAD_MUX_NC xdum_mux_n_xb VPWR VPWR pfet L=0.15U W=1.0U
Mxdum_xnor_n_MMNnand0 VGND OUTN_NC xdum_xnor_n_sndNA VGND nfet L=0.15U W=0.65U
Mxdum_xnor_n_MMNnand1 xdum_xnor_n_sndNA DOUT9 xdum_xnor_n_inand VGND nfet L=0.15U W=0.65U
Mxdum_xnor_n_MMNaoi10 xdum_xnor_n_nmid OUTN_NC VGND VGND nfet L=0.15U W=0.65U
Mxdum_xnor_n_MMNaoi11 xdum_xnor_n_nmid DOUT9 VGND VGND nfet L=0.15U W=0.65U
Mxdum_xnor_n_MMNaoi20 DUMLOAD_XNOR_NC xdum_xnor_n_inand xdum_xnor_n_nmid VGND nfet L=0.15U W=0.65U
Mxdum_xnor_n_MMPnand0 xdum_xnor_n_inand OUTN_NC VPWR VPWR pfet L=0.15U W=1.0U
Mxdum_xnor_n_MMPnand1 xdum_xnor_n_inand DOUT9 VPWR VPWR pfet L=0.15U W=1.0U
Mxdum_xnor_n_MMPaoi10 VPWR OUTN_NC xdum_xnor_n_sndPA VPWR pfet L=0.15U W=1.0U
Mxdum_xnor_n_MMPaoi11 xdum_xnor_n_sndPA DOUT9 DUMLOAD_XNOR_NC VPWR pfet L=0.15U W=1.0U
Mxdum_xnor_n_MMPaoi20 DUMLOAD_XNOR_NC xdum_xnor_n_inand VPWR VPWR pfet L=0.15U W=1.0U
Mxinv_clkcap_MMIN1 CLKN CLK VGND VGND nfet L=0.15U W=0.65U
Mxinv_clkcap_MMIP1 CLKN CLK VPWR VPWR pfet L=0.15U W=1.0U
Mxinv_dout9n_MMIN1 DOUT9N DOUT9 VGND VGND nfet L=0.15U W=0.65U
Mxinv_dout9n_MMIP1 DOUT9N DOUT9 VPWR VPWR pfet L=0.15U W=1.0U
Mxinv_halflsb_MMIN1 HALF_LSB_ENN HALF_LSB_EN VGND VGND nfet L=0.15U W=0.65U
Mxinv_halflsb_MMIP1 HALF_LSB_ENN HALF_LSB_EN VPWR VPWR pfet L=0.15U W=1.0U
Mxxor_code0_MMNnor0 xxor_code0_inor DOUT0 VGND VGND nfet L=0.15U W=0.65U
Mxxor_code0_MMNnor1 xxor_code0_inor DOUT9N VGND VGND nfet L=0.15U W=0.65U
Mxxor_code0_MMNaoi10 VGND DOUT0 xxor_code0_sndNA VGND nfet L=0.15U W=0.65U
Mxxor_code0_MMNaoi11 xxor_code0_sndNA DOUT9N ADCOUT0 VGND nfet L=0.15U W=0.65U
Mxxor_code0_MMNaoi20 ADCOUT0 xxor_code0_inor VGND VGND nfet L=0.15U W=0.65U
Mxxor_code0_MMPnor0 VPWR DOUT0 xxor_code0_sndPA VPWR pfet L=0.15U W=1.0U
Mxxor_code0_MMPnor1 xxor_code0_sndPA DOUT9N xxor_code0_inor VPWR pfet L=0.15U W=1.0U
Mxxor_code0_MMPaoi10 xxor_code0_pmid DOUT0 VPWR VPWR pfet L=0.15U W=1.0U
Mxxor_code0_MMPaoi11 xxor_code0_pmid DOUT9N VPWR VPWR pfet L=0.15U W=1.0U
Mxxor_code0_MMPaoi20 ADCOUT0 xxor_code0_inor xxor_code0_pmid VPWR pfet L=0.15U W=1.0U
Mxxor_code1_MMNnor0 xxor_code1_inor DOUT1 VGND VGND nfet L=0.15U W=0.65U
Mxxor_code1_MMNnor1 xxor_code1_inor DOUT9N VGND VGND nfet L=0.15U W=0.65U
Mxxor_code1_MMNaoi10 VGND DOUT1 xxor_code1_sndNA VGND nfet L=0.15U W=0.65U
Mxxor_code1_MMNaoi11 xxor_code1_sndNA DOUT9N ADCOUT1 VGND nfet L=0.15U W=0.65U
Mxxor_code1_MMNaoi20 ADCOUT1 xxor_code1_inor VGND VGND nfet L=0.15U W=0.65U
Mxxor_code1_MMPnor0 VPWR DOUT1 xxor_code1_sndPA VPWR pfet L=0.15U W=1.0U
Mxxor_code1_MMPnor1 xxor_code1_sndPA DOUT9N xxor_code1_inor VPWR pfet L=0.15U W=1.0U
Mxxor_code1_MMPaoi10 xxor_code1_pmid DOUT1 VPWR VPWR pfet L=0.15U W=1.0U
Mxxor_code1_MMPaoi11 xxor_code1_pmid DOUT9N VPWR VPWR pfet L=0.15U W=1.0U
Mxxor_code1_MMPaoi20 ADCOUT1 xxor_code1_inor xxor_code1_pmid VPWR pfet L=0.15U W=1.0U
Mxxor_code2_MMNnor0 xxor_code2_inor DOUT2 VGND VGND nfet L=0.15U W=0.65U
Mxxor_code2_MMNnor1 xxor_code2_inor DOUT9N VGND VGND nfet L=0.15U W=0.65U
Mxxor_code2_MMNaoi10 VGND DOUT2 xxor_code2_sndNA VGND nfet L=0.15U W=0.65U
Mxxor_code2_MMNaoi11 xxor_code2_sndNA DOUT9N ADCOUT2 VGND nfet L=0.15U W=0.65U
Mxxor_code2_MMNaoi20 ADCOUT2 xxor_code2_inor VGND VGND nfet L=0.15U W=0.65U
Mxxor_code2_MMPnor0 VPWR DOUT2 xxor_code2_sndPA VPWR pfet L=0.15U W=1.0U
Mxxor_code2_MMPnor1 xxor_code2_sndPA DOUT9N xxor_code2_inor VPWR pfet L=0.15U W=1.0U
Mxxor_code2_MMPaoi10 xxor_code2_pmid DOUT2 VPWR VPWR pfet L=0.15U W=1.0U
Mxxor_code2_MMPaoi11 xxor_code2_pmid DOUT9N VPWR VPWR pfet L=0.15U W=1.0U
Mxxor_code2_MMPaoi20 ADCOUT2 xxor_code2_inor xxor_code2_pmid VPWR pfet L=0.15U W=1.0U
Mxxor_code3_MMNnor0 xxor_code3_inor DOUT3 VGND VGND nfet L=0.15U W=0.65U
Mxxor_code3_MMNnor1 xxor_code3_inor DOUT9N VGND VGND nfet L=0.15U W=0.65U
Mxxor_code3_MMNaoi10 VGND DOUT3 xxor_code3_sndNA VGND nfet L=0.15U W=0.65U
Mxxor_code3_MMNaoi11 xxor_code3_sndNA DOUT9N ADCOUT3 VGND nfet L=0.15U W=0.65U
Mxxor_code3_MMNaoi20 ADCOUT3 xxor_code3_inor VGND VGND nfet L=0.15U W=0.65U
Mxxor_code3_MMPnor0 VPWR DOUT3 xxor_code3_sndPA VPWR pfet L=0.15U W=1.0U
Mxxor_code3_MMPnor1 xxor_code3_sndPA DOUT9N xxor_code3_inor VPWR pfet L=0.15U W=1.0U
Mxxor_code3_MMPaoi10 xxor_code3_pmid DOUT3 VPWR VPWR pfet L=0.15U W=1.0U
Mxxor_code3_MMPaoi11 xxor_code3_pmid DOUT9N VPWR VPWR pfet L=0.15U W=1.0U
Mxxor_code3_MMPaoi20 ADCOUT3 xxor_code3_inor xxor_code3_pmid VPWR pfet L=0.15U W=1.0U
Mxxor_code4_MMNnor0 xxor_code4_inor DOUT4 VGND VGND nfet L=0.15U W=0.65U
Mxxor_code4_MMNnor1 xxor_code4_inor DOUT9N VGND VGND nfet L=0.15U W=0.65U
Mxxor_code4_MMNaoi10 VGND DOUT4 xxor_code4_sndNA VGND nfet L=0.15U W=0.65U
Mxxor_code4_MMNaoi11 xxor_code4_sndNA DOUT9N ADCOUT4 VGND nfet L=0.15U W=0.65U
Mxxor_code4_MMNaoi20 ADCOUT4 xxor_code4_inor VGND VGND nfet L=0.15U W=0.65U
Mxxor_code4_MMPnor0 VPWR DOUT4 xxor_code4_sndPA VPWR pfet L=0.15U W=1.0U
Mxxor_code4_MMPnor1 xxor_code4_sndPA DOUT9N xxor_code4_inor VPWR pfet L=0.15U W=1.0U
Mxxor_code4_MMPaoi10 xxor_code4_pmid DOUT4 VPWR VPWR pfet L=0.15U W=1.0U
Mxxor_code4_MMPaoi11 xxor_code4_pmid DOUT9N VPWR VPWR pfet L=0.15U W=1.0U
Mxxor_code4_MMPaoi20 ADCOUT4 xxor_code4_inor xxor_code4_pmid VPWR pfet L=0.15U W=1.0U
Mxxor_code5_MMNnor0 xxor_code5_inor DOUT5 VGND VGND nfet L=0.15U W=0.65U
Mxxor_code5_MMNnor1 xxor_code5_inor DOUT9N VGND VGND nfet L=0.15U W=0.65U
Mxxor_code5_MMNaoi10 VGND DOUT5 xxor_code5_sndNA VGND nfet L=0.15U W=0.65U
Mxxor_code5_MMNaoi11 xxor_code5_sndNA DOUT9N ADCOUT5 VGND nfet L=0.15U W=0.65U
Mxxor_code5_MMNaoi20 ADCOUT5 xxor_code5_inor VGND VGND nfet L=0.15U W=0.65U
Mxxor_code5_MMPnor0 VPWR DOUT5 xxor_code5_sndPA VPWR pfet L=0.15U W=1.0U
Mxxor_code5_MMPnor1 xxor_code5_sndPA DOUT9N xxor_code5_inor VPWR pfet L=0.15U W=1.0U
Mxxor_code5_MMPaoi10 xxor_code5_pmid DOUT5 VPWR VPWR pfet L=0.15U W=1.0U
Mxxor_code5_MMPaoi11 xxor_code5_pmid DOUT9N VPWR VPWR pfet L=0.15U W=1.0U
Mxxor_code5_MMPaoi20 ADCOUT5 xxor_code5_inor xxor_code5_pmid VPWR pfet L=0.15U W=1.0U
Mxxor_code6_MMNnor0 xxor_code6_inor DOUT6 VGND VGND nfet L=0.15U W=0.65U
Mxxor_code6_MMNnor1 xxor_code6_inor DOUT9N VGND VGND nfet L=0.15U W=0.65U
Mxxor_code6_MMNaoi10 VGND DOUT6 xxor_code6_sndNA VGND nfet L=0.15U W=0.65U
Mxxor_code6_MMNaoi11 xxor_code6_sndNA DOUT9N ADCOUT6 VGND nfet L=0.15U W=0.65U
Mxxor_code6_MMNaoi20 ADCOUT6 xxor_code6_inor VGND VGND nfet L=0.15U W=0.65U
Mxxor_code6_MMPnor0 VPWR DOUT6 xxor_code6_sndPA VPWR pfet L=0.15U W=1.0U
Mxxor_code6_MMPnor1 xxor_code6_sndPA DOUT9N xxor_code6_inor VPWR pfet L=0.15U W=1.0U
Mxxor_code6_MMPaoi10 xxor_code6_pmid DOUT6 VPWR VPWR pfet L=0.15U W=1.0U
Mxxor_code6_MMPaoi11 xxor_code6_pmid DOUT9N VPWR VPWR pfet L=0.15U W=1.0U
Mxxor_code6_MMPaoi20 ADCOUT6 xxor_code6_inor xxor_code6_pmid VPWR pfet L=0.15U W=1.0U
Mxxor_code7_MMNnor0 xxor_code7_inor DOUT7 VGND VGND nfet L=0.15U W=0.65U
Mxxor_code7_MMNnor1 xxor_code7_inor DOUT9N VGND VGND nfet L=0.15U W=0.65U
Mxxor_code7_MMNaoi10 VGND DOUT7 xxor_code7_sndNA VGND nfet L=0.15U W=0.65U
Mxxor_code7_MMNaoi11 xxor_code7_sndNA DOUT9N ADCOUT7 VGND nfet L=0.15U W=0.65U
Mxxor_code7_MMNaoi20 ADCOUT7 xxor_code7_inor VGND VGND nfet L=0.15U W=0.65U
Mxxor_code7_MMPnor0 VPWR DOUT7 xxor_code7_sndPA VPWR pfet L=0.15U W=1.0U
Mxxor_code7_MMPnor1 xxor_code7_sndPA DOUT9N xxor_code7_inor VPWR pfet L=0.15U W=1.0U
Mxxor_code7_MMPaoi10 xxor_code7_pmid DOUT7 VPWR VPWR pfet L=0.15U W=1.0U
Mxxor_code7_MMPaoi11 xxor_code7_pmid DOUT9N VPWR VPWR pfet L=0.15U W=1.0U
Mxxor_code7_MMPaoi20 ADCOUT7 xxor_code7_inor xxor_code7_pmid VPWR pfet L=0.15U W=1.0U
Mxxor_code8_MMNnor0 xxor_code8_inor DOUT8 VGND VGND nfet L=0.15U W=0.65U
Mxxor_code8_MMNnor1 xxor_code8_inor DOUT9N VGND VGND nfet L=0.15U W=0.65U
Mxxor_code8_MMNaoi10 VGND DOUT8 xxor_code8_sndNA VGND nfet L=0.15U W=0.65U
Mxxor_code8_MMNaoi11 xxor_code8_sndNA DOUT9N ADCOUT8 VGND nfet L=0.15U W=0.65U
Mxxor_code8_MMNaoi20 ADCOUT8 xxor_code8_inor VGND VGND nfet L=0.15U W=0.65U
Mxxor_code8_MMPnor0 VPWR DOUT8 xxor_code8_sndPA VPWR pfet L=0.15U W=1.0U
Mxxor_code8_MMPnor1 xxor_code8_sndPA DOUT9N xxor_code8_inor VPWR pfet L=0.15U W=1.0U
Mxxor_code8_MMPaoi10 xxor_code8_pmid DOUT8 VPWR VPWR pfet L=0.15U W=1.0U
Mxxor_code8_MMPaoi11 xxor_code8_pmid DOUT9N VPWR VPWR pfet L=0.15U W=1.0U
Mxxor_code8_MMPaoi20 ADCOUT8 xxor_code8_inor xxor_code8_pmid VPWR pfet L=0.15U W=1.0U
.ENDS top_glue
