* extracted by klt extract --deck sky130

* cell top_glue
* pin A,A0,B,DOUT9
* pin A,A1,OUTN_NC
* pin A,B,DOUT0
* pin A,B,DOUT1
* pin A,B,DOUT2
* pin A,B,DOUT3
* pin A,B,DOUT4
* pin A,B,DOUT5
* pin A,B,DOUT6
* pin A,B,DOUT7
* pin A,B,DOUT8
* pin A,CLK
* pin A,HALF_LSB_EN,X
* pin ADCOUT0,X
* pin ADCOUT1,X
* pin ADCOUT2,X
* pin ADCOUT3,X
* pin ADCOUT4,X
* pin ADCOUT5,X
* pin ADCOUT6,X
* pin ADCOUT7,X
* pin ADCOUT8,X
* pin A_N,PH_B9,S
* pin B,BUSY
* pin CLKN,Y
* pin DUMLOAD_MUX_NC,X
* pin DUMLOAD_XNOR_NC,Y
* pin HALF_LSB_ENN,Y
* pin SELn0,X
* pin SELn1,X
* pin SELn2,X
* pin SELn3,X
* pin SELn4,X
* pin SELn5,X
* pin SELn6,X
* pin SELn7,X
* pin SELn8,X
* pin SELp0,X
* pin SELp1,X
* pin SELp2,X
* pin SELp3,X
* pin SELp4,X
* pin SELp5,X
* pin SELp6,X
* pin SELp7,X
* pin SELp8,X
* pin VGND
* pin VPB,VPWR
.SUBCKT top_glue A|A0|B|DOUT9 A|A1|OUTN_NC A|B|DOUT0 A|B|DOUT1 A|B|DOUT2
+ A|B|DOUT3 A|B|DOUT4 A|B|DOUT5 A|B|DOUT6 A|B|DOUT7 A|B|DOUT8 A|CLK
+ A|HALF_LSB_EN|X ADCOUT0|X ADCOUT1|X ADCOUT2|X ADCOUT3|X ADCOUT4|X ADCOUT5|X
+ ADCOUT6|X ADCOUT7|X ADCOUT8|X A_N|PH_B9|S B|BUSY CLKN|Y DUMLOAD_MUX_NC|X
+ DUMLOAD_XNOR_NC|Y HALF_LSB_ENN|Y SELn0|X SELn1|X SELn2|X SELn3|X SELn4|X
+ SELn5|X SELn6|X SELn7|X SELn8|X SELp0|X SELp1|X SELp2|X SELp3|X SELp4|X
+ SELp5|X SELp6|X SELp7|X SELp8|X VGND VPB|VPWR
* device instance $1 r0 *1 15.23,56.56 nfet
M$1 \$3 B|Y VGND VGND nfet L=0.15U W=0.65U AS=0.169P AD=0.08775P PS=1.82U
+ PD=0.92U
* device instance $2 r0 *1 15.65,56.56 nfet
M$2 VGND A|B|DOUT8 \$3 VGND nfet L=0.15U W=0.65U AS=0.08775P AD=0.08775P
+ PS=0.92U PD=0.92U
* device instance $3 r0 *1 16.07,56.56 nfet
M$3 \$12 A|B|DOUT8 VGND VGND nfet L=0.15U W=0.65U AS=0.08775P AD=0.08775P
+ PS=0.92U PD=0.92U
* device instance $4 r0 *1 16.49,56.56 nfet
M$4 ADCOUT8|X B|Y \$12 VGND nfet L=0.15U W=0.65U AS=0.08775P AD=0.25025P
+ PS=0.92U PD=1.42U
* device instance $5 r0 *1 17.41,56.56 nfet
M$5 VGND \$3 ADCOUT8|X VGND nfet L=0.15U W=0.65U AS=0.25025P AD=0.208P PS=1.42U
+ PD=1.94U
* device instance $6 r0 *1 31.375,57.565 nfet
M$6 \$28 A_N|PH_B9|S VGND VGND nfet L=0.15U W=0.42U AS=0.11285P AD=0.0693P
+ PS=1.045U PD=0.75U
* device instance $7 r0 *1 31.855,57.565 nfet
M$7 \$19 A|A1|OUTN_NC \$28 VGND nfet L=0.15U W=0.42U AS=0.0693P AD=0.09975P
+ PS=0.75U PD=0.895U
* device instance $8 r0 *1 32.48,57.565 nfet
M$8 \$29 A|A0|B|DOUT9 \$19 VGND nfet L=0.15U W=0.42U AS=0.09975P AD=0.0693P
+ PS=0.895U PD=0.75U
* device instance $9 r0 *1 32.96,57.565 nfet
M$9 VGND \$22 \$29 VGND nfet L=0.15U W=0.42U AS=0.0693P AD=0.1449P PS=0.75U
+ PD=1.11U
* device instance $10 r0 *1 33.8,57.565 nfet
M$10 \$22 A_N|PH_B9|S VGND VGND nfet L=0.15U W=0.42U AS=0.1449P AD=0.1092P
+ PS=1.11U PD=1.36U
* device instance $11 r0 *1 30.83,57.68 nfet
M$11 VGND \$19 DUMLOAD_MUX_NC|X VGND nfet L=0.15U W=0.65U AS=0.169P AD=0.11285P
+ PS=1.82U PD=1.045U
* device instance $12 r0 *1 43.89,56.535 nfet
M$12 \$13 A|B|DOUT1 \$9 VGND nfet L=0.15U W=0.42U AS=0.1176P AD=0.0567P PS=1.4U
+ PD=0.69U
* device instance $13 r0 *1 44.31,56.535 nfet
M$13 \$13 B|Y VGND VGND nfet L=0.15U W=0.42U AS=0.1118P AD=0.0567P PS=1.04U
+ PD=0.69U
* device instance $14 r0 *1 44.85,56.56 nfet
M$14 SELn1|X \$9 VGND VGND nfet L=0.15U W=0.65U AS=0.1118P AD=0.182P PS=1.04U
+ PD=1.86U
* device instance $15 r0 *1 14.31,62 nfet
M$15 \$32 B|Y VGND VGND nfet L=0.15U W=0.65U AS=0.169P AD=0.08775P PS=1.82U
+ PD=0.92U
* device instance $16 r0 *1 14.73,62 nfet
M$16 VGND A|B|DOUT2 \$32 VGND nfet L=0.15U W=0.65U AS=0.08775P AD=0.08775P
+ PS=0.92U PD=0.92U
* device instance $17 r0 *1 15.15,62 nfet
M$17 \$66 A|B|DOUT2 VGND VGND nfet L=0.15U W=0.65U AS=0.08775P AD=0.08775P
+ PS=0.92U PD=0.92U
* device instance $18 r0 *1 15.57,62 nfet
M$18 ADCOUT2|X B|Y \$66 VGND nfet L=0.15U W=0.65U AS=0.08775P AD=0.25025P
+ PS=0.92U PD=1.42U
* device instance $19 r0 *1 16.49,62 nfet
M$19 VGND \$32 ADCOUT2|X VGND nfet L=0.15U W=0.65U AS=0.25025P AD=0.208P
+ PS=1.42U PD=1.94U
* device instance $20 r0 *1 18.45,62 nfet
M$20 \$36 B|Y VGND VGND nfet L=0.15U W=0.65U AS=0.169P AD=0.08775P PS=1.82U
+ PD=0.92U
* device instance $21 r0 *1 18.87,62 nfet
M$21 VGND A|B|DOUT3 \$36 VGND nfet L=0.15U W=0.65U AS=0.08775P AD=0.08775P
+ PS=0.92U PD=0.92U
* device instance $22 r0 *1 19.29,62 nfet
M$22 \$65 A|B|DOUT3 VGND VGND nfet L=0.15U W=0.65U AS=0.08775P AD=0.08775P
+ PS=0.92U PD=0.92U
* device instance $23 r0 *1 19.71,62 nfet
M$23 ADCOUT3|X B|Y \$65 VGND nfet L=0.15U W=0.65U AS=0.08775P AD=0.25025P
+ PS=0.92U PD=1.42U
* device instance $24 r0 *1 20.63,62 nfet
M$24 VGND \$36 ADCOUT3|X VGND nfet L=0.15U W=0.65U AS=0.25025P AD=0.208P
+ PS=1.42U PD=1.94U
* device instance $25 r0 *1 23.51,62 nfet
M$25 \$40 B|Y VGND VGND nfet L=0.15U W=0.65U AS=0.169P AD=0.08775P PS=1.82U
+ PD=0.92U
* device instance $26 r0 *1 23.93,62 nfet
M$26 VGND A|B|DOUT7 \$40 VGND nfet L=0.15U W=0.65U AS=0.08775P AD=0.08775P
+ PS=0.92U PD=0.92U
* device instance $27 r0 *1 24.35,62 nfet
M$27 \$64 A|B|DOUT7 VGND VGND nfet L=0.15U W=0.65U AS=0.08775P AD=0.08775P
+ PS=0.92U PD=0.92U
* device instance $28 r0 *1 24.77,62 nfet
M$28 ADCOUT7|X B|Y \$64 VGND nfet L=0.15U W=0.65U AS=0.08775P AD=0.25025P
+ PS=0.92U PD=1.42U
* device instance $29 r0 *1 25.69,62 nfet
M$29 VGND \$40 ADCOUT7|X VGND nfet L=0.15U W=0.65U AS=0.25025P AD=0.208P
+ PS=1.42U PD=1.94U
* device instance $30 r0 *1 25.03,57.705 nfet
M$30 \$26 A|A0|B|DOUT9 \$15 VGND nfet L=0.15U W=0.42U AS=0.1176P AD=0.0567P
+ PS=1.4U PD=0.69U
* device instance $31 r0 *1 25.45,57.705 nfet
M$31 \$26 A|B|DOUT6 VGND VGND nfet L=0.15U W=0.42U AS=0.1118P AD=0.0567P
+ PS=1.04U PD=0.69U
* device instance $32 r0 *1 25.99,57.68 nfet
M$32 SELp6|X \$15 VGND VGND nfet L=0.15U W=0.65U AS=0.1118P AD=0.182P PS=1.04U
+ PD=1.86U
* device instance $33 r0 *1 36.39,62 nfet
M$33 \$48 B|Y VGND VGND nfet L=0.15U W=0.65U AS=0.169P AD=0.08775P PS=1.82U
+ PD=0.92U
* device instance $34 r0 *1 36.81,62 nfet
M$34 VGND A|B|DOUT4 \$48 VGND nfet L=0.15U W=0.65U AS=0.08775P AD=0.08775P
+ PS=0.92U PD=0.92U
* device instance $35 r0 *1 37.23,62 nfet
M$35 \$63 A|B|DOUT4 VGND VGND nfet L=0.15U W=0.65U AS=0.08775P AD=0.08775P
+ PS=0.92U PD=0.92U
* device instance $36 r0 *1 37.65,62 nfet
M$36 ADCOUT4|X B|Y \$63 VGND nfet L=0.15U W=0.65U AS=0.08775P AD=0.25025P
+ PS=0.92U PD=1.42U
* device instance $37 r0 *1 38.57,62 nfet
M$37 VGND \$48 ADCOUT4|X VGND nfet L=0.15U W=0.65U AS=0.25025P AD=0.208P
+ PS=1.42U PD=1.94U
* device instance $38 r0 *1 51.275,62 nfet
M$38 B|Y A|A0|B|DOUT9 VGND VGND nfet L=0.15U W=0.65U AS=0.169P AD=0.169P
+ PS=1.82U PD=1.82U
* device instance $39 r0 *1 53.09,57.705 nfet
M$39 \$31 A|A0|B|DOUT9 \$24 VGND nfet L=0.15U W=0.42U AS=0.1176P AD=0.0567P
+ PS=1.4U PD=0.69U
* device instance $40 r0 *1 53.51,57.705 nfet
M$40 \$31 A|B|DOUT4 VGND VGND nfet L=0.15U W=0.42U AS=0.1118P AD=0.0567P
+ PS=1.04U PD=0.69U
* device instance $41 r0 *1 54.05,57.68 nfet
M$41 SELp4|X \$24 VGND VGND nfet L=0.15U W=0.65U AS=0.1118P AD=0.182P PS=1.04U
+ PD=1.86U
* device instance $42 r0 *1 13.39,63.12 nfet
M$42 \$67 B|Y VGND VGND nfet L=0.15U W=0.65U AS=0.169P AD=0.08775P PS=1.82U
+ PD=0.92U
* device instance $43 r0 *1 13.81,63.12 nfet
M$43 VGND A|B|DOUT0 \$67 VGND nfet L=0.15U W=0.65U AS=0.08775P AD=0.08775P
+ PS=0.92U PD=0.92U
* device instance $44 r0 *1 14.23,63.12 nfet
M$44 \$92 A|B|DOUT0 VGND VGND nfet L=0.15U W=0.65U AS=0.08775P AD=0.08775P
+ PS=0.92U PD=0.92U
* device instance $45 r0 *1 14.65,63.12 nfet
M$45 ADCOUT0|X B|Y \$92 VGND nfet L=0.15U W=0.65U AS=0.08775P AD=0.25025P
+ PS=0.92U PD=1.42U
* device instance $46 r0 *1 15.57,63.12 nfet
M$46 VGND \$67 ADCOUT0|X VGND nfet L=0.15U W=0.65U AS=0.25025P AD=0.208P
+ PS=1.42U PD=1.94U
* device instance $47 r0 *1 19.075,63.12 nfet
M$47 HALF_LSB_ENN|Y A|HALF_LSB_EN|X VGND VGND nfet L=0.15U W=0.65U AS=0.169P
+ AD=0.169P PS=1.82U PD=1.82U
* device instance $48 r0 *1 26.87,61.975 nfet
M$48 \$61 A|B|DOUT7 \$44 VGND nfet L=0.15U W=0.42U AS=0.1176P AD=0.0567P
+ PS=1.4U PD=0.69U
* device instance $49 r0 *1 27.29,61.975 nfet
M$49 \$61 B|Y VGND VGND nfet L=0.15U W=0.42U AS=0.1118P AD=0.0567P PS=1.04U
+ PD=0.69U
* device instance $50 r0 *1 27.83,62 nfet
M$50 SELn7|X \$44 VGND VGND nfet L=0.15U W=0.65U AS=0.1118P AD=0.182P PS=1.04U
+ PD=1.86U
* device instance $51 r0 *1 30.01,63.12 nfet
M$51 \$95 A|A0|B|DOUT9 \$78 VGND nfet L=0.15U W=0.65U AS=0.169P AD=0.06825P
+ PS=1.82U PD=0.86U
* device instance $52 r0 *1 30.37,63.12 nfet
M$52 VGND A|A1|OUTN_NC \$95 VGND nfet L=0.15U W=0.65U AS=0.06825P AD=0.08775P
+ PS=0.86U PD=0.92U
* device instance $53 r0 *1 30.79,63.12 nfet
M$53 \$77 A|A1|OUTN_NC VGND VGND nfet L=0.15U W=0.65U AS=0.08775P AD=0.169P
+ PS=0.92U PD=1.82U
* device instance $54 r0 *1 31.73,63.12 nfet
M$54 \$77 A|A0|B|DOUT9 VGND VGND nfet L=0.15U W=0.65U AS=0.169P AD=0.08775P
+ PS=1.82U PD=0.92U
* device instance $55 r0 *1 32.15,63.12 nfet
M$55 DUMLOAD_XNOR_NC|Y \$78 \$77 VGND nfet L=0.15U W=0.65U AS=0.08775P
+ AD=0.195P PS=0.92U PD=1.9U
* device instance $56 r0 *1 33.77,61.975 nfet
M$56 \$62 A|A0|B|DOUT9 \$46 VGND nfet L=0.15U W=0.42U AS=0.1176P AD=0.0567P
+ PS=1.4U PD=0.69U
* device instance $57 r0 *1 34.19,61.975 nfet
M$57 \$62 A|B|DOUT1 VGND VGND nfet L=0.15U W=0.42U AS=0.1118P AD=0.0567P
+ PS=1.04U PD=0.69U
* device instance $58 r0 *1 34.73,62 nfet
M$58 SELp1|X \$46 VGND VGND nfet L=0.15U W=0.65U AS=0.1118P AD=0.182P PS=1.04U
+ PD=1.86U
* device instance $59 r0 *1 37.77,63.12 nfet
M$59 \$81 B|Y VGND VGND nfet L=0.15U W=0.65U AS=0.169P AD=0.08775P PS=1.82U
+ PD=0.92U
* device instance $60 r0 *1 38.19,63.12 nfet
M$60 VGND A|B|DOUT5 \$81 VGND nfet L=0.15U W=0.65U AS=0.08775P AD=0.08775P
+ PS=0.92U PD=0.92U
* device instance $61 r0 *1 38.61,63.12 nfet
M$61 \$97 A|B|DOUT5 VGND VGND nfet L=0.15U W=0.65U AS=0.08775P AD=0.08775P
+ PS=0.92U PD=0.92U
* device instance $62 r0 *1 39.03,63.12 nfet
M$62 ADCOUT5|X B|Y \$97 VGND nfet L=0.15U W=0.65U AS=0.08775P AD=0.25025P
+ PS=0.92U PD=1.42U
* device instance $63 r0 *1 39.95,63.12 nfet
M$63 VGND \$81 ADCOUT5|X VGND nfet L=0.15U W=0.65U AS=0.25025P AD=0.208P
+ PS=1.42U PD=1.94U
* device instance $64 r0 *1 41.155,63.12 nfet
M$64 CLKN|Y A|CLK VGND VGND nfet L=0.15U W=0.65U AS=0.169P AD=0.169P PS=1.82U
+ PD=1.82U
* device instance $65 r0 *1 43.43,61.975 nfet
M$65 \$60 A|A0|B|DOUT9 \$51 VGND nfet L=0.15U W=0.42U AS=0.1176P AD=0.0567P
+ PS=1.4U PD=0.69U
* device instance $66 r0 *1 43.85,61.975 nfet
M$66 \$60 A|B|DOUT7 VGND VGND nfet L=0.15U W=0.42U AS=0.1118P AD=0.0567P
+ PS=1.04U PD=0.69U
* device instance $67 r0 *1 44.39,62 nfet
M$67 SELp7|X \$51 VGND VGND nfet L=0.15U W=0.65U AS=0.1118P AD=0.182P PS=1.04U
+ PD=1.86U
* device instance $68 r0 *1 53.09,61.975 nfet
M$68 \$59 A|B|DOUT6 \$53 VGND nfet L=0.15U W=0.42U AS=0.1176P AD=0.0567P
+ PS=1.4U PD=0.69U
* device instance $69 r0 *1 53.51,61.975 nfet
M$69 \$59 B|Y VGND VGND nfet L=0.15U W=0.42U AS=0.1118P AD=0.0567P PS=1.04U
+ PD=0.69U
* device instance $70 r0 *1 54.05,62 nfet
M$70 SELn6|X \$53 VGND VGND nfet L=0.15U W=0.65U AS=0.1118P AD=0.182P PS=1.04U
+ PD=1.86U
* device instance $71 r0 *1 23.65,63.145 nfet
M$71 \$93 A|A0|B|DOUT9 \$72 VGND nfet L=0.15U W=0.42U AS=0.1176P AD=0.0567P
+ PS=1.4U PD=0.69U
* device instance $72 r0 *1 24.07,63.145 nfet
M$72 \$93 A|B|DOUT0 VGND VGND nfet L=0.15U W=0.42U AS=0.1118P AD=0.0567P
+ PS=1.04U PD=0.69U
* device instance $73 r0 *1 24.61,63.12 nfet
M$73 SELp0|X \$72 VGND VGND nfet L=0.15U W=0.65U AS=0.1118P AD=0.182P PS=1.04U
+ PD=1.86U
* device instance $74 r0 *1 26.41,63.145 nfet
M$74 \$94 A|B|DOUT3 \$74 VGND nfet L=0.15U W=0.42U AS=0.1176P AD=0.0567P
+ PS=1.4U PD=0.69U
* device instance $75 r0 *1 26.83,63.145 nfet
M$75 \$94 B|Y VGND VGND nfet L=0.15U W=0.42U AS=0.1118P AD=0.0567P PS=1.04U
+ PD=0.69U
* device instance $76 r0 *1 27.37,63.12 nfet
M$76 SELn3|X \$74 VGND VGND nfet L=0.15U W=0.65U AS=0.1118P AD=0.182P PS=1.04U
+ PD=1.86U
* device instance $77 r0 *1 34.55,67.44 nfet
M$77 \$113 B|Y VGND VGND nfet L=0.15U W=0.65U AS=0.169P AD=0.08775P PS=1.82U
+ PD=0.92U
* device instance $78 r0 *1 34.97,67.44 nfet
M$78 VGND A|B|DOUT1 \$113 VGND nfet L=0.15U W=0.65U AS=0.08775P AD=0.08775P
+ PS=0.92U PD=0.92U
* device instance $79 r0 *1 35.39,67.44 nfet
M$79 \$133 A|B|DOUT1 VGND VGND nfet L=0.15U W=0.65U AS=0.08775P AD=0.08775P
+ PS=0.92U PD=0.92U
* device instance $80 r0 *1 35.81,67.44 nfet
M$80 ADCOUT1|X B|Y \$133 VGND nfet L=0.15U W=0.65U AS=0.08775P AD=0.25025P
+ PS=0.92U PD=1.42U
* device instance $81 r0 *1 36.73,67.44 nfet
M$81 VGND \$113 ADCOUT1|X VGND nfet L=0.15U W=0.65U AS=0.25025P AD=0.208P
+ PS=1.42U PD=1.94U
* device instance $82 r0 *1 35.61,63.145 nfet
M$82 \$96 A|B|DOUT2 \$79 VGND nfet L=0.15U W=0.42U AS=0.1176P AD=0.0567P
+ PS=1.4U PD=0.69U
* device instance $83 r0 *1 36.03,63.145 nfet
M$83 \$96 B|Y VGND VGND nfet L=0.15U W=0.42U AS=0.1118P AD=0.0567P PS=1.04U
+ PD=0.69U
* device instance $84 r0 *1 36.57,63.12 nfet
M$84 SELn2|X \$79 VGND VGND nfet L=0.15U W=0.65U AS=0.1118P AD=0.182P PS=1.04U
+ PD=1.86U
* device instance $85 r0 *1 38.69,67.44 nfet
M$85 \$116 B|Y VGND VGND nfet L=0.15U W=0.65U AS=0.169P AD=0.08775P PS=1.82U
+ PD=0.92U
* device instance $86 r0 *1 39.11,67.44 nfet
M$86 VGND A|B|DOUT6 \$116 VGND nfet L=0.15U W=0.65U AS=0.08775P AD=0.08775P
+ PS=0.92U PD=0.92U
* device instance $87 r0 *1 39.53,67.44 nfet
M$87 \$132 A|B|DOUT6 VGND VGND nfet L=0.15U W=0.65U AS=0.08775P AD=0.08775P
+ PS=0.92U PD=0.92U
* device instance $88 r0 *1 39.95,67.44 nfet
M$88 ADCOUT6|X B|Y \$132 VGND nfet L=0.15U W=0.65U AS=0.08775P AD=0.25025P
+ PS=0.92U PD=1.42U
* device instance $89 r0 *1 40.87,67.44 nfet
M$89 VGND \$116 ADCOUT6|X VGND nfet L=0.15U W=0.65U AS=0.25025P AD=0.208P
+ PS=1.42U PD=1.94U
* device instance $90 r0 *1 44.81,63.145 nfet
M$90 \$99 A|A0|B|DOUT9 \$86 VGND nfet L=0.15U W=0.42U AS=0.1176P AD=0.0567P
+ PS=1.4U PD=0.69U
* device instance $91 r0 *1 45.23,63.145 nfet
M$91 \$99 A|B|DOUT8 VGND VGND nfet L=0.15U W=0.42U AS=0.1118P AD=0.0567P
+ PS=1.04U PD=0.69U
* device instance $92 r0 *1 45.77,63.12 nfet
M$92 SELp8|X \$86 VGND VGND nfet L=0.15U W=0.65U AS=0.1118P AD=0.182P PS=1.04U
+ PD=1.86U
* device instance $93 r0 *1 48.49,63.145 nfet
M$93 \$100 A|A0|B|DOUT9 \$88 VGND nfet L=0.15U W=0.42U AS=0.1176P AD=0.0567P
+ PS=1.4U PD=0.69U
* device instance $94 r0 *1 48.91,63.145 nfet
M$94 \$100 A|B|DOUT3 VGND VGND nfet L=0.15U W=0.42U AS=0.1118P AD=0.0567P
+ PS=1.04U PD=0.69U
* device instance $95 r0 *1 49.45,63.12 nfet
M$95 SELp3|X \$88 VGND VGND nfet L=0.15U W=0.65U AS=0.1118P AD=0.182P PS=1.04U
+ PD=1.86U
* device instance $96 r0 *1 52.17,63.145 nfet
M$96 \$98 A|B|DOUT5 \$90 VGND nfet L=0.15U W=0.42U AS=0.1176P AD=0.0567P
+ PS=1.4U PD=0.69U
* device instance $97 r0 *1 52.59,63.145 nfet
M$97 \$98 B|Y VGND VGND nfet L=0.15U W=0.42U AS=0.1118P AD=0.0567P PS=1.04U
+ PD=0.69U
* device instance $98 r0 *1 53.13,63.12 nfet
M$98 SELn5|X \$90 VGND VGND nfet L=0.15U W=0.65U AS=0.1118P AD=0.182P PS=1.04U
+ PD=1.86U
* device instance $99 r0 *1 18.13,67.415 nfet
M$99 \$127 A|B|DOUT8 \$106 VGND nfet L=0.15U W=0.42U AS=0.1176P AD=0.0567P
+ PS=1.4U PD=0.69U
* device instance $100 r0 *1 18.55,67.415 nfet
M$100 \$127 B|Y VGND VGND nfet L=0.15U W=0.42U AS=0.1118P AD=0.0567P PS=1.04U
+ PD=0.69U
* device instance $101 r0 *1 19.09,67.44 nfet
M$101 SELn8|X \$106 VGND VGND nfet L=0.15U W=0.65U AS=0.1118P AD=0.182P
+ PS=1.04U PD=1.86U
* device instance $102 r0 *1 24.57,67.415 nfet
M$102 \$128 A|A0|B|DOUT9 \$108 VGND nfet L=0.15U W=0.42U AS=0.1176P AD=0.0567P
+ PS=1.4U PD=0.69U
* device instance $103 r0 *1 24.99,67.415 nfet
M$103 \$128 A|B|DOUT2 VGND VGND nfet L=0.15U W=0.42U AS=0.1118P AD=0.0567P
+ PS=1.04U PD=0.69U
* device instance $104 r0 *1 25.53,67.44 nfet
M$104 SELp2|X \$108 VGND VGND nfet L=0.15U W=0.65U AS=0.1118P AD=0.182P
+ PS=1.04U PD=1.86U
* device instance $105 r0 *1 30.83,67.555 nfet
M$105 \$110 A_N|PH_B9|S VGND VGND nfet L=0.15U W=0.42U AS=0.1092P AD=0.1092P
+ PS=1.36U PD=1.36U
* device instance $106 r0 *1 31.77,67.555 nfet
M$106 \$134 \$110 \$111 VGND nfet L=0.15U W=0.42U AS=0.1092P AD=0.0504P
+ PS=1.36U PD=0.66U
* device instance $107 r0 *1 32.16,67.555 nfet
M$107 \$134 B|BUSY VGND VGND nfet L=0.15U W=0.42U AS=0.1013P AD=0.0504P
+ PS=0.99U PD=0.66U
* device instance $108 r0 *1 32.65,67.44 nfet
M$108 A|HALF_LSB_EN|X \$111 VGND VGND nfet L=0.15U W=0.65U AS=0.1013P AD=0.169P
+ PS=0.99U PD=1.82U
* device instance $109 r0 *1 44.81,67.415 nfet
M$109 \$131 A|A0|B|DOUT9 \$119 VGND nfet L=0.15U W=0.42U AS=0.1176P AD=0.0567P
+ PS=1.4U PD=0.69U
* device instance $110 r0 *1 45.23,67.415 nfet
M$110 \$131 A|B|DOUT5 VGND VGND nfet L=0.15U W=0.42U AS=0.1118P AD=0.0567P
+ PS=1.04U PD=0.69U
* device instance $111 r0 *1 45.77,67.44 nfet
M$111 SELp5|X \$119 VGND VGND nfet L=0.15U W=0.65U AS=0.1118P AD=0.182P
+ PS=1.04U PD=1.86U
* device instance $112 r0 *1 48.49,67.415 nfet
M$112 \$130 A|B|DOUT0 \$121 VGND nfet L=0.15U W=0.42U AS=0.1176P AD=0.0567P
+ PS=1.4U PD=0.69U
* device instance $113 r0 *1 48.91,67.415 nfet
M$113 \$130 B|Y VGND VGND nfet L=0.15U W=0.42U AS=0.1118P AD=0.0567P PS=1.04U
+ PD=0.69U
* device instance $114 r0 *1 49.45,67.44 nfet
M$114 SELn0|X \$121 VGND VGND nfet L=0.15U W=0.65U AS=0.1118P AD=0.182P
+ PS=1.04U PD=1.86U
* device instance $115 r0 *1 52.63,67.415 nfet
M$115 \$129 A|B|DOUT4 \$123 VGND nfet L=0.15U W=0.42U AS=0.1176P AD=0.0567P
+ PS=1.4U PD=0.69U
* device instance $116 r0 *1 53.05,67.415 nfet
M$116 \$129 B|Y VGND VGND nfet L=0.15U W=0.42U AS=0.1118P AD=0.0567P PS=1.04U
+ PD=0.69U
* device instance $117 r0 *1 53.59,67.44 nfet
M$117 SELn4|X \$123 VGND VGND nfet L=0.15U W=0.65U AS=0.1118P AD=0.182P
+ PS=1.04U PD=1.86U
* device instance $118 r0 *1 15.23,55.135 pfet
M$118 \$11 B|Y \$3 VPB|VPWR pfet L=0.15U W=1U AS=0.26P AD=0.135P PS=2.52U
+ PD=1.27U
* device instance $119 r0 *1 15.65,55.135 pfet
M$119 VPB|VPWR A|B|DOUT8 \$11 VPB|VPWR pfet L=0.15U W=1U AS=0.135P AD=0.135P
+ PS=1.27U PD=1.27U
* device instance $120 r0 *1 16.07,55.135 pfet
M$120 \$6 A|B|DOUT8 VPB|VPWR VPB|VPWR pfet L=0.15U W=1U AS=0.135P AD=0.135P
+ PS=1.27U PD=1.27U
* device instance $121 r0 *1 16.49,55.135 pfet
M$121 VPB|VPWR B|Y \$6 VPB|VPWR pfet L=0.15U W=1U AS=0.135P AD=0.26P PS=1.27U
+ PD=2.52U
* device instance $122 r0 *1 17.43,55.135 pfet
M$122 ADCOUT8|X \$3 \$6 VPB|VPWR pfet L=0.15U W=1U AS=0.26P AD=0.3P PS=2.52U
+ PD=2.6U
* device instance $123 r0 *1 25.03,59.185 pfet
M$123 \$15 A|A0|B|DOUT9 VPB|VPWR VPB|VPWR pfet L=0.15U W=0.42U AS=0.1176P
+ AD=0.0567P PS=1.4U PD=0.69U
* device instance $124 r0 *1 25.45,59.185 pfet
M$124 \$15 A|B|DOUT6 VPB|VPWR VPB|VPWR pfet L=0.15U W=0.42U AS=0.16655P
+ AD=0.0567P PS=1.39U PD=0.69U
* device instance $125 r0 *1 25.99,59.105 pfet
M$125 SELp6|X \$15 VPB|VPWR VPB|VPWR pfet L=0.15U W=1U AS=0.16655P AD=0.475P
+ PS=1.39U PD=2.95U
* device instance $126 r0 *1 31.375,59.2 pfet
M$126 \$27 A_N|PH_B9|S VPB|VPWR VPB|VPWR pfet L=0.15U W=0.42U AS=0.15835P
+ AD=0.07665P PS=1.395U PD=0.785U
* device instance $127 r0 *1 31.89,59.2 pfet
M$127 \$19 A|A0|B|DOUT9 \$27 VPB|VPWR pfet L=0.15U W=0.42U AS=0.07665P
+ AD=0.1932P PS=0.785U PD=1.34U
* device instance $128 r0 *1 32.96,59.2 pfet
M$128 \$30 A|A1|OUTN_NC \$19 VPB|VPWR pfet L=0.15U W=0.42U AS=0.1932P
+ AD=0.0441P PS=1.34U PD=0.63U
* device instance $129 r0 *1 33.32,59.2 pfet
M$129 VPB|VPWR \$22 \$30 VPB|VPWR pfet L=0.15U W=0.42U AS=0.0441P AD=0.0693P
+ PS=0.63U PD=0.75U
* device instance $130 r0 *1 33.8,59.2 pfet
M$130 \$22 A_N|PH_B9|S VPB|VPWR VPB|VPWR pfet L=0.15U W=0.42U AS=0.0693P
+ AD=0.1176P PS=0.75U PD=1.4U
* device instance $131 r0 *1 30.83,59.105 pfet
M$131 VPB|VPWR \$19 DUMLOAD_MUX_NC|X VPB|VPWR pfet L=0.15U W=1U AS=0.26P
+ AD=0.15835P PS=2.52U PD=1.395U
* device instance $132 r0 *1 43.89,55.055 pfet
M$132 \$9 A|B|DOUT1 VPB|VPWR VPB|VPWR pfet L=0.15U W=0.42U AS=0.1176P
+ AD=0.0567P PS=1.4U PD=0.69U
* device instance $133 r0 *1 44.31,55.055 pfet
M$133 \$9 B|Y VPB|VPWR VPB|VPWR pfet L=0.15U W=0.42U AS=0.16655P AD=0.0567P
+ PS=1.39U PD=0.69U
* device instance $134 r0 *1 44.85,55.135 pfet
M$134 SELn1|X \$9 VPB|VPWR VPB|VPWR pfet L=0.15U W=1U AS=0.16655P AD=0.475P
+ PS=1.39U PD=2.95U
* device instance $135 r0 *1 53.09,59.185 pfet
M$135 \$24 A|A0|B|DOUT9 VPB|VPWR VPB|VPWR pfet L=0.15U W=0.42U AS=0.1176P
+ AD=0.0567P PS=1.4U PD=0.69U
* device instance $136 r0 *1 53.51,59.185 pfet
M$136 \$24 A|B|DOUT4 VPB|VPWR VPB|VPWR pfet L=0.15U W=0.42U AS=0.16655P
+ AD=0.0567P PS=1.39U PD=0.69U
* device instance $137 r0 *1 54.05,59.105 pfet
M$137 SELp4|X \$24 VPB|VPWR VPB|VPWR pfet L=0.15U W=1U AS=0.16655P AD=0.475P
+ PS=1.39U PD=2.95U
* device instance $138 r0 *1 14.31,60.575 pfet
M$138 \$55 B|Y \$32 VPB|VPWR pfet L=0.15U W=1U AS=0.26P AD=0.135P PS=2.52U
+ PD=1.27U
* device instance $139 r0 *1 14.73,60.575 pfet
M$139 VPB|VPWR A|B|DOUT2 \$55 VPB|VPWR pfet L=0.15U W=1U AS=0.135P AD=0.135P
+ PS=1.27U PD=1.27U
* device instance $140 r0 *1 15.15,60.575 pfet
M$140 \$34 A|B|DOUT2 VPB|VPWR VPB|VPWR pfet L=0.15U W=1U AS=0.135P AD=0.135P
+ PS=1.27U PD=1.27U
* device instance $141 r0 *1 15.57,60.575 pfet
M$141 VPB|VPWR B|Y \$34 VPB|VPWR pfet L=0.15U W=1U AS=0.135P AD=0.26P PS=1.27U
+ PD=2.52U
* device instance $142 r0 *1 16.51,60.575 pfet
M$142 ADCOUT2|X \$32 \$34 VPB|VPWR pfet L=0.15U W=1U AS=0.26P AD=0.3P PS=2.52U
+ PD=2.6U
* device instance $143 r0 *1 18.45,60.575 pfet
M$143 \$56 B|Y \$36 VPB|VPWR pfet L=0.15U W=1U AS=0.26P AD=0.135P PS=2.52U
+ PD=1.27U
* device instance $144 r0 *1 18.87,60.575 pfet
M$144 VPB|VPWR A|B|DOUT3 \$56 VPB|VPWR pfet L=0.15U W=1U AS=0.135P AD=0.135P
+ PS=1.27U PD=1.27U
* device instance $145 r0 *1 19.29,60.575 pfet
M$145 \$38 A|B|DOUT3 VPB|VPWR VPB|VPWR pfet L=0.15U W=1U AS=0.135P AD=0.135P
+ PS=1.27U PD=1.27U
* device instance $146 r0 *1 19.71,60.575 pfet
M$146 VPB|VPWR B|Y \$38 VPB|VPWR pfet L=0.15U W=1U AS=0.135P AD=0.26P PS=1.27U
+ PD=2.52U
* device instance $147 r0 *1 20.65,60.575 pfet
M$147 ADCOUT3|X \$36 \$38 VPB|VPWR pfet L=0.15U W=1U AS=0.26P AD=0.3P PS=2.52U
+ PD=2.6U
* device instance $148 r0 *1 23.51,60.575 pfet
M$148 \$57 B|Y \$40 VPB|VPWR pfet L=0.15U W=1U AS=0.26P AD=0.135P PS=2.52U
+ PD=1.27U
* device instance $149 r0 *1 23.93,60.575 pfet
M$149 VPB|VPWR A|B|DOUT7 \$57 VPB|VPWR pfet L=0.15U W=1U AS=0.135P AD=0.135P
+ PS=1.27U PD=1.27U
* device instance $150 r0 *1 24.35,60.575 pfet
M$150 \$42 A|B|DOUT7 VPB|VPWR VPB|VPWR pfet L=0.15U W=1U AS=0.135P AD=0.135P
+ PS=1.27U PD=1.27U
* device instance $151 r0 *1 24.77,60.575 pfet
M$151 VPB|VPWR B|Y \$42 VPB|VPWR pfet L=0.15U W=1U AS=0.135P AD=0.26P PS=1.27U
+ PD=2.52U
* device instance $152 r0 *1 25.71,60.575 pfet
M$152 ADCOUT7|X \$40 \$42 VPB|VPWR pfet L=0.15U W=1U AS=0.26P AD=0.3P PS=2.52U
+ PD=2.6U
* device instance $153 r0 *1 36.39,60.575 pfet
M$153 \$58 B|Y \$48 VPB|VPWR pfet L=0.15U W=1U AS=0.26P AD=0.135P PS=2.52U
+ PD=1.27U
* device instance $154 r0 *1 36.81,60.575 pfet
M$154 VPB|VPWR A|B|DOUT4 \$58 VPB|VPWR pfet L=0.15U W=1U AS=0.135P AD=0.135P
+ PS=1.27U PD=1.27U
* device instance $155 r0 *1 37.23,60.575 pfet
M$155 \$49 A|B|DOUT4 VPB|VPWR VPB|VPWR pfet L=0.15U W=1U AS=0.135P AD=0.135P
+ PS=1.27U PD=1.27U
* device instance $156 r0 *1 37.65,60.575 pfet
M$156 VPB|VPWR B|Y \$49 VPB|VPWR pfet L=0.15U W=1U AS=0.135P AD=0.26P PS=1.27U
+ PD=2.52U
* device instance $157 r0 *1 38.59,60.575 pfet
M$157 ADCOUT4|X \$48 \$49 VPB|VPWR pfet L=0.15U W=1U AS=0.26P AD=0.3P PS=2.52U
+ PD=2.6U
* device instance $158 r0 *1 51.275,60.575 pfet
M$158 B|Y A|A0|B|DOUT9 VPB|VPWR VPB|VPWR pfet L=0.15U W=1U AS=0.26P AD=0.26P
+ PS=2.52U PD=2.52U
* device instance $159 r0 *1 13.39,64.545 pfet
M$159 \$105 B|Y \$67 VPB|VPWR pfet L=0.15U W=1U AS=0.26P AD=0.135P PS=2.52U
+ PD=1.27U
* device instance $160 r0 *1 13.81,64.545 pfet
M$160 VPB|VPWR A|B|DOUT0 \$105 VPB|VPWR pfet L=0.15U W=1U AS=0.135P AD=0.135P
+ PS=1.27U PD=1.27U
* device instance $161 r0 *1 14.23,64.545 pfet
M$161 \$101 A|B|DOUT0 VPB|VPWR VPB|VPWR pfet L=0.15U W=1U AS=0.135P AD=0.135P
+ PS=1.27U PD=1.27U
* device instance $162 r0 *1 14.65,64.545 pfet
M$162 VPB|VPWR B|Y \$101 VPB|VPWR pfet L=0.15U W=1U AS=0.135P AD=0.26P PS=1.27U
+ PD=2.52U
* device instance $163 r0 *1 15.59,64.545 pfet
M$163 ADCOUT0|X \$67 \$101 VPB|VPWR pfet L=0.15U W=1U AS=0.26P AD=0.3P PS=2.52U
+ PD=2.6U
* device instance $164 r0 *1 19.075,64.545 pfet
M$164 HALF_LSB_ENN|Y A|HALF_LSB_EN|X VPB|VPWR VPB|VPWR pfet L=0.15U W=1U
+ AS=0.26P AD=0.26P PS=2.52U PD=2.52U
* device instance $165 r0 *1 26.87,60.495 pfet
M$165 \$44 A|B|DOUT7 VPB|VPWR VPB|VPWR pfet L=0.15U W=0.42U AS=0.1176P
+ AD=0.0567P PS=1.4U PD=0.69U
* device instance $166 r0 *1 27.29,60.495 pfet
M$166 \$44 B|Y VPB|VPWR VPB|VPWR pfet L=0.15U W=0.42U AS=0.16655P AD=0.0567P
+ PS=1.39U PD=0.69U
* device instance $167 r0 *1 27.83,60.575 pfet
M$167 SELn7|X \$44 VPB|VPWR VPB|VPWR pfet L=0.15U W=1U AS=0.16655P AD=0.475P
+ PS=1.39U PD=2.95U
* device instance $168 r0 *1 29.95,64.545 pfet
M$168 \$78 A|A0|B|DOUT9 VPB|VPWR VPB|VPWR pfet L=0.15U W=1U AS=0.3P AD=0.135P
+ PS=2.6U PD=1.27U
* device instance $169 r0 *1 30.37,64.545 pfet
M$169 VPB|VPWR A|A1|OUTN_NC \$78 VPB|VPWR pfet L=0.15U W=1U AS=0.135P AD=0.365P
+ PS=1.27U PD=1.73U
* device instance $170 r0 *1 31.25,64.545 pfet
M$170 \$104 A|A1|OUTN_NC VPB|VPWR VPB|VPWR pfet L=0.15U W=1U AS=0.365P
+ AD=0.105P PS=1.73U PD=1.21U
* device instance $171 r0 *1 31.61,64.545 pfet
M$171 DUMLOAD_XNOR_NC|Y A|A0|B|DOUT9 \$104 VPB|VPWR pfet L=0.15U W=1U AS=0.105P
+ AD=0.165P PS=1.21U PD=1.33U
* device instance $172 r0 *1 32.09,64.545 pfet
M$172 VPB|VPWR \$78 DUMLOAD_XNOR_NC|Y VPB|VPWR pfet L=0.15U W=1U AS=0.165P
+ AD=0.36P PS=1.33U PD=2.72U
* device instance $173 r0 *1 33.77,60.495 pfet
M$173 \$46 A|A0|B|DOUT9 VPB|VPWR VPB|VPWR pfet L=0.15U W=0.42U AS=0.1176P
+ AD=0.0567P PS=1.4U PD=0.69U
* device instance $174 r0 *1 34.19,60.495 pfet
M$174 \$46 A|B|DOUT1 VPB|VPWR VPB|VPWR pfet L=0.15U W=0.42U AS=0.16655P
+ AD=0.0567P PS=1.39U PD=0.69U
* device instance $175 r0 *1 34.73,60.575 pfet
M$175 SELp1|X \$46 VPB|VPWR VPB|VPWR pfet L=0.15U W=1U AS=0.16655P AD=0.475P
+ PS=1.39U PD=2.95U
* device instance $176 r0 *1 37.77,64.545 pfet
M$176 \$103 B|Y \$81 VPB|VPWR pfet L=0.15U W=1U AS=0.26P AD=0.135P PS=2.52U
+ PD=1.27U
* device instance $177 r0 *1 38.19,64.545 pfet
M$177 VPB|VPWR A|B|DOUT5 \$103 VPB|VPWR pfet L=0.15U W=1U AS=0.135P AD=0.135P
+ PS=1.27U PD=1.27U
* device instance $178 r0 *1 38.61,64.545 pfet
M$178 \$102 A|B|DOUT5 VPB|VPWR VPB|VPWR pfet L=0.15U W=1U AS=0.135P AD=0.135P
+ PS=1.27U PD=1.27U
* device instance $179 r0 *1 39.03,64.545 pfet
M$179 VPB|VPWR B|Y \$102 VPB|VPWR pfet L=0.15U W=1U AS=0.135P AD=0.26P PS=1.27U
+ PD=2.52U
* device instance $180 r0 *1 39.97,64.545 pfet
M$180 ADCOUT5|X \$81 \$102 VPB|VPWR pfet L=0.15U W=1U AS=0.26P AD=0.3P PS=2.52U
+ PD=2.6U
* device instance $181 r0 *1 41.155,64.545 pfet
M$181 CLKN|Y A|CLK VPB|VPWR VPB|VPWR pfet L=0.15U W=1U AS=0.26P AD=0.26P
+ PS=2.52U PD=2.52U
* device instance $182 r0 *1 43.43,60.495 pfet
M$182 \$51 A|A0|B|DOUT9 VPB|VPWR VPB|VPWR pfet L=0.15U W=0.42U AS=0.1176P
+ AD=0.0567P PS=1.4U PD=0.69U
* device instance $183 r0 *1 43.85,60.495 pfet
M$183 \$51 A|B|DOUT7 VPB|VPWR VPB|VPWR pfet L=0.15U W=0.42U AS=0.16655P
+ AD=0.0567P PS=1.39U PD=0.69U
* device instance $184 r0 *1 44.39,60.575 pfet
M$184 SELp7|X \$51 VPB|VPWR VPB|VPWR pfet L=0.15U W=1U AS=0.16655P AD=0.475P
+ PS=1.39U PD=2.95U
* device instance $185 r0 *1 53.09,60.495 pfet
M$185 \$53 A|B|DOUT6 VPB|VPWR VPB|VPWR pfet L=0.15U W=0.42U AS=0.1176P
+ AD=0.0567P PS=1.4U PD=0.69U
* device instance $186 r0 *1 53.51,60.495 pfet
M$186 \$53 B|Y VPB|VPWR VPB|VPWR pfet L=0.15U W=0.42U AS=0.16655P AD=0.0567P
+ PS=1.39U PD=0.69U
* device instance $187 r0 *1 54.05,60.575 pfet
M$187 SELn6|X \$53 VPB|VPWR VPB|VPWR pfet L=0.15U W=1U AS=0.16655P AD=0.475P
+ PS=1.39U PD=2.95U
* device instance $188 r0 *1 23.65,64.625 pfet
M$188 \$72 A|A0|B|DOUT9 VPB|VPWR VPB|VPWR pfet L=0.15U W=0.42U AS=0.1176P
+ AD=0.0567P PS=1.4U PD=0.69U
* device instance $189 r0 *1 24.07,64.625 pfet
M$189 \$72 A|B|DOUT0 VPB|VPWR VPB|VPWR pfet L=0.15U W=0.42U AS=0.16655P
+ AD=0.0567P PS=1.39U PD=0.69U
* device instance $190 r0 *1 24.61,64.545 pfet
M$190 SELp0|X \$72 VPB|VPWR VPB|VPWR pfet L=0.15U W=1U AS=0.16655P AD=0.475P
+ PS=1.39U PD=2.95U
* device instance $191 r0 *1 26.41,64.625 pfet
M$191 \$74 A|B|DOUT3 VPB|VPWR VPB|VPWR pfet L=0.15U W=0.42U AS=0.1176P
+ AD=0.0567P PS=1.4U PD=0.69U
* device instance $192 r0 *1 26.83,64.625 pfet
M$192 \$74 B|Y VPB|VPWR VPB|VPWR pfet L=0.15U W=0.42U AS=0.16655P AD=0.0567P
+ PS=1.39U PD=0.69U
* device instance $193 r0 *1 27.37,64.545 pfet
M$193 SELn3|X \$74 VPB|VPWR VPB|VPWR pfet L=0.15U W=1U AS=0.16655P AD=0.475P
+ PS=1.39U PD=2.95U
* device instance $194 r0 *1 30.83,65.725 pfet
M$194 VPB|VPWR A_N|PH_B9|S \$110 VPB|VPWR pfet L=0.15U W=0.42U AS=0.1092P
+ AD=0.0714P PS=1.36U PD=0.76U
* device instance $195 r0 *1 31.32,65.725 pfet
M$195 \$111 \$110 VPB|VPWR VPB|VPWR pfet L=0.15U W=0.42U AS=0.0714P AD=0.0609P
+ PS=0.76U PD=0.71U
* device instance $196 r0 *1 31.76,65.725 pfet
M$196 VPB|VPWR B|BUSY \$111 VPB|VPWR pfet L=0.15U W=0.42U AS=0.0609P AD=0.2279P
+ PS=0.71U PD=1.74U
* device instance $197 r0 *1 32.65,66.015 pfet
M$197 A|HALF_LSB_EN|X \$111 VPB|VPWR VPB|VPWR pfet L=0.15U W=1U AS=0.2279P
+ AD=0.26P PS=1.74U PD=2.52U
* device instance $198 r0 *1 34.55,66.015 pfet
M$198 \$125 B|Y \$113 VPB|VPWR pfet L=0.15U W=1U AS=0.26P AD=0.135P PS=2.52U
+ PD=1.27U
* device instance $199 r0 *1 34.97,66.015 pfet
M$199 VPB|VPWR A|B|DOUT1 \$125 VPB|VPWR pfet L=0.15U W=1U AS=0.135P AD=0.135P
+ PS=1.27U PD=1.27U
* device instance $200 r0 *1 35.39,66.015 pfet
M$200 \$114 A|B|DOUT1 VPB|VPWR VPB|VPWR pfet L=0.15U W=1U AS=0.135P AD=0.135P
+ PS=1.27U PD=1.27U
* device instance $201 r0 *1 35.81,66.015 pfet
M$201 VPB|VPWR B|Y \$114 VPB|VPWR pfet L=0.15U W=1U AS=0.135P AD=0.26P PS=1.27U
+ PD=2.52U
* device instance $202 r0 *1 35.61,64.625 pfet
M$202 \$79 A|B|DOUT2 VPB|VPWR VPB|VPWR pfet L=0.15U W=0.42U AS=0.1176P
+ AD=0.0567P PS=1.4U PD=0.69U
* device instance $203 r0 *1 36.03,64.625 pfet
M$203 \$79 B|Y VPB|VPWR VPB|VPWR pfet L=0.15U W=0.42U AS=0.16655P AD=0.0567P
+ PS=1.39U PD=0.69U
* device instance $204 r0 *1 36.57,64.545 pfet
M$204 SELn2|X \$79 VPB|VPWR VPB|VPWR pfet L=0.15U W=1U AS=0.16655P AD=0.475P
+ PS=1.39U PD=2.95U
* device instance $205 r0 *1 36.75,66.015 pfet
M$205 ADCOUT1|X \$113 \$114 VPB|VPWR pfet L=0.15U W=1U AS=0.26P AD=0.3P
+ PS=2.52U PD=2.6U
* device instance $206 r0 *1 38.69,66.015 pfet
M$206 \$126 B|Y \$116 VPB|VPWR pfet L=0.15U W=1U AS=0.26P AD=0.135P PS=2.52U
+ PD=1.27U
* device instance $207 r0 *1 39.11,66.015 pfet
M$207 VPB|VPWR A|B|DOUT6 \$126 VPB|VPWR pfet L=0.15U W=1U AS=0.135P AD=0.135P
+ PS=1.27U PD=1.27U
* device instance $208 r0 *1 39.53,66.015 pfet
M$208 \$117 A|B|DOUT6 VPB|VPWR VPB|VPWR pfet L=0.15U W=1U AS=0.135P AD=0.135P
+ PS=1.27U PD=1.27U
* device instance $209 r0 *1 39.95,66.015 pfet
M$209 VPB|VPWR B|Y \$117 VPB|VPWR pfet L=0.15U W=1U AS=0.135P AD=0.26P PS=1.27U
+ PD=2.52U
* device instance $210 r0 *1 40.89,66.015 pfet
M$210 ADCOUT6|X \$116 \$117 VPB|VPWR pfet L=0.15U W=1U AS=0.26P AD=0.3P
+ PS=2.52U PD=2.6U
* device instance $211 r0 *1 44.81,64.625 pfet
M$211 \$86 A|A0|B|DOUT9 VPB|VPWR VPB|VPWR pfet L=0.15U W=0.42U AS=0.1176P
+ AD=0.0567P PS=1.4U PD=0.69U
* device instance $212 r0 *1 45.23,64.625 pfet
M$212 \$86 A|B|DOUT8 VPB|VPWR VPB|VPWR pfet L=0.15U W=0.42U AS=0.16655P
+ AD=0.0567P PS=1.39U PD=0.69U
* device instance $213 r0 *1 45.77,64.545 pfet
M$213 SELp8|X \$86 VPB|VPWR VPB|VPWR pfet L=0.15U W=1U AS=0.16655P AD=0.475P
+ PS=1.39U PD=2.95U
* device instance $214 r0 *1 48.49,64.625 pfet
M$214 \$88 A|A0|B|DOUT9 VPB|VPWR VPB|VPWR pfet L=0.15U W=0.42U AS=0.1176P
+ AD=0.0567P PS=1.4U PD=0.69U
* device instance $215 r0 *1 48.91,64.625 pfet
M$215 \$88 A|B|DOUT3 VPB|VPWR VPB|VPWR pfet L=0.15U W=0.42U AS=0.16655P
+ AD=0.0567P PS=1.39U PD=0.69U
* device instance $216 r0 *1 49.45,64.545 pfet
M$216 SELp3|X \$88 VPB|VPWR VPB|VPWR pfet L=0.15U W=1U AS=0.16655P AD=0.475P
+ PS=1.39U PD=2.95U
* device instance $217 r0 *1 52.17,64.625 pfet
M$217 \$90 A|B|DOUT5 VPB|VPWR VPB|VPWR pfet L=0.15U W=0.42U AS=0.1176P
+ AD=0.0567P PS=1.4U PD=0.69U
* device instance $218 r0 *1 52.59,64.625 pfet
M$218 \$90 B|Y VPB|VPWR VPB|VPWR pfet L=0.15U W=0.42U AS=0.16655P AD=0.0567P
+ PS=1.39U PD=0.69U
* device instance $219 r0 *1 53.13,64.545 pfet
M$219 SELn5|X \$90 VPB|VPWR VPB|VPWR pfet L=0.15U W=1U AS=0.16655P AD=0.475P
+ PS=1.39U PD=2.95U
* device instance $220 r0 *1 18.13,65.935 pfet
M$220 \$106 A|B|DOUT8 VPB|VPWR VPB|VPWR pfet L=0.15U W=0.42U AS=0.1176P
+ AD=0.0567P PS=1.4U PD=0.69U
* device instance $221 r0 *1 18.55,65.935 pfet
M$221 \$106 B|Y VPB|VPWR VPB|VPWR pfet L=0.15U W=0.42U AS=0.16655P AD=0.0567P
+ PS=1.39U PD=0.69U
* device instance $222 r0 *1 19.09,66.015 pfet
M$222 SELn8|X \$106 VPB|VPWR VPB|VPWR pfet L=0.15U W=1U AS=0.16655P AD=0.475P
+ PS=1.39U PD=2.95U
* device instance $223 r0 *1 24.57,65.935 pfet
M$223 \$108 A|A0|B|DOUT9 VPB|VPWR VPB|VPWR pfet L=0.15U W=0.42U AS=0.1176P
+ AD=0.0567P PS=1.4U PD=0.69U
* device instance $224 r0 *1 24.99,65.935 pfet
M$224 \$108 A|B|DOUT2 VPB|VPWR VPB|VPWR pfet L=0.15U W=0.42U AS=0.16655P
+ AD=0.0567P PS=1.39U PD=0.69U
* device instance $225 r0 *1 25.53,66.015 pfet
M$225 SELp2|X \$108 VPB|VPWR VPB|VPWR pfet L=0.15U W=1U AS=0.16655P AD=0.475P
+ PS=1.39U PD=2.95U
* device instance $226 r0 *1 44.81,65.935 pfet
M$226 \$119 A|A0|B|DOUT9 VPB|VPWR VPB|VPWR pfet L=0.15U W=0.42U AS=0.1176P
+ AD=0.0567P PS=1.4U PD=0.69U
* device instance $227 r0 *1 45.23,65.935 pfet
M$227 \$119 A|B|DOUT5 VPB|VPWR VPB|VPWR pfet L=0.15U W=0.42U AS=0.16655P
+ AD=0.0567P PS=1.39U PD=0.69U
* device instance $228 r0 *1 45.77,66.015 pfet
M$228 SELp5|X \$119 VPB|VPWR VPB|VPWR pfet L=0.15U W=1U AS=0.16655P AD=0.475P
+ PS=1.39U PD=2.95U
* device instance $229 r0 *1 48.49,65.935 pfet
M$229 \$121 A|B|DOUT0 VPB|VPWR VPB|VPWR pfet L=0.15U W=0.42U AS=0.1176P
+ AD=0.0567P PS=1.4U PD=0.69U
* device instance $230 r0 *1 48.91,65.935 pfet
M$230 \$121 B|Y VPB|VPWR VPB|VPWR pfet L=0.15U W=0.42U AS=0.16655P AD=0.0567P
+ PS=1.39U PD=0.69U
* device instance $231 r0 *1 49.45,66.015 pfet
M$231 SELn0|X \$121 VPB|VPWR VPB|VPWR pfet L=0.15U W=1U AS=0.16655P AD=0.475P
+ PS=1.39U PD=2.95U
* device instance $232 r0 *1 52.63,65.935 pfet
M$232 \$123 A|B|DOUT4 VPB|VPWR VPB|VPWR pfet L=0.15U W=0.42U AS=0.1176P
+ AD=0.0567P PS=1.4U PD=0.69U
* device instance $233 r0 *1 53.05,65.935 pfet
M$233 \$123 B|Y VPB|VPWR VPB|VPWR pfet L=0.15U W=0.42U AS=0.16655P AD=0.0567P
+ PS=1.39U PD=0.69U
* device instance $234 r0 *1 53.59,66.015 pfet
M$234 SELn4|X \$123 VPB|VPWR VPB|VPWR pfet L=0.15U W=1U AS=0.16655P AD=0.475P
+ PS=1.39U PD=2.95U
.ENDS top_glue
