* NEGATIVE CONTROL -- deliberately corrupted, body column only.
*
* Identical to reference.spice except that the four DR-004 boosted body ties
* (Sa_p/Se_p -> BOOST_P, Sa_n/Se_n -> BOOST_N) are moved to VDD, i.e. exactly
* the "conventional" single-VDD-well layout DR-004 forbids. NOTHING else
* changes: every source, gate and drain net, every device size and every
* capacitor is byte-identical to reference.spice.
*
* run-flow.sh requires `klt lvs` to report MISMATCH against this file. Without
* that verdict, the MATCH against reference.spice would prove only that the
* comparison ignores the body column -- a layout that silently drew one
* VDD-tied n-well over the whole PFET set would be DRC-clean, would extract
* nine PFETs, would get every source/gate/drain net right and would still
* report `unbiased_pmos_body_nets: []`.
*
* Hand-written LVS reference netlist for the FULL sampling front end sub-block
* (issue #99), against which layout/sampling-frontend/bin/run-flow.sh's
* composed layout is compared.
*
* Scope: every device design/sampling_frontend.sch instantiates -- eleven
* `sky130_fd_pr__nfet_01v8`, nine `sky130_fd_pr__pfet_01v8` and four
* `sky130_fd_pr__cap_mim_m3_1` -- unlike
* layout/sampling-frontend-wells/reference.spice, which is deliberately the
* PFET-only slice that issue #122 needed to falsify a well-isolation claim.
*
* Topology and device sizing are transcribed 1:1 from
* sim/sampling-frontend/testbench/sampling_frontend_dut.spice -- the
* xschem-derived, already-simulated device fragment for
* design/sampling_frontend.sch (issue #52) -- and generalized to the generic
* `pfet`/`nfet` device classes and the `sky130_fd_pr__model__cap_mim` class
* that `klt extract --deck sky130`'s curated deck reports (the same convention
* layout/comparator/reference.spice, layout/cdac-array/'s generated reference
* and layout/trivial-cell/reference.spice all use, and for the same reason:
* the layout side can only ever report the generic class).
*
* THE BODY COLUMN IS LOAD-BEARING, per DR-004 / DR-007.
* In an M-card `M<name> D G S B ...` the fourth net is the body terminal. Four
* of the nine PFETs declare a body that is NOT VDD:
*
*   M_SA_P / M_SE_P  -> BOOST_P
*   M_SA_N / M_SE_N  -> BOOST_N
*
* because BOOST_x rises above VDD during sampling, so a VDD-tied body would
* forward-bias those devices' drain/body junction once BOOST exceeds VDD by a
* diode drop. bin/build_layout.py draws three physically separate n-well
* islands and routes each island's tap to its own domain net, so `klt extract`
* resolves each PMOS body from the island it actually sits in;
* reference.broken-body-tie.spice is the negative control that proves LVS can
* *see* the body column at all.
*
* THE CAPACITOR TOP PLATES ARE ALSO LOAD-BEARING, and are the reason this file
* could not exist before layout/requirements.txt moved to klt 0.4.0. On the
* 0.3.0 pin, `klt extract`'s MiM-cap top-plate-via exclusion was scoped to the
* whole drawn met3 layer rather than to met3 that actually touches a capm
* plate, so every legal via3 in the layout was dropped from the deck's generic
* via3 connectivity and all four cap top plates extracted as isolated,
* single-terminal nets (`extract.json`'s own `single_terminal_nets[]` flagged
* them). reference.broken-topology.spice is the negative control for exactly
* that failure mode: it moves the two sampling caps' top plates off TOP_P/TOP_N
* and must be reported as a mismatch.
*
* Capacitance values are the curated deck's own two-term law for
* sky130_fd_pr__cap_mim_m3_1, C = camimc*W*L + cpmimc*2*(W+L) with
* camimc = 2.0 fF/um^2 and cpmimc = 0.19 fF/um (klt's sky130 extraction deck,
* tt corner), evaluated at the schematic's drawn plate sizes:
*   Cboot: W=L=9.8 um  -> 2.0e-15*96.04   + 1.9e-16*39.2  = 1.99528e-13 F
*   Csamp: W=L=46.9 um -> 2.0e-15*2199.61 + 1.9e-16*187.6 = 4.434864e-12 F
*
* Net names below match design/sampling_frontend.sch's own net names;
* `klt lvs`/`NetlistComparer` compares topology rather than net names, but the
* layout side draws eleven of them as met2.pin labels so the reported net
* correspondence reads directly. GND is the twelfth port: it has no drawn pin
* label, because `klt extract` synthesizes the NMOS body/substrate net
* (`vsubs`) globally and the drawn p-substrate tap merges GND into it (see
* bin/build_layout.py's docstring).
*
* Provenance: pattern (generic device classes, schematic-derived topology,
* positive + negative controls) follows layout/comparator/reference.spice and
* layout/sampling-frontend-wells/reference.spice; the device list is
* re-derived from this repo's own design/sampling_frontend.sch, not copied from
* any sibling or external implementation -- clean-room, per CLAUDE.md.
.SUBCKT sampling_frontend VDD GND SAMPLE VCM VINP VINN TOP_P TOP_N BPREF_P
+ BPREF_N BOOST_P BOOST_N
* --- input sampling switches (the matched differential pair) ---------------
M_MSW_P   VINP    G_P     TOP_P   GND     nfet L=0.15U W=2U
M_MSW_N   VINN    G_N     TOP_N   GND     nfet L=0.15U W=2U
* --- bootstrap / precharge NFETs -------------------------------------------
M_SB_P    BSBOT_P SAMPLEB GND     GND     nfet L=0.15U W=1U
M_SCN_P   BSBOT_P SAMPLE  VINP    GND     nfet L=0.15U W=1U
M_SD_P    G_P     SAMPLEB GND     GND     nfet L=0.5U  W=1U
M_CMSWN_P BPREF_P SAMPLE  VCM     GND     nfet L=0.15U W=1U
M_CMSWN_N BPREF_N SAMPLE  VCM     GND     nfet L=0.15U W=1U
M_SD_N    G_N     SAMPLEB GND     GND     nfet L=0.5U  W=1U
M_SCN_N   BSBOT_N SAMPLE  VINN    GND     nfet L=0.15U W=1U
M_SB_N    BSBOT_N SAMPLEB GND     GND     nfet L=0.15U W=1U
M_INVN    SAMPLEB SAMPLE  GND     GND     nfet L=0.15U W=1U
* --- bootstrap / precharge PFETs (body column per DR-004) ------------------
M_SA_P    BOOST_P SAMPLE  VDD     VDD     pfet L=0.5U  W=1U
M_SE_P    G_P     SAMPLEB BOOST_P VDD     pfet L=0.15U W=1U
M_SCP_P   BSBOT_P SAMPLEB VINP    VDD     pfet L=0.15U W=1U
M_CMSWP_P BPREF_P SAMPLEB VCM     VDD     pfet L=0.15U W=1U
M_INVP    SAMPLEB SAMPLE  VDD     VDD     pfet L=0.15U W=2U
M_CMSWP_N BPREF_N SAMPLEB VCM     VDD     pfet L=0.15U W=1U
M_SCP_N   BSBOT_N SAMPLEB VINN    VDD     pfet L=0.15U W=1U
M_SE_N    G_N     SAMPLEB BOOST_N VDD     pfet L=0.15U W=1U
M_SA_N    BOOST_N SAMPLE  VDD     VDD     pfet L=0.5U  W=1U
* --- MiM capacitors: bottom plate first (P1), top plate second (P2) --------
C_CBOOT_P BSBOT_P BOOST_P 1.99528e-13 sky130_fd_pr__model__cap_mim
C_CBOOT_N BSBOT_N BOOST_N 1.99528e-13 sky130_fd_pr__model__cap_mim
C_CSAMP_P BPREF_P TOP_P   4.434864e-12 sky130_fd_pr__model__cap_mim
C_CSAMP_N BPREF_N TOP_N   4.434864e-12 sky130_fd_pr__model__cap_mim
.ENDS sampling_frontend
