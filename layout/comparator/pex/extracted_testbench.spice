* extracted_testbench.spice -- extracted-side leg of the comparator PEX
* delta (issue #112). Byte-identical to testbench.spice's stimulus (see
* that file for the pick-off methodology and corner-point design); the
* ONLY difference is the `.include` target, pointed at this sub-block's own
* freshly `--parasitics`-extracted, unit-normalized netlist
* (comparator.pex-extract.normalized.spice, written per-record by
* run_pex.py -- not a file that lives permanently in this directory)
* instead of the schematic DUT.
*
* This file exists as a SEPARATE, hand-maintained copy -- not generated by
* `klt pex`'s own DUT-`.include`-swap machinery -- because `klt pex`
* end-to-end hit two independent tool bugs on this sub-block, both filed
* generically per CLAUDE.md's friction protocol (see
* layout/comparator/pex/README.md for the citations and full workaround
* writeup):
*
*   1. `klt pex`'s generated extracted-side request copy re-resolves a
*      relative `models.lib` path against the ORIGINAL request file's own
*      directory instead of the PDK-variant directory `models.pdk` would
*      resolve it against -- "model library not found", even though the
*      identical request runs fine standalone via `klt sim` and on `klt
*      pex`'s own schematic-side leg.
*   2. `klt extract --pdk sky130A --parasitics`'s sky130 MOS binding writes
*      device geometry (L/W/AS/AD/PS/PD) with explicit SPICE unit suffixes
*      (e.g. `L=0.5U`); sky130's vendor model deck sets `.option
*      scale=1.0u` and its own internal NRD/NRS default-value formula
*      assumes bare, suffix-free micron literals (the same convention
*      sim/comparator-decision/testbench/comparator_core.spice's
*      hand/xschem-authored device cards already use) -- feeding it
*      unit-suffixed values instead makes the model's computed default NRD
*      off by ~1e6, and ngspice refuses the deck with "could not find a
*      valid modelname" (verified empirically on a single-device minimal
*      repro). `normalize_extracted_units.py` in this directory is the
*      mechanical, value-preserving workaround: it rewrites those six
*      fields to bare micron numbers so the affected devices simulate as
*      the physically-intended geometry.
.param vdd_val=1.8

Vdd VDD 0 DC {vdd_val}
Vclk CLK 0 PULSE(0 {vdd_val} 5n 0.1n 0.1n 1.5n 16.6n)
Vinp VINP 0 DC 0.9
Vinn VINN 0 DC 0.9

.include "comparator.pex-extract.normalized.spice"
Xdut CLK GND OUTN OUTP VDD VINN VINP gen_compose_0
