* testbench.spice -- `klt pex` testbench body for the comparator sub-block
* (issue #112), reusing sim/comparator-decision/run.py's own pick-off
* methodology: a single reset(CLK=0)->evaluate(CLK=VDD) transient edge,
* Vindiff applied as a DC differential on VINP/VINN, decision statistic
* v(OUTP)/v(OUTN) sampled PICKOFF_NS=1.2ns after the evaluate edge starts
* (RESET_NS=5ns + RESET_TR_NS=0.1ns -> absolute pick-off time 6.3ns) -- see
* that file's `_pickoff_deck()` for the ORIGINAL PICKOFF_NS=0.3ns/5.4ns
* numbers this once reproduced.
*
* Re-derived for DR-004 Amendment A's extracted (parasitic-loaded) leg
* (issue #187): the original 0.3ns/5.4ns instant was calibrated against the
* pre-#175 topology and produced a sign-flipped extracted-side pick-off
* differential against this topology's real routing parasitics (negative for
* a positive applied Vindiff -- see `reports/20260906-101231-1250ff4/
* record.md`'s AC3). `layout/comparator/pex/regen_probe.py`'s reset->evaluate
* transient sweep (`reports/20260906-144802-eace0b6/record.md`) found the
* extracted leg's own regeneration onset is measurably delayed relative to
* the ideal schematic leg by the real parasitic R/C on DIP/DIN/OUTP/OUTN,
* and that its pick-off differential does not cross from the sign-flipped
* artifact region to a clean, correctly-signed, non-saturated response until
* ~1.0-1.2ns after the evaluate edge -- 1.2ns was chosen as the new instant
* (see that record's "Recommendation" section for the full derivation and a
* corner spot check at ss/-40C and ff/125C).
*
* CORNER AXES (issue #1017's re-mint at the ratified 9-point OAT grid):
* `vdd` is a literal DC source keyed by `corners.supply_v` (the alter
* gotcha below), and the evaluate clock TRACKS the rail at every corner the
* way sim/comparator-decision's own regen-corners campaign drives it
* ("reset(CLK=0)->evaluate(CLK=supply)"). The original bench's
* `PULSE(0 {vdd_val} ...)` amplitude cannot be altered (ngspice `alter`
* sets a named source's DC value, not a waveform parameter), so the clock
* is now an ideal switch (`Sclk`) that connects the CLK node to the VDD
* RAIL NODE while a fixed-amplitude PWL control enables it -- the same
* ideal-switch primitive this repo's other pex testbenches already use.
* The 100MEG bleed gives the reset phase its CLK=0 level (the DUT's CLK
* load is purely capacitive). The evaluate high level is then exactly
* v(VDD) at every rail, e.g. 1.62V at the -10% supply corner.
*
* Vindiff's two points per OAT rail (see run_pex.py's generated requests):
*   - zero: vinp=vinn=vdd/2 -- Vindiff=0. Both legs' *devices* are
*     identical on both the schematic DUT and (since `klt pex` extracts
*     this composed layout's real device instances, not a stochastically
*     mismatched draw) the extracted netlist too -- so a nonzero pick-off
*     differential at this point isolates the ROUTING/parasitic-driven
*     imbalance alone, with device mismatch structurally excluded from
*     the comparison.
*   - cal: vinp=vdd/2+5mV, vinn=vdd/2-5mV -- Vindiff=+10mV, one of
*     run.py's own VINDIFF_GAIN_CAL_MV gain-calibration points, included so
*     the zero-point delta can be converted to an input-referred quantity
*     via the same zero-intercept-gain technique run.py's `offset`
*     subcommand uses, without re-deriving a new methodology.
*
* `.include`s the schematic-equivalent DUT (comparator_pex_reference.spice
* -- see that file's own header for why it exists as a separate,
* `.SUBCKT`-wrapped file rather than reusing comparator_core.spice
* directly). `klt pex` rewrites only that one line to point at its own
* freshly `--parasitics`-extracted netlist for the extracted-side leg; the
* schematic-side leg runs this file completely unmodified.
Vdd VDD 0 DC 1.8
Vinp VINP 0 DC 0.9
Vinn VINN 0 DC 0.9

Vclken nclk 0 PULSE(0 1.8 5n 0.1n 0.1n 1.5n 16.6n)
.model SWCLK SW(Ron=1 Roff=1e12 Vt=0.9 Vh=0.05)
Sclk CLK VDD nclk 0 SWCLK
Rclkbleed CLK 0 100e6

.include "comparator_pex_reference.spice"
Xdut CLK GND OUTN OUTP VDD VINN VINP gen_compose_0
