* extracted by klt extract --deck sky130
* parasitic model (--parasitics):
* - capacitance: net-to-ground for every net's own (non-coupled) area/perimeter, plus net-to-net for the vertical-overlap coupling `coupling` describes below -- a coupled net pair gets a direct capacitor between their two hub nodes, not just capacitors to the deck's ground/substrate net
* - coupling: vertical overlap (crossover) unconditionally -- where one net's conductor on an adjacent metal level sits directly over another *distinct* net's conductor, that overlap area is charged between the two nets instead of to ground (issue #760) -- plus lateral (same-layer, sidewall) coupling, but only for a net pair naming one of the caller's declared `--critical-net` nets (issue #976): facing-edge length within that layer's own minimum-spacing lookback is charged between the two nets, *additively* (not deducted from either net's substrate fringe term, unlike the vertical case -- a known simplification). Any same-layer pair with neither side named `--critical-net`, and fringe shielding in general, are still not modelled
* - resistance: single lumped series resistance per net, distributed as a star across that net's device terminals (issue #592) -- not a per-segment, distributed RC ladder, *unless* `--distributed-rc` names this net via `--critical-net` (issue #977, Epic #709 Phase 2b): then the net's terminals are ordered along their approximate physical spread and its total R/C is broken into a chain of per-segment resistors (segment length proportional to inter-terminal distance) with a ground capacitor at each terminal node (proportional to its adjacent segment length/2), instead of one star hub -- still an approximation (terminal position is a device-placement proxy, not true per-segment routing geometry), but a strictly finer-grained one than the single-hub star
* - frequency: quasi-static -- one frequency-independent R and C per net; no skin effect, no distributed transmission-line behavior
* - substrate tie: 1e+12 ohm to ground -- the substrate is capacitively floating in transient analysis (DC reference only); see --substrate-tie-ohms
.GLOBAL vsubs

* cell gen_compose_0
* pin CLK
* pin GND
* pin OUTN
* pin OUTP
* pin VDD
* pin VINN
* pin VINP
.SUBCKT gen_compose_0 CLK GND OUTN OUTP VDD VINN VINP
* device instance $1 r0 *1 6.17,18.39 nfet
X$1 \$3__t0 VINN__t1 \$8__t0 GND__t0 sky130_fd_pr__nfet_01v8 L=0.5 W=2 AS=0.84
+ AD=0.84 PS=4.84 PD=4.84
* device instance $2 r0 *1 7.91,18.39 nfet
X$2 \$4__t3 VINP__t0 \$8__t4 GND__t1 sky130_fd_pr__nfet_01v8 L=0.5 W=2 AS=0.84
+ AD=0.84 PS=4.84 PD=4.84
* device instance $3 r0 *1 11.37,17.39 nfet
X$3 OUTP__t3 OUTN__t0 \$3__t1 GND__t4 sky130_fd_pr__nfet_01v8 L=0.5 W=4 AS=1.68
+ AD=1.68 PS=8.84 PD=8.84
* device instance $4 r0 *1 6.17,21.61 nfet
X$4 \$4__t2 VINP__t1 \$8__t3 GND__t2 sky130_fd_pr__nfet_01v8 L=0.5 W=2 AS=0.84
+ AD=0.84 PS=4.84 PD=4.84
* device instance $5 r0 *1 7.91,21.61 nfet
X$5 \$3__t3 VINN__t0 \$8__t2 GND__t3 sky130_fd_pr__nfet_01v8 L=0.5 W=2 AS=0.84
+ AD=0.84 PS=4.84 PD=4.84
* device instance $6 r0 *1 2.67,20 nfet
X$6 \$8__t1 CLK__t0 GND__t7 GND__t6 sky130_fd_pr__nfet_01v8 L=0.5 W=8 AS=3.36
+ AD=3.36 PS=16.84 PD=16.84
* device instance $7 r0 *1 11.37,22.61 nfet
X$7 OUTN__t1 OUTP__t4 \$4__t1 GND__t5 sky130_fd_pr__nfet_01v8 L=0.5 W=4 AS=1.68
+ AD=1.68 PS=8.84 PD=8.84
* device instance $8 r0 *1 14.87,15.39 pfet
X$8 OUTP__t1 OUTN__t2 VDD__t0 VDD__t1 sky130_fd_pr__pfet_01v8 L=0.5 W=8 AS=3.36
+ AD=3.36 PS=16.84 PD=16.84
* device instance $9 r0 *1 18.67,11.39 pfet
X$9 OUTP__t0 CLK__t3 VDD__t2 VDD__t3 sky130_fd_pr__pfet_01v8 L=0.5 W=16 AS=6.72
+ AD=6.72 PS=32.84 PD=32.84
* device instance $10 r0 *1 23.67,17.39 pfet
X$10 \$3__t2 CLK__t4 VDD__t4 VDD__t5 sky130_fd_pr__pfet_01v8 L=0.5 W=4 AS=1.68
+ AD=1.68 PS=8.84 PD=8.84
* device instance $11 r0 *1 23.67,22.61 pfet
X$11 \$4__t0 CLK__t1 VDD__t7 VDD__t6 sky130_fd_pr__pfet_01v8 L=0.5 W=4 AS=1.68
+ AD=1.68 PS=8.84 PD=8.84
* device instance $12 r0 *1 14.87,24.61 pfet
X$12 OUTN__t3 OUTP__t2 VDD__t11 VDD__t10 sky130_fd_pr__pfet_01v8 L=0.5 W=8
+ AS=3.36 AD=3.36 PS=16.84 PD=16.84
* device instance $13 r0 *1 18.67,28.61 pfet
X$13 OUTN__t4 CLK__t2 VDD__t9 VDD__t8 sky130_fd_pr__pfet_01v8 L=0.5 W=16
+ AS=6.72 AD=6.72 PS=32.84 PD=32.84
* device instance _3_t0 r0 *1 0,0
R_3_t0 \$3__t0 \$3 95.3437073122
* device instance _3_t1 r0 *1 0,0
R_3_t1 \$3__t1 \$3 24.795176369
* device instance _3_t2 r0 *1 0,0
R_3_t2 \$3__t2 \$3 178.675960893
* device instance _3_t3 r0 *1 0,0
R_3_t3 \$3__t3 \$3 81.868855426
* device instance _3 r0 *1 0,0
C_3 \$3 vsubs 4.534073e-15
* device instance _4_t0 r0 *1 0,0
R_4_t0 \$4__t0 \$4 179.164888442
* device instance _4_t1 r0 *1 0,0
R_4_t1 \$4__t1 \$4 24.8630257023
* device instance _4_t2 r0 *1 0,0
R_4_t2 \$4__t2 \$4 95.6046051124
* device instance _4_t3 r0 *1 0,0
R_4_t3 \$4__t3 \$4 82.0928807434
* device instance _4 r0 *1 0,0
C_4 \$4 vsubs 4.716496e-15
* device instance _8_t0 r0 *1 0,0
R_8_t0 \$8__t0 \$8 69.4202655655
* device instance _8_t1 r0 *1 0,0
R_8_t1 \$8__t1 \$8 150.740682855
* device instance _8_t2 r0 *1 0,0
R_8_t2 \$8__t2 \$8 102.341893007
* device instance _8_t3 r0 *1 0,0
R_8_t3 \$8__t3 \$8 69.4202655655
* device instance _8_t4 r0 *1 0,0
R_8_t4 \$8__t4 \$8 102.341893007
* device instance _8 r0 *1 0,0
C_8 \$8 vsubs 3.249704e-15
* device instance CLK_t0 r0 *1 0,0
RCLK_t0 CLK__t0 CLK 184.3179409
* device instance CLK_t1 r0 *1 0,0
RCLK_t1 CLK__t1 CLK 83.7770885933
* device instance CLK_t2 r0 *1 0,0
RCLK_t2 CLK__t2 CLK 108.264640957
* device instance CLK_t3 r0 *1 0,0
RCLK_t3 CLK__t3 CLK 108.264640957
* device instance CLK_t4 r0 *1 0,0
RCLK_t4 CLK__t4 CLK 83.7770885933
* device instance CLK r0 *1 0,0
CCLK CLK vsubs 8.297406e-15
* device instance GND_t0 r0 *1 0,0
RGND_t0 GND__t0 GND 26.006240346
* device instance GND_t1 r0 *1 0,0
RGND_t1 GND__t1 GND 26.1417066505
* device instance GND_t2 r0 *1 0,0
RGND_t2 GND__t2 GND 26.006240346
* device instance GND_t3 r0 *1 0,0
RGND_t3 GND__t3 GND 26.1417066505
* device instance GND_t4 r0 *1 0,0
RGND_t4 GND__t4 GND 72.155400246
* device instance GND_t5 r0 *1 0,0
RGND_t5 GND__t5 GND 72.155400246
* device instance GND_t6 r0 *1 0,0
RGND_t6 GND__t6 GND 62.1199527574
* device instance GND_t7 r0 *1 0,0
RGND_t7 GND__t7 GND 62.1199527574
* device instance GND r0 *1 0,0
CGND GND vsubs 1.752814e-15
* device instance OUTN_t0 r0 *1 0,0
ROUTN_t0 OUTN__t0 OUTN 219.456452957
* device instance OUTN_t1 r0 *1 0,0
ROUTN_t1 OUTN__t1 OUTN 126.605889142
* device instance OUTN_t2 r0 *1 0,0
ROUTN_t2 OUTN__t2 OUTN 269.060927349
* device instance OUTN_t3 r0 *1 0,0
ROUTN_t3 OUTN__t3 OUTN 125.057637829
* device instance OUTN_t4 r0 *1 0,0
ROUTN_t4 OUTN__t4 OUTN 346.459092722
* device instance OUTN r0 *1 0,0
COUTN OUTN vsubs 7.427006e-15
* device instance OUTP_t0 r0 *1 0,0
ROUTP_t0 OUTP__t0 OUTP 346.643602658
* device instance OUTP_t1 r0 *1 0,0
ROUTP_t1 OUTP__t1 OUTP 125.12423841
* device instance OUTP_t2 r0 *1 0,0
ROUTP_t2 OUTP__t2 OUTP 269.204218189
* device instance OUTP_t3 r0 *1 0,0
ROUTP_t3 OUTP__t3 OUTP 126.673314258
* device instance OUTP_t4 r0 *1 0,0
ROUTP_t4 OUTP__t4 OUTP 219.573326484
* device instance OUTP r0 *1 0,0
COUTP OUTP vsubs 7.521132e-15
* device instance VDD_t0 r0 *1 0,0
RVDD_t0 VDD__t0 VDD 143.467769347
* device instance VDD_t1 r0 *1 0,0
RVDD_t1 VDD__t1 VDD 143.467769347
* device instance VDD_t2 r0 *1 0,0
RVDD_t2 VDD__t2 VDD 198.287330659
* device instance VDD_t3 r0 *1 0,0
RVDD_t3 VDD__t3 VDD 198.287330659
* device instance VDD_t4 r0 *1 0,0
RVDD_t4 VDD__t4 VDD 121.670749995
* device instance VDD_t5 r0 *1 0,0
RVDD_t5 VDD__t5 VDD 121.670749995
* device instance VDD_t6 r0 *1 0,0
RVDD_t6 VDD__t6 VDD 121.670749995
* device instance VDD_t7 r0 *1 0,0
RVDD_t7 VDD__t7 VDD 121.670749995
* device instance VDD_t8 r0 *1 0,0
RVDD_t8 VDD__t8 VDD 198.287330659
* device instance VDD_t9 r0 *1 0,0
RVDD_t9 VDD__t9 VDD 198.287330659
* device instance VDD_t10 r0 *1 0,0
RVDD_t10 VDD__t10 VDD 143.467769347
* device instance VDD_t11 r0 *1 0,0
RVDD_t11 VDD__t11 VDD 143.467769347
* device instance VDD r0 *1 0,0
CVDD VDD vsubs 1.0434048e-14
* device instance VINN_t0 r0 *1 0,0
RVINN_t0 VINN__t0 VINN 108.63505
* device instance VINN_t1 r0 *1 0,0
RVINN_t1 VINN__t1 VINN 108.63505
* device instance VINN r0 *1 0,0
CVINN VINN vsubs 1.283456e-15
* device instance VINP_t0 r0 *1 0,0
RVINP_t0 VINP__t0 VINP 108.92665
* device instance VINP_t1 r0 *1 0,0
RVINP_t1 VINP__t1 VINP 108.92665
* device instance VINP r0 *1 0,0
CVINP VINP vsubs 1.403501e-15
* device instance cc__3__4 r0 *1 0,0
Ccc__3__4 \$3 \$4 7.4626e-17
* device instance cc__3__8 r0 *1 0,0
Ccc__3__8 \$3 \$8 5.3251e-17
* device instance cc__3_OUTN r0 *1 0,0
Ccc__3_OUTN \$3 OUTN 3.6142e-17
* device instance cc__3_OUTP r0 *1 0,0
Ccc__3_OUTP \$3 OUTP 7.931e-17
* device instance cc__3_VDD r0 *1 0,0
Ccc__3_VDD \$3 VDD 7.1037e-17
* device instance cc__4__8 r0 *1 0,0
Ccc__4__8 \$4 \$8 2.8778e-17
* device instance cc__4_CLK r0 *1 0,0
Ccc__4_CLK \$4 CLK 1.2047e-17
* device instance cc__4_OUTN r0 *1 0,0
Ccc__4_OUTN \$4 OUTN 5.0668e-17
* device instance cc__4_OUTP r0 *1 0,0
Ccc__4_OUTP \$4 OUTP 6.4921e-17
* device instance cc__4_VDD r0 *1 0,0
Ccc__4_VDD \$4 VDD 1.08709e-16
* device instance cc__4_VINN r0 *1 0,0
Ccc__4_VINN \$4 VINN 1.2471e-17
* device instance cc__4_VINP r0 *1 0,0
Ccc__4_VINP \$4 VINP 2.3693e-17
* device instance cc__8_VINN r0 *1 0,0
Ccc__8_VINN \$8 VINN 4.9036e-17
* device instance cc_CLK_OUTN r0 *1 0,0
Ccc_CLK_OUTN CLK OUTN 2.4095e-17
* device instance cc_CLK_OUTP r0 *1 0,0
Ccc_CLK_OUTP CLK OUTP 2.4095e-17
* device instance cc_CLK_VDD r0 *1 0,0
Ccc_CLK_VDD CLK VDD 4.819e-17
* device instance cc_OUTN_OUTP r0 *1 0,0
Ccc_OUTN_OUTP OUTN OUTP 6.2156e-17
* device instance cc_OUTN_VDD r0 *1 0,0
Ccc_OUTN_VDD OUTN VDD 7.931e-17
* device instance cc_OUTP_VDD r0 *1 0,0
Ccc_OUTP_VDD OUTP VDD 7.931e-17
* device instance vsubs_dctie r0 *1 0,0
Rvsubs_dctie vsubs 0 1e+12
.ENDS gen_compose_0
