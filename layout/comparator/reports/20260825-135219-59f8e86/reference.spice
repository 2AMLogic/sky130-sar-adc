* Hand-written LVS reference netlist for the dynamic comparator sub-block
* (issue #101), against which layout/comparator/bin/run-flow.sh's composed
* layout is compared.
*
* Topology and device sizing are copied 1:1 from
* sim/comparator-decision/testbench/comparator_core.spice -- the xschem
* -derived, already-simulated device fragment for design/comparator.sch
* (issue #54) -- generalizing every `sky130_fd_pr__{n,p}fet_01v8` instance to
* the generic `nfet`/`pfet` device classes `klt extract --deck sky130`'s
* curated deck reports (matching layout/trivial-cell/reference.spice's and
* layout/sar-sequencer/reference/sar_sequencer.lvs-reference.spice's own
* convention for the same reason: the layout side of the comparison can only
* ever report those two generic classes, regardless of the real device
* flavor).
*
* Each schematic device (M_INN, M_INP, M_LATN_P/N, M_LATP_P/N, M_RST_P/N) is
* one lumped M-card at its full schematic W, not split into
* layout/comparator/bin/gen_blocks.py's own interleaved/multi-leg unit
* instances -- `klt lvs`'s `options.combine_devices` (set in
* layout/comparator/bin/run-flow.sh's own lvs.request.json) is what re-lumps
* the layout side's parallel unit legs back into one equivalent device per
* schematic instance for comparison, exactly as
* layout/sar-sequencer/bin/run-flow.sh's own lvs.request.json already relies
* on for that sub-block's folded/multi-finger standard cells. Concretely: the
* input pair's four common-centroid W=2u legs re-lump into the two W=4u
* devices declared below.
*
* Body terminals are REAL here, not aspirational: layout/comparator/bin/
* build_layout.py draws a p-substrate tie (tap outside every n-well,
* contacted up to GND) and an n-well tie (tap inside the well, contacted up
* to VDD), so `klt extract` resolves every nfet body to GND and every pfet
* body to VDD rather than to KLayout's synthesized `vsubs`/anonymous proxy
* net. run-flow.sh's own record asserts that separately from the LVS verdict
* (`unbiased_pmos_body_nets` must be empty) -- see render-record.py's verdict
* 6, because an LVS "match" against a reference that declared the proxy net
* would prove nothing about the ties actually being drawn.
*
* Net names below (VDD/GND/CLK/VINP/VINN/OUTP/OUTN/TAIL) match
* design/comparator.sch's own port/net names; `klt lvs`/`NetlistComparer`
* compares topology rather than net names, but the layout side draws the same
* seven names as met1.pin labels so the reported net correspondence reads
* directly.
*
* Provenance: pattern (generic device classes, schematic-derived topology,
* combine_devices for split/interleaved layout legs) ported from
* layout/trivial-cell/reference.spice and
* layout/sar-sequencer/bin/generate-lvs-reference.py, per CLAUDE.md's
* "Harness bootstrap" instruction -- device list re-derived against this
* repo's own design/comparator.sch, not copied from either sibling.
.SUBCKT comparator VDD GND CLK VINP VINN OUTP OUTN
M_TAIL TAIL CLK GND GND nfet L=0.5U W=8U
M_INN OUTP VINN TAIL GND nfet L=0.5U W=4U
M_INP OUTN VINP TAIL GND nfet L=0.5U W=4U
M_LATN_P OUTP OUTN GND GND nfet L=0.5U W=4U
M_LATN_N OUTN OUTP GND GND nfet L=0.5U W=4U
M_LATP_P OUTP OUTN VDD VDD pfet L=0.5U W=8U
M_LATP_N OUTN OUTP VDD VDD pfet L=0.5U W=8U
M_RST_P OUTP CLK VDD VDD pfet L=0.5U W=16U
M_RST_N OUTN CLK VDD VDD pfet L=0.5U W=16U
.ENDS comparator
