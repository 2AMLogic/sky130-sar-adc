* extracted by klt extract --deck sky130

* cell gen_compose_0
* pin CLK
* pin GND
* pin OUTP
* pin TAIL
* pin VDD
* pin VINN
* pin vsubs
.SUBCKT gen_compose_0 CLK GND OUTP TAIL VDD VINN vsubs
* device instance $1 r0 *1 5.01,1 nfet
M$1 \$7 VINN TAIL vsubs nfet L=0.5U W=2U AS=0.84P AD=0.84P PS=4.84U PD=4.84U
* device instance $2 r0 *1 6.75,1 nfet
M$2 \$8 \$1 TAIL vsubs nfet L=0.5U W=2U AS=0.84P AD=0.84P PS=4.84U PD=4.84U
* device instance $3 r0 *1 11.09,2 nfet
M$3 OUTP \$2 GND vsubs nfet L=0.5U W=4U AS=1.68P AD=1.68P PS=8.84U PD=8.84U
* device instance $4 r0 *1 5.01,4.22 nfet
M$4 \$11 \$5 TAIL vsubs nfet L=0.5U W=2U AS=0.84P AD=0.84P PS=4.84U PD=4.84U
* device instance $5 r0 *1 6.75,4.22 nfet
M$5 \$13 VINN \$12 vsubs nfet L=0.5U W=2U AS=0.84P AD=0.84P PS=4.84U PD=4.84U
* device instance $6 r0 *1 0.67,4 nfet
M$6 TAIL CLK \$10 vsubs nfet L=0.5U W=8U AS=3.36P AD=3.36P PS=16.84U PD=16.84U
* device instance $7 r0 *1 11.09,7.22 nfet
M$7 \$16 OUTP GND vsubs nfet L=0.5U W=4U AS=1.68P AD=1.68P PS=8.84U PD=8.84U
* device instance $8 r0 *1 15.58,4 pfet
M$8 OUTP \$3 VDD \$22 pfet L=0.5U W=8U AS=3.36P AD=3.36P PS=16.84U PD=16.84U
* device instance $9 r0 *1 20.22,8 pfet
M$9 \$19 CLK \$18 \$23 pfet L=0.5U W=16U AS=6.72P AD=6.72P PS=32.84U PD=32.84U
* device instance $10 r0 *1 15.58,13.22 pfet
M$10 \$17 OUTP VDD \$22 pfet L=0.5U W=8U AS=3.36P AD=3.36P PS=16.84U PD=16.84U
* device instance $11 r0 *1 20.22,25.22 pfet
M$11 \$21 CLK \$18 \$23 pfet L=0.5U W=16U AS=6.72P AD=6.72P PS=32.84U PD=32.84U
.ENDS gen_compose_0
