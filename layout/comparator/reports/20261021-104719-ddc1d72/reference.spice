* Hand-written LVS reference netlist for the dynamic comparator sub-block
* (issue #101), against which layout/comparator/bin/run-flow.sh's composed
* layout is compared.
*
* Topology and device sizing are copied 1:1 from
* sim/comparator-decision/testbench/comparator_core.spice -- the xschem
* -derived, already-simulated device fragment for design/comparator.sch
* (issue #54) -- generalizing every `sky130_fd_pr__{n,p}fet_01v8` instance to
* the generic `nfet`/`pfet` device classes `klt extract --deck sky130`'s
* curated deck reports (matching layout/trivial-cell/reference.spice's and
* layout/sar-sequencer/reference/sar_sequencer.lvs-reference.spice's own
* convention for the same reason: the layout side of the comparison can only
* ever report those two generic classes, regardless of the real device
* flavor).
*
* DR-004 Amendment A changed design/comparator.sch from the 9-device variant
* this block was originally drawn against to the 11-device StrongARM
* arrangement below: the input pair's drains moved onto their own internal
* nodes DIP/DIN, the cross-coupled NMOS pair's sources moved from GND onto
* those same nodes, and two CLK-gated PMOS precharge devices
* (M_RST_DIP/M_RST_DIN) were added on them. The device list below is
* re-derived from the amended
* sim/comparator-decision/testbench/comparator_core.spice, per this file's own
* "copied 1:1" contract -- leaving it at the superseded device set would make
* an LVS "match" a statement about a schematic that no longer exists.
*
* The composed layout under layout/comparator/reports/ has since been
* re-drawn against this amended 11-device topology (issue #180): `klt lvs`
* against this reference now reports MATCH (11/11 devices) -- see
* layout/comparator/README.md's status section and reports/LATEST for the
* current record.
*
* Each schematic device (M_INN, M_INP, M_LATN_P/N, M_LATP_P/N, M_RST_P/N,
* M_RST_DIP/DIN) is one lumped M-card at its full schematic W, not split into
* layout/comparator/bin/gen_blocks.py's own interleaved/multi-leg unit
* instances -- `klt lvs`'s `options.combine_devices` (set in
* layout/comparator/bin/run-flow.sh's own lvs.request.json) is what re-lumps
* the layout side's parallel unit legs back into one equivalent device per
* schematic instance for comparison, exactly as
* layout/sar-sequencer/bin/run-flow.sh's own lvs.request.json already relies
* on for that sub-block's folded/multi-finger standard cells. Concretely: the
* input pair's four common-centroid W=2u legs re-lump into the two W=4u
* devices declared below.
*
* Body terminals are REAL here, not aspirational: layout/comparator/bin/
* build_layout.py draws a p-substrate tie (tap outside every n-well,
* contacted up to GND) and an n-well tie (tap inside the well, contacted up
* to VDD), so `klt extract` resolves every nfet body to GND and every pfet
* body to VDD rather than to KLayout's synthesized `vsubs`/anonymous proxy
* net. run-flow.sh's own record asserts that separately from the LVS verdict
* (`unbiased_pmos_body_nets` must be empty) -- see render-record.py's verdict
* 6, because an LVS "match" against a reference that declared the proxy net
* would prove nothing about the ties actually being drawn.
*
* Net names below (VDD/GND/CLK/VINP/VINN/OUTP/OUTN/TAIL/DIP/DIN) match
* design/comparator.sch's own port/net names; `klt lvs`/`NetlistComparer`
* compares topology rather than net names, but the layout side draws the same
* seven names as met1.pin labels so the reported net correspondence reads
* directly.
*
* Provenance: pattern (generic device classes, schematic-derived topology,
* combine_devices for split/interleaved layout legs) ported from
* layout/trivial-cell/reference.spice and
* layout/sar-sequencer/bin/generate-lvs-reference.py, per CLAUDE.md's
* "Harness bootstrap" instruction -- device list re-derived against this
* repo's own design/comparator.sch, not copied from either sibling.
.SUBCKT comparator VDD GND CLK VINP VINN OUTP OUTN
M_TAIL TAIL CLK GND GND nfet L=0.5U W=8U
M_INN DIP VINN TAIL GND nfet L=0.5U W=4U
M_INP DIN VINP TAIL GND nfet L=0.5U W=4U
M_LATN_P OUTP OUTN DIP GND nfet L=0.5U W=4U
M_LATN_N OUTN OUTP DIN GND nfet L=0.5U W=4U
M_LATP_P OUTP OUTN VDD VDD pfet L=0.5U W=8U
M_LATP_N OUTN OUTP VDD VDD pfet L=0.5U W=8U
M_RST_P OUTP CLK VDD VDD pfet L=0.5U W=16U
M_RST_N OUTN CLK VDD VDD pfet L=0.5U W=16U
M_RST_DIP DIP CLK VDD VDD pfet L=0.5U W=4U
M_RST_DIN DIN CLK VDD VDD pfet L=0.5U W=4U
.ENDS comparator
