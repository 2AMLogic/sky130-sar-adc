* testbench.spice -- `klt pex` testbench body for the cdac_array sub-block
* (issue #1017): the DAC transfer characteristic of sim/cdac-array-transfer's
* own methodology (testbench/tb_cdac_array_transfer.spice, issue #53), re-cast
* around the layout's own extracted subckt interface so `klt pex` can swap the
* single `.include` below for its freshly `--parasitics`-extracted netlist and
* diff the schematic leg against the extracted leg, per corner, per code.
*
* As in the transfer campaign, each of the 5 representative 9-bit
* sub-array codes (0, 128, 256, 384, 511) gets its OWN instance of the array --
* P side driven with the code directly, N side with the 9-bit mirrored
* complement -- reset to Vcm by an ideal testbench-only switch until t=1n while
* every bottom plate sits at its pre-code baseline (SEL high, bit=0 -> VREFN),
* then released: at t=1n every bit-1 position's real bottom-plate switch moves
* its bottom plate to VREFP. The settled top-plate pair at t=500n
* (>> RC of any active path) is that code's DAC output, read via the .meas rows
* of the pex request run_pex.py builds. Ideal expected value computed
* independently in run_pex.py: vdiff_ideal(code) = vdd*(2*code-511)/512.
*
* Pin order on every X line below is the EXTRACTED netlist's own (alphabetical)
* order -- layout/cdac-array/reports/LATEST's cdac_array.extract.spice declares
*   .SUBCKT cdac_array SELn0..SELn8 SELp0..SELp8 TOP_N TOP_P VDD VREFN VREFP VSS
* run_pex.py asserts the current extraction still declares exactly this list
* before running, so a re-draw that reorders pins fails loudly here instead of
* silently permuting nets.
*
* CORNER AXES: `vdd` and `vcm` are literal DC sources keyed by corners.supply_v
* in the request run_pex.py builds (the `alter` gotcha: only a named SOURCE is
* an alter target -- layout/comparator/pex/README.md). VCM tracks the rail
* (VCM = VDD/2) as a PAIRED supply point, never independently swept -- the
* settled top-plate value depends on the reset baseline, so a VCM that did not
* follow its corner's rail would swamp the comparison with a ~(VDD/2 - 0.9 V)
* offset, orders of magnitude above an LSB. VREFP is not a separate source at
* all: DR-003 ratifies V_REF = V_DD at the rail, so every VREFP pin below is
* wired straight to the vdd rail node, as are the bit=0 SEL pins. On both PEX
* legs the pulsed SEL and reset highs are fixed at 1.8 V and SWMOD Vt at 0.9 V.
* The transfer campaign uses VDD and VDD/2 respectively, so those levels
* differ at the 1.62 V and 1.98 V corners.

Vdd    vdd    0 DC 1.8
Vrefn  vrefn  0 DC 0
Vss    vss    0 DC 0
Vcm    vcm    0 DC 0.9

* Shared ideal reset-switch control (testbench-only): closed (high) before t=1n
* pins every top node to Vcm; open after lets charge redistribute.
Vctrl_reset nctrl_reset 0 pwl(0 1.8 0.9n 1.8 1.1n 0 500n 0)
.model SWMOD SW(Ron=1 Roff=1e12 Vt=0.9 Vh=0.05)

.include "cdac_array_pex_reference.spice"

* ---- code=0  (P code=0, N code=511) ----
Vsel_0n0 sel_0n0 0 pwl(0 1.8 0.9n 1.8 1.1n 0 500n 0)
Vsel_0n1 sel_0n1 0 pwl(0 1.8 0.9n 1.8 1.1n 0 500n 0)
Vsel_0n2 sel_0n2 0 pwl(0 1.8 0.9n 1.8 1.1n 0 500n 0)
Vsel_0n3 sel_0n3 0 pwl(0 1.8 0.9n 1.8 1.1n 0 500n 0)
Vsel_0n4 sel_0n4 0 pwl(0 1.8 0.9n 1.8 1.1n 0 500n 0)
Vsel_0n5 sel_0n5 0 pwl(0 1.8 0.9n 1.8 1.1n 0 500n 0)
Vsel_0n6 sel_0n6 0 pwl(0 1.8 0.9n 1.8 1.1n 0 500n 0)
Vsel_0n7 sel_0n7 0 pwl(0 1.8 0.9n 1.8 1.1n 0 500n 0)
Vsel_0n8 sel_0n8 0 pwl(0 1.8 0.9n 1.8 1.1n 0 500n 0)
Xarr_0 sel_0n0 sel_0n1 sel_0n2 sel_0n3 sel_0n4 sel_0n5 sel_0n6 sel_0n7 sel_0n8 vdd vdd vdd vdd vdd vdd vdd vdd vdd top_0n top_0p vdd vrefn vdd vss cdac_array
Sreset_0p top_0p vcm nctrl_reset 0 SWMOD
Rdc_0p top_0p vcm 1T
Sreset_0n top_0n vcm nctrl_reset 0 SWMOD
Rdc_0n top_0n vcm 1T

* ---- code=128  (P code=128, N code=383) ----
Vsel_128p7 sel_128p7 0 pwl(0 1.8 0.9n 1.8 1.1n 0 500n 0)
Vsel_128n0 sel_128n0 0 pwl(0 1.8 0.9n 1.8 1.1n 0 500n 0)
Vsel_128n1 sel_128n1 0 pwl(0 1.8 0.9n 1.8 1.1n 0 500n 0)
Vsel_128n2 sel_128n2 0 pwl(0 1.8 0.9n 1.8 1.1n 0 500n 0)
Vsel_128n3 sel_128n3 0 pwl(0 1.8 0.9n 1.8 1.1n 0 500n 0)
Vsel_128n4 sel_128n4 0 pwl(0 1.8 0.9n 1.8 1.1n 0 500n 0)
Vsel_128n5 sel_128n5 0 pwl(0 1.8 0.9n 1.8 1.1n 0 500n 0)
Vsel_128n6 sel_128n6 0 pwl(0 1.8 0.9n 1.8 1.1n 0 500n 0)
Vsel_128n8 sel_128n8 0 pwl(0 1.8 0.9n 1.8 1.1n 0 500n 0)
Xarr_128 sel_128n0 sel_128n1 sel_128n2 sel_128n3 sel_128n4 sel_128n5 sel_128n6 vdd sel_128n8 vdd vdd vdd vdd vdd vdd vdd sel_128p7 vdd top_128n top_128p vdd vrefn vdd vss cdac_array
Sreset_128p top_128p vcm nctrl_reset 0 SWMOD
Rdc_128p top_128p vcm 1T
Sreset_128n top_128n vcm nctrl_reset 0 SWMOD
Rdc_128n top_128n vcm 1T

* ---- code=256  (P code=256, N code=255) ----
Vsel_256p8 sel_256p8 0 pwl(0 1.8 0.9n 1.8 1.1n 0 500n 0)
Vsel_256n0 sel_256n0 0 pwl(0 1.8 0.9n 1.8 1.1n 0 500n 0)
Vsel_256n1 sel_256n1 0 pwl(0 1.8 0.9n 1.8 1.1n 0 500n 0)
Vsel_256n2 sel_256n2 0 pwl(0 1.8 0.9n 1.8 1.1n 0 500n 0)
Vsel_256n3 sel_256n3 0 pwl(0 1.8 0.9n 1.8 1.1n 0 500n 0)
Vsel_256n4 sel_256n4 0 pwl(0 1.8 0.9n 1.8 1.1n 0 500n 0)
Vsel_256n5 sel_256n5 0 pwl(0 1.8 0.9n 1.8 1.1n 0 500n 0)
Vsel_256n6 sel_256n6 0 pwl(0 1.8 0.9n 1.8 1.1n 0 500n 0)
Vsel_256n7 sel_256n7 0 pwl(0 1.8 0.9n 1.8 1.1n 0 500n 0)
Xarr_256 sel_256n0 sel_256n1 sel_256n2 sel_256n3 sel_256n4 sel_256n5 sel_256n6 sel_256n7 vdd vdd vdd vdd vdd vdd vdd vdd vdd sel_256p8 top_256n top_256p vdd vrefn vdd vss cdac_array
Sreset_256p top_256p vcm nctrl_reset 0 SWMOD
Rdc_256p top_256p vcm 1T
Sreset_256n top_256n vcm nctrl_reset 0 SWMOD
Rdc_256n top_256n vcm 1T

* ---- code=384  (P code=384, N code=127) ----
Vsel_384p7 sel_384p7 0 pwl(0 1.8 0.9n 1.8 1.1n 0 500n 0)
Vsel_384p8 sel_384p8 0 pwl(0 1.8 0.9n 1.8 1.1n 0 500n 0)
Vsel_384n0 sel_384n0 0 pwl(0 1.8 0.9n 1.8 1.1n 0 500n 0)
Vsel_384n1 sel_384n1 0 pwl(0 1.8 0.9n 1.8 1.1n 0 500n 0)
Vsel_384n2 sel_384n2 0 pwl(0 1.8 0.9n 1.8 1.1n 0 500n 0)
Vsel_384n3 sel_384n3 0 pwl(0 1.8 0.9n 1.8 1.1n 0 500n 0)
Vsel_384n4 sel_384n4 0 pwl(0 1.8 0.9n 1.8 1.1n 0 500n 0)
Vsel_384n5 sel_384n5 0 pwl(0 1.8 0.9n 1.8 1.1n 0 500n 0)
Vsel_384n6 sel_384n6 0 pwl(0 1.8 0.9n 1.8 1.1n 0 500n 0)
Xarr_384 sel_384n0 sel_384n1 sel_384n2 sel_384n3 sel_384n4 sel_384n5 sel_384n6 vdd vdd vdd vdd vdd vdd vdd vdd vdd sel_384p7 sel_384p8 top_384n top_384p vdd vrefn vdd vss cdac_array
Sreset_384p top_384p vcm nctrl_reset 0 SWMOD
Rdc_384p top_384p vcm 1T
Sreset_384n top_384n vcm nctrl_reset 0 SWMOD
Rdc_384n top_384n vcm 1T

* ---- code=511  (P code=511, N code=0) ----
Vsel_511p0 sel_511p0 0 pwl(0 1.8 0.9n 1.8 1.1n 0 500n 0)
Vsel_511p1 sel_511p1 0 pwl(0 1.8 0.9n 1.8 1.1n 0 500n 0)
Vsel_511p2 sel_511p2 0 pwl(0 1.8 0.9n 1.8 1.1n 0 500n 0)
Vsel_511p3 sel_511p3 0 pwl(0 1.8 0.9n 1.8 1.1n 0 500n 0)
Vsel_511p4 sel_511p4 0 pwl(0 1.8 0.9n 1.8 1.1n 0 500n 0)
Vsel_511p5 sel_511p5 0 pwl(0 1.8 0.9n 1.8 1.1n 0 500n 0)
Vsel_511p6 sel_511p6 0 pwl(0 1.8 0.9n 1.8 1.1n 0 500n 0)
Vsel_511p7 sel_511p7 0 pwl(0 1.8 0.9n 1.8 1.1n 0 500n 0)
Vsel_511p8 sel_511p8 0 pwl(0 1.8 0.9n 1.8 1.1n 0 500n 0)
Xarr_511 vdd vdd vdd vdd vdd vdd vdd vdd vdd sel_511p0 sel_511p1 sel_511p2 sel_511p3 sel_511p4 sel_511p5 sel_511p6 sel_511p7 sel_511p8 top_511n top_511p vdd vrefn vdd vss cdac_array
Sreset_511p top_511p vcm nctrl_reset 0 SWMOD
Rdc_511p top_511p vcm 1T
Sreset_511n top_511n vcm nctrl_reset 0 SWMOD
Rdc_511n top_511n vcm 1T
