* cdac_array.lvs-reference.spice -- GENERATED, do not edit by hand.
*
* Regenerate with: layout/cdac-array/bin/generate-lvs-reference.py
* Source of truth: design/cdac/cdac_array.sch (issue #53), netlisted headlessly
* by xschem and rewritten into `klt extract --deck sky130`'s own device
* vocabulary. See that script's docstring for the three rewrites and why
* each is a change of vocabulary rather than of topology.
*
* Unit capacitor: the schematic sizes the MiM plate W=L=1.8988 um; the
* drawn plate is the nearest 1 nm-grid square, 1.898 um, whose
* capacitance under the extraction deck's own published coefficients
* (area 2.0 fF/um^2, perimeter 0.19 fF/um) is
* C_unit = 8.647288000e-15 F. A bit of weight w carries `MF=w` in the
* schematic and w drawn unit capacitors in the layout, so its reference is
* w separate C cards of C_unit each -- one per physically drawn unit,
* compared 1:1 against the layout's own w extracted unit devices with no
* `klt lvs` `combine_devices` folding needed on either side (issue #148:
* `Netlist.combine_devices()` does not reliably re-sum w identical-valued
* parallel capacitors into one device for w in the hundreds).
*
* Substrate: the schematic's VSS (every nfet bulk) appears here as
* `vsubs`, the name the sky130 extraction deck gives its
* synthesized global substrate net.
.SUBCKT cdac_array VREFP VREFN VDD vsubs SELn0 SELp0 SELn1 SELp1 SELn2 SELp2 SELn3 SELp3 SELn4 SELp4 TOP_N TOP_P SELp5 SELn5 SELp6 SELn6 SELn7 SELp7 SELn8 SELp8
Cp0 BOT_p0 TOP_P 8.647288000e-15 sky130_fd_pr__model__cap_mim
Mp0n BOT_p0 SELp0 VREFN vsubs nfet L=0.15U W=1U
Mp0p BOT_p0 SELp0 VREFP VDD pfet L=0.15U W=2U
Cp1_0 BOT_p1 TOP_P 8.647288000e-15 sky130_fd_pr__model__cap_mim
Cp1_1 BOT_p1 TOP_P 8.647288000e-15 sky130_fd_pr__model__cap_mim
Mp1n BOT_p1 SELp1 VREFN vsubs nfet L=0.15U W=1U
Mp1p BOT_p1 SELp1 VREFP VDD pfet L=0.15U W=2U
Cp2_0 BOT_p2 TOP_P 8.647288000e-15 sky130_fd_pr__model__cap_mim
Cp2_1 BOT_p2 TOP_P 8.647288000e-15 sky130_fd_pr__model__cap_mim
Cp2_2 BOT_p2 TOP_P 8.647288000e-15 sky130_fd_pr__model__cap_mim
Cp2_3 BOT_p2 TOP_P 8.647288000e-15 sky130_fd_pr__model__cap_mim
Mp2n BOT_p2 SELp2 VREFN vsubs nfet L=0.15U W=1U
Mp2p BOT_p2 SELp2 VREFP VDD pfet L=0.15U W=2U
Cp3_0 BOT_p3 TOP_P 8.647288000e-15 sky130_fd_pr__model__cap_mim
Cp3_1 BOT_p3 TOP_P 8.647288000e-15 sky130_fd_pr__model__cap_mim
Cp3_2 BOT_p3 TOP_P 8.647288000e-15 sky130_fd_pr__model__cap_mim
Cp3_3 BOT_p3 TOP_P 8.647288000e-15 sky130_fd_pr__model__cap_mim
Cp3_4 BOT_p3 TOP_P 8.647288000e-15 sky130_fd_pr__model__cap_mim
Cp3_5 BOT_p3 TOP_P 8.647288000e-15 sky130_fd_pr__model__cap_mim
Cp3_6 BOT_p3 TOP_P 8.647288000e-15 sky130_fd_pr__model__cap_mim
Cp3_7 BOT_p3 TOP_P 8.647288000e-15 sky130_fd_pr__model__cap_mim
Mp3n BOT_p3 SELp3 VREFN vsubs nfet L=0.15U W=1U
Mp3p BOT_p3 SELp3 VREFP VDD pfet L=0.15U W=2U
Cp4_0 BOT_p4 TOP_P 8.647288000e-15 sky130_fd_pr__model__cap_mim
Cp4_1 BOT_p4 TOP_P 8.647288000e-15 sky130_fd_pr__model__cap_mim
Cp4_2 BOT_p4 TOP_P 8.647288000e-15 sky130_fd_pr__model__cap_mim
Cp4_3 BOT_p4 TOP_P 8.647288000e-15 sky130_fd_pr__model__cap_mim
Cp4_4 BOT_p4 TOP_P 8.647288000e-15 sky130_fd_pr__model__cap_mim
Cp4_5 BOT_p4 TOP_P 8.647288000e-15 sky130_fd_pr__model__cap_mim
Cp4_6 BOT_p4 TOP_P 8.647288000e-15 sky130_fd_pr__model__cap_mim
Cp4_7 BOT_p4 TOP_P 8.647288000e-15 sky130_fd_pr__model__cap_mim
Cp4_8 BOT_p4 TOP_P 8.647288000e-15 sky130_fd_pr__model__cap_mim
Cp4_9 BOT_p4 TOP_P 8.647288000e-15 sky130_fd_pr__model__cap_mim
Cp4_10 BOT_p4 TOP_P 8.647288000e-15 sky130_fd_pr__model__cap_mim
Cp4_11 BOT_p4 TOP_P 8.647288000e-15 sky130_fd_pr__model__cap_mim
Cp4_12 BOT_p4 TOP_P 8.647288000e-15 sky130_fd_pr__model__cap_mim
Cp4_13 BOT_p4 TOP_P 8.647288000e-15 sky130_fd_pr__model__cap_mim
Cp4_14 BOT_p4 TOP_P 8.647288000e-15 sky130_fd_pr__model__cap_mim
Cp4_15 BOT_p4 TOP_P 8.647288000e-15 sky130_fd_pr__model__cap_mim
Mp4n BOT_p4 SELp4 VREFN vsubs nfet L=0.15U W=1U
Mp4p BOT_p4 SELp4 VREFP VDD pfet L=0.15U W=2U
Cp5_0 BOT_p5 TOP_P 8.647288000e-15 sky130_fd_pr__model__cap_mim
Cp5_1 BOT_p5 TOP_P 8.647288000e-15 sky130_fd_pr__model__cap_mim
Cp5_2 BOT_p5 TOP_P 8.647288000e-15 sky130_fd_pr__model__cap_mim
Cp5_3 BOT_p5 TOP_P 8.647288000e-15 sky130_fd_pr__model__cap_mim
Cp5_4 BOT_p5 TOP_P 8.647288000e-15 sky130_fd_pr__model__cap_mim
Cp5_5 BOT_p5 TOP_P 8.647288000e-15 sky130_fd_pr__model__cap_mim
Cp5_6 BOT_p5 TOP_P 8.647288000e-15 sky130_fd_pr__model__cap_mim
Cp5_7 BOT_p5 TOP_P 8.647288000e-15 sky130_fd_pr__model__cap_mim
Cp5_8 BOT_p5 TOP_P 8.647288000e-15 sky130_fd_pr__model__cap_mim
Cp5_9 BOT_p5 TOP_P 8.647288000e-15 sky130_fd_pr__model__cap_mim
Cp5_10 BOT_p5 TOP_P 8.647288000e-15 sky130_fd_pr__model__cap_mim
Cp5_11 BOT_p5 TOP_P 8.647288000e-15 sky130_fd_pr__model__cap_mim
Cp5_12 BOT_p5 TOP_P 8.647288000e-15 sky130_fd_pr__model__cap_mim
Cp5_13 BOT_p5 TOP_P 8.647288000e-15 sky130_fd_pr__model__cap_mim
Cp5_14 BOT_p5 TOP_P 8.647288000e-15 sky130_fd_pr__model__cap_mim
Cp5_15 BOT_p5 TOP_P 8.647288000e-15 sky130_fd_pr__model__cap_mim
Cp5_16 BOT_p5 TOP_P 8.647288000e-15 sky130_fd_pr__model__cap_mim
Cp5_17 BOT_p5 TOP_P 8.647288000e-15 sky130_fd_pr__model__cap_mim
Cp5_18 BOT_p5 TOP_P 8.647288000e-15 sky130_fd_pr__model__cap_mim
Cp5_19 BOT_p5 TOP_P 8.647288000e-15 sky130_fd_pr__model__cap_mim
Cp5_20 BOT_p5 TOP_P 8.647288000e-15 sky130_fd_pr__model__cap_mim
Cp5_21 BOT_p5 TOP_P 8.647288000e-15 sky130_fd_pr__model__cap_mim
Cp5_22 BOT_p5 TOP_P 8.647288000e-15 sky130_fd_pr__model__cap_mim
Cp5_23 BOT_p5 TOP_P 8.647288000e-15 sky130_fd_pr__model__cap_mim
Cp5_24 BOT_p5 TOP_P 8.647288000e-15 sky130_fd_pr__model__cap_mim
Cp5_25 BOT_p5 TOP_P 8.647288000e-15 sky130_fd_pr__model__cap_mim
Cp5_26 BOT_p5 TOP_P 8.647288000e-15 sky130_fd_pr__model__cap_mim
Cp5_27 BOT_p5 TOP_P 8.647288000e-15 sky130_fd_pr__model__cap_mim
Cp5_28 BOT_p5 TOP_P 8.647288000e-15 sky130_fd_pr__model__cap_mim
Cp5_29 BOT_p5 TOP_P 8.647288000e-15 sky130_fd_pr__model__cap_mim
Cp5_30 BOT_p5 TOP_P 8.647288000e-15 sky130_fd_pr__model__cap_mim
Cp5_31 BOT_p5 TOP_P 8.647288000e-15 sky130_fd_pr__model__cap_mim
Mp5n BOT_p5 SELp5 VREFN vsubs nfet L=0.15U W=1U
Mp5p BOT_p5 SELp5 VREFP VDD pfet L=0.15U W=2U
Cp6_0 BOT_p6 TOP_P 8.647288000e-15 sky130_fd_pr__model__cap_mim
Cp6_1 BOT_p6 TOP_P 8.647288000e-15 sky130_fd_pr__model__cap_mim
Cp6_2 BOT_p6 TOP_P 8.647288000e-15 sky130_fd_pr__model__cap_mim
Cp6_3 BOT_p6 TOP_P 8.647288000e-15 sky130_fd_pr__model__cap_mim
Cp6_4 BOT_p6 TOP_P 8.647288000e-15 sky130_fd_pr__model__cap_mim
Cp6_5 BOT_p6 TOP_P 8.647288000e-15 sky130_fd_pr__model__cap_mim
Cp6_6 BOT_p6 TOP_P 8.647288000e-15 sky130_fd_pr__model__cap_mim
Cp6_7 BOT_p6 TOP_P 8.647288000e-15 sky130_fd_pr__model__cap_mim
Cp6_8 BOT_p6 TOP_P 8.647288000e-15 sky130_fd_pr__model__cap_mim
Cp6_9 BOT_p6 TOP_P 8.647288000e-15 sky130_fd_pr__model__cap_mim
Cp6_10 BOT_p6 TOP_P 8.647288000e-15 sky130_fd_pr__model__cap_mim
Cp6_11 BOT_p6 TOP_P 8.647288000e-15 sky130_fd_pr__model__cap_mim
Cp6_12 BOT_p6 TOP_P 8.647288000e-15 sky130_fd_pr__model__cap_mim
Cp6_13 BOT_p6 TOP_P 8.647288000e-15 sky130_fd_pr__model__cap_mim
Cp6_14 BOT_p6 TOP_P 8.647288000e-15 sky130_fd_pr__model__cap_mim
Cp6_15 BOT_p6 TOP_P 8.647288000e-15 sky130_fd_pr__model__cap_mim
Cp6_16 BOT_p6 TOP_P 8.647288000e-15 sky130_fd_pr__model__cap_mim
Cp6_17 BOT_p6 TOP_P 8.647288000e-15 sky130_fd_pr__model__cap_mim
Cp6_18 BOT_p6 TOP_P 8.647288000e-15 sky130_fd_pr__model__cap_mim
Cp6_19 BOT_p6 TOP_P 8.647288000e-15 sky130_fd_pr__model__cap_mim
Cp6_20 BOT_p6 TOP_P 8.647288000e-15 sky130_fd_pr__model__cap_mim
Cp6_21 BOT_p6 TOP_P 8.647288000e-15 sky130_fd_pr__model__cap_mim
Cp6_22 BOT_p6 TOP_P 8.647288000e-15 sky130_fd_pr__model__cap_mim
Cp6_23 BOT_p6 TOP_P 8.647288000e-15 sky130_fd_pr__model__cap_mim
Cp6_24 BOT_p6 TOP_P 8.647288000e-15 sky130_fd_pr__model__cap_mim
Cp6_25 BOT_p6 TOP_P 8.647288000e-15 sky130_fd_pr__model__cap_mim
Cp6_26 BOT_p6 TOP_P 8.647288000e-15 sky130_fd_pr__model__cap_mim
Cp6_27 BOT_p6 TOP_P 8.647288000e-15 sky130_fd_pr__model__cap_mim
Cp6_28 BOT_p6 TOP_P 8.647288000e-15 sky130_fd_pr__model__cap_mim
Cp6_29 BOT_p6 TOP_P 8.647288000e-15 sky130_fd_pr__model__cap_mim
Cp6_30 BOT_p6 TOP_P 8.647288000e-15 sky130_fd_pr__model__cap_mim
Cp6_31 BOT_p6 TOP_P 8.647288000e-15 sky130_fd_pr__model__cap_mim
Cp6_32 BOT_p6 TOP_P 8.647288000e-15 sky130_fd_pr__model__cap_mim
Cp6_33 BOT_p6 TOP_P 8.647288000e-15 sky130_fd_pr__model__cap_mim
Cp6_34 BOT_p6 TOP_P 8.647288000e-15 sky130_fd_pr__model__cap_mim
Cp6_35 BOT_p6 TOP_P 8.647288000e-15 sky130_fd_pr__model__cap_mim
Cp6_36 BOT_p6 TOP_P 8.647288000e-15 sky130_fd_pr__model__cap_mim
Cp6_37 BOT_p6 TOP_P 8.647288000e-15 sky130_fd_pr__model__cap_mim
Cp6_38 BOT_p6 TOP_P 8.647288000e-15 sky130_fd_pr__model__cap_mim
Cp6_39 BOT_p6 TOP_P 8.647288000e-15 sky130_fd_pr__model__cap_mim
Cp6_40 BOT_p6 TOP_P 8.647288000e-15 sky130_fd_pr__model__cap_mim
Cp6_41 BOT_p6 TOP_P 8.647288000e-15 sky130_fd_pr__model__cap_mim
Cp6_42 BOT_p6 TOP_P 8.647288000e-15 sky130_fd_pr__model__cap_mim
Cp6_43 BOT_p6 TOP_P 8.647288000e-15 sky130_fd_pr__model__cap_mim
Cp6_44 BOT_p6 TOP_P 8.647288000e-15 sky130_fd_pr__model__cap_mim
Cp6_45 BOT_p6 TOP_P 8.647288000e-15 sky130_fd_pr__model__cap_mim
Cp6_46 BOT_p6 TOP_P 8.647288000e-15 sky130_fd_pr__model__cap_mim
Cp6_47 BOT_p6 TOP_P 8.647288000e-15 sky130_fd_pr__model__cap_mim
Cp6_48 BOT_p6 TOP_P 8.647288000e-15 sky130_fd_pr__model__cap_mim
Cp6_49 BOT_p6 TOP_P 8.647288000e-15 sky130_fd_pr__model__cap_mim
Cp6_50 BOT_p6 TOP_P 8.647288000e-15 sky130_fd_pr__model__cap_mim
Cp6_51 BOT_p6 TOP_P 8.647288000e-15 sky130_fd_pr__model__cap_mim
Cp6_52 BOT_p6 TOP_P 8.647288000e-15 sky130_fd_pr__model__cap_mim
Cp6_53 BOT_p6 TOP_P 8.647288000e-15 sky130_fd_pr__model__cap_mim
Cp6_54 BOT_p6 TOP_P 8.647288000e-15 sky130_fd_pr__model__cap_mim
Cp6_55 BOT_p6 TOP_P 8.647288000e-15 sky130_fd_pr__model__cap_mim
Cp6_56 BOT_p6 TOP_P 8.647288000e-15 sky130_fd_pr__model__cap_mim
Cp6_57 BOT_p6 TOP_P 8.647288000e-15 sky130_fd_pr__model__cap_mim
Cp6_58 BOT_p6 TOP_P 8.647288000e-15 sky130_fd_pr__model__cap_mim
Cp6_59 BOT_p6 TOP_P 8.647288000e-15 sky130_fd_pr__model__cap_mim
Cp6_60 BOT_p6 TOP_P 8.647288000e-15 sky130_fd_pr__model__cap_mim
Cp6_61 BOT_p6 TOP_P 8.647288000e-15 sky130_fd_pr__model__cap_mim
Cp6_62 BOT_p6 TOP_P 8.647288000e-15 sky130_fd_pr__model__cap_mim
Cp6_63 BOT_p6 TOP_P 8.647288000e-15 sky130_fd_pr__model__cap_mim
Mp6n BOT_p6 SELp6 VREFN vsubs nfet L=0.15U W=1U
Mp6p BOT_p6 SELp6 VREFP VDD pfet L=0.15U W=2U
Cp7_0 BOT_p7 TOP_P 8.647288000e-15 sky130_fd_pr__model__cap_mim
Cp7_1 BOT_p7 TOP_P 8.647288000e-15 sky130_fd_pr__model__cap_mim
Cp7_2 BOT_p7 TOP_P 8.647288000e-15 sky130_fd_pr__model__cap_mim
Cp7_3 BOT_p7 TOP_P 8.647288000e-15 sky130_fd_pr__model__cap_mim
Cp7_4 BOT_p7 TOP_P 8.647288000e-15 sky130_fd_pr__model__cap_mim
Cp7_5 BOT_p7 TOP_P 8.647288000e-15 sky130_fd_pr__model__cap_mim
Cp7_6 BOT_p7 TOP_P 8.647288000e-15 sky130_fd_pr__model__cap_mim
Cp7_7 BOT_p7 TOP_P 8.647288000e-15 sky130_fd_pr__model__cap_mim
Cp7_8 BOT_p7 TOP_P 8.647288000e-15 sky130_fd_pr__model__cap_mim
Cp7_9 BOT_p7 TOP_P 8.647288000e-15 sky130_fd_pr__model__cap_mim
Cp7_10 BOT_p7 TOP_P 8.647288000e-15 sky130_fd_pr__model__cap_mim
Cp7_11 BOT_p7 TOP_P 8.647288000e-15 sky130_fd_pr__model__cap_mim
Cp7_12 BOT_p7 TOP_P 8.647288000e-15 sky130_fd_pr__model__cap_mim
Cp7_13 BOT_p7 TOP_P 8.647288000e-15 sky130_fd_pr__model__cap_mim
Cp7_14 BOT_p7 TOP_P 8.647288000e-15 sky130_fd_pr__model__cap_mim
Cp7_15 BOT_p7 TOP_P 8.647288000e-15 sky130_fd_pr__model__cap_mim
Cp7_16 BOT_p7 TOP_P 8.647288000e-15 sky130_fd_pr__model__cap_mim
Cp7_17 BOT_p7 TOP_P 8.647288000e-15 sky130_fd_pr__model__cap_mim
Cp7_18 BOT_p7 TOP_P 8.647288000e-15 sky130_fd_pr__model__cap_mim
Cp7_19 BOT_p7 TOP_P 8.647288000e-15 sky130_fd_pr__model__cap_mim
Cp7_20 BOT_p7 TOP_P 8.647288000e-15 sky130_fd_pr__model__cap_mim
Cp7_21 BOT_p7 TOP_P 8.647288000e-15 sky130_fd_pr__model__cap_mim
Cp7_22 BOT_p7 TOP_P 8.647288000e-15 sky130_fd_pr__model__cap_mim
Cp7_23 BOT_p7 TOP_P 8.647288000e-15 sky130_fd_pr__model__cap_mim
Cp7_24 BOT_p7 TOP_P 8.647288000e-15 sky130_fd_pr__model__cap_mim
Cp7_25 BOT_p7 TOP_P 8.647288000e-15 sky130_fd_pr__model__cap_mim
Cp7_26 BOT_p7 TOP_P 8.647288000e-15 sky130_fd_pr__model__cap_mim
Cp7_27 BOT_p7 TOP_P 8.647288000e-15 sky130_fd_pr__model__cap_mim
Cp7_28 BOT_p7 TOP_P 8.647288000e-15 sky130_fd_pr__model__cap_mim
Cp7_29 BOT_p7 TOP_P 8.647288000e-15 sky130_fd_pr__model__cap_mim
Cp7_30 BOT_p7 TOP_P 8.647288000e-15 sky130_fd_pr__model__cap_mim
Cp7_31 BOT_p7 TOP_P 8.647288000e-15 sky130_fd_pr__model__cap_mim
Cp7_32 BOT_p7 TOP_P 8.647288000e-15 sky130_fd_pr__model__cap_mim
Cp7_33 BOT_p7 TOP_P 8.647288000e-15 sky130_fd_pr__model__cap_mim
Cp7_34 BOT_p7 TOP_P 8.647288000e-15 sky130_fd_pr__model__cap_mim
Cp7_35 BOT_p7 TOP_P 8.647288000e-15 sky130_fd_pr__model__cap_mim
Cp7_36 BOT_p7 TOP_P 8.647288000e-15 sky130_fd_pr__model__cap_mim
Cp7_37 BOT_p7 TOP_P 8.647288000e-15 sky130_fd_pr__model__cap_mim
Cp7_38 BOT_p7 TOP_P 8.647288000e-15 sky130_fd_pr__model__cap_mim
Cp7_39 BOT_p7 TOP_P 8.647288000e-15 sky130_fd_pr__model__cap_mim
Cp7_40 BOT_p7 TOP_P 8.647288000e-15 sky130_fd_pr__model__cap_mim
Cp7_41 BOT_p7 TOP_P 8.647288000e-15 sky130_fd_pr__model__cap_mim
Cp7_42 BOT_p7 TOP_P 8.647288000e-15 sky130_fd_pr__model__cap_mim
Cp7_43 BOT_p7 TOP_P 8.647288000e-15 sky130_fd_pr__model__cap_mim
Cp7_44 BOT_p7 TOP_P 8.647288000e-15 sky130_fd_pr__model__cap_mim
Cp7_45 BOT_p7 TOP_P 8.647288000e-15 sky130_fd_pr__model__cap_mim
Cp7_46 BOT_p7 TOP_P 8.647288000e-15 sky130_fd_pr__model__cap_mim
Cp7_47 BOT_p7 TOP_P 8.647288000e-15 sky130_fd_pr__model__cap_mim
Cp7_48 BOT_p7 TOP_P 8.647288000e-15 sky130_fd_pr__model__cap_mim
Cp7_49 BOT_p7 TOP_P 8.647288000e-15 sky130_fd_pr__model__cap_mim
Cp7_50 BOT_p7 TOP_P 8.647288000e-15 sky130_fd_pr__model__cap_mim
Cp7_51 BOT_p7 TOP_P 8.647288000e-15 sky130_fd_pr__model__cap_mim
Cp7_52 BOT_p7 TOP_P 8.647288000e-15 sky130_fd_pr__model__cap_mim
Cp7_53 BOT_p7 TOP_P 8.647288000e-15 sky130_fd_pr__model__cap_mim
Cp7_54 BOT_p7 TOP_P 8.647288000e-15 sky130_fd_pr__model__cap_mim
Cp7_55 BOT_p7 TOP_P 8.647288000e-15 sky130_fd_pr__model__cap_mim
Cp7_56 BOT_p7 TOP_P 8.647288000e-15 sky130_fd_pr__model__cap_mim
Cp7_57 BOT_p7 TOP_P 8.647288000e-15 sky130_fd_pr__model__cap_mim
Cp7_58 BOT_p7 TOP_P 8.647288000e-15 sky130_fd_pr__model__cap_mim
Cp7_59 BOT_p7 TOP_P 8.647288000e-15 sky130_fd_pr__model__cap_mim
Cp7_60 BOT_p7 TOP_P 8.647288000e-15 sky130_fd_pr__model__cap_mim
Cp7_61 BOT_p7 TOP_P 8.647288000e-15 sky130_fd_pr__model__cap_mim
Cp7_62 BOT_p7 TOP_P 8.647288000e-15 sky130_fd_pr__model__cap_mim
Cp7_63 BOT_p7 TOP_P 8.647288000e-15 sky130_fd_pr__model__cap_mim
Cp7_64 BOT_p7 TOP_P 8.647288000e-15 sky130_fd_pr__model__cap_mim
Cp7_65 BOT_p7 TOP_P 8.647288000e-15 sky130_fd_pr__model__cap_mim
Cp7_66 BOT_p7 TOP_P 8.647288000e-15 sky130_fd_pr__model__cap_mim
Cp7_67 BOT_p7 TOP_P 8.647288000e-15 sky130_fd_pr__model__cap_mim
Cp7_68 BOT_p7 TOP_P 8.647288000e-15 sky130_fd_pr__model__cap_mim
Cp7_69 BOT_p7 TOP_P 8.647288000e-15 sky130_fd_pr__model__cap_mim
Cp7_70 BOT_p7 TOP_P 8.647288000e-15 sky130_fd_pr__model__cap_mim
Cp7_71 BOT_p7 TOP_P 8.647288000e-15 sky130_fd_pr__model__cap_mim
Cp7_72 BOT_p7 TOP_P 8.647288000e-15 sky130_fd_pr__model__cap_mim
Cp7_73 BOT_p7 TOP_P 8.647288000e-15 sky130_fd_pr__model__cap_mim
Cp7_74 BOT_p7 TOP_P 8.647288000e-15 sky130_fd_pr__model__cap_mim
Cp7_75 BOT_p7 TOP_P 8.647288000e-15 sky130_fd_pr__model__cap_mim
Cp7_76 BOT_p7 TOP_P 8.647288000e-15 sky130_fd_pr__model__cap_mim
Cp7_77 BOT_p7 TOP_P 8.647288000e-15 sky130_fd_pr__model__cap_mim
Cp7_78 BOT_p7 TOP_P 8.647288000e-15 sky130_fd_pr__model__cap_mim
Cp7_79 BOT_p7 TOP_P 8.647288000e-15 sky130_fd_pr__model__cap_mim
Cp7_80 BOT_p7 TOP_P 8.647288000e-15 sky130_fd_pr__model__cap_mim
Cp7_81 BOT_p7 TOP_P 8.647288000e-15 sky130_fd_pr__model__cap_mim
Cp7_82 BOT_p7 TOP_P 8.647288000e-15 sky130_fd_pr__model__cap_mim
Cp7_83 BOT_p7 TOP_P 8.647288000e-15 sky130_fd_pr__model__cap_mim
Cp7_84 BOT_p7 TOP_P 8.647288000e-15 sky130_fd_pr__model__cap_mim
Cp7_85 BOT_p7 TOP_P 8.647288000e-15 sky130_fd_pr__model__cap_mim
Cp7_86 BOT_p7 TOP_P 8.647288000e-15 sky130_fd_pr__model__cap_mim
Cp7_87 BOT_p7 TOP_P 8.647288000e-15 sky130_fd_pr__model__cap_mim
Cp7_88 BOT_p7 TOP_P 8.647288000e-15 sky130_fd_pr__model__cap_mim
Cp7_89 BOT_p7 TOP_P 8.647288000e-15 sky130_fd_pr__model__cap_mim
Cp7_90 BOT_p7 TOP_P 8.647288000e-15 sky130_fd_pr__model__cap_mim
Cp7_91 BOT_p7 TOP_P 8.647288000e-15 sky130_fd_pr__model__cap_mim
Cp7_92 BOT_p7 TOP_P 8.647288000e-15 sky130_fd_pr__model__cap_mim
Cp7_93 BOT_p7 TOP_P 8.647288000e-15 sky130_fd_pr__model__cap_mim
Cp7_94 BOT_p7 TOP_P 8.647288000e-15 sky130_fd_pr__model__cap_mim
Cp7_95 BOT_p7 TOP_P 8.647288000e-15 sky130_fd_pr__model__cap_mim
Cp7_96 BOT_p7 TOP_P 8.647288000e-15 sky130_fd_pr__model__cap_mim
Cp7_97 BOT_p7 TOP_P 8.647288000e-15 sky130_fd_pr__model__cap_mim
Cp7_98 BOT_p7 TOP_P 8.647288000e-15 sky130_fd_pr__model__cap_mim
Cp7_99 BOT_p7 TOP_P 8.647288000e-15 sky130_fd_pr__model__cap_mim
Cp7_100 BOT_p7 TOP_P 8.647288000e-15 sky130_fd_pr__model__cap_mim
Cp7_101 BOT_p7 TOP_P 8.647288000e-15 sky130_fd_pr__model__cap_mim
Cp7_102 BOT_p7 TOP_P 8.647288000e-15 sky130_fd_pr__model__cap_mim
Cp7_103 BOT_p7 TOP_P 8.647288000e-15 sky130_fd_pr__model__cap_mim
Cp7_104 BOT_p7 TOP_P 8.647288000e-15 sky130_fd_pr__model__cap_mim
Cp7_105 BOT_p7 TOP_P 8.647288000e-15 sky130_fd_pr__model__cap_mim
Cp7_106 BOT_p7 TOP_P 8.647288000e-15 sky130_fd_pr__model__cap_mim
Cp7_107 BOT_p7 TOP_P 8.647288000e-15 sky130_fd_pr__model__cap_mim
Cp7_108 BOT_p7 TOP_P 8.647288000e-15 sky130_fd_pr__model__cap_mim
Cp7_109 BOT_p7 TOP_P 8.647288000e-15 sky130_fd_pr__model__cap_mim
Cp7_110 BOT_p7 TOP_P 8.647288000e-15 sky130_fd_pr__model__cap_mim
Cp7_111 BOT_p7 TOP_P 8.647288000e-15 sky130_fd_pr__model__cap_mim
Cp7_112 BOT_p7 TOP_P 8.647288000e-15 sky130_fd_pr__model__cap_mim
Cp7_113 BOT_p7 TOP_P 8.647288000e-15 sky130_fd_pr__model__cap_mim
Cp7_114 BOT_p7 TOP_P 8.647288000e-15 sky130_fd_pr__model__cap_mim
Cp7_115 BOT_p7 TOP_P 8.647288000e-15 sky130_fd_pr__model__cap_mim
Cp7_116 BOT_p7 TOP_P 8.647288000e-15 sky130_fd_pr__model__cap_mim
Cp7_117 BOT_p7 TOP_P 8.647288000e-15 sky130_fd_pr__model__cap_mim
Cp7_118 BOT_p7 TOP_P 8.647288000e-15 sky130_fd_pr__model__cap_mim
Cp7_119 BOT_p7 TOP_P 8.647288000e-15 sky130_fd_pr__model__cap_mim
Cp7_120 BOT_p7 TOP_P 8.647288000e-15 sky130_fd_pr__model__cap_mim
Cp7_121 BOT_p7 TOP_P 8.647288000e-15 sky130_fd_pr__model__cap_mim
Cp7_122 BOT_p7 TOP_P 8.647288000e-15 sky130_fd_pr__model__cap_mim
Cp7_123 BOT_p7 TOP_P 8.647288000e-15 sky130_fd_pr__model__cap_mim
Cp7_124 BOT_p7 TOP_P 8.647288000e-15 sky130_fd_pr__model__cap_mim
Cp7_125 BOT_p7 TOP_P 8.647288000e-15 sky130_fd_pr__model__cap_mim
Cp7_126 BOT_p7 TOP_P 8.647288000e-15 sky130_fd_pr__model__cap_mim
Cp7_127 BOT_p7 TOP_P 8.647288000e-15 sky130_fd_pr__model__cap_mim
Mp7n BOT_p7 SELp7 VREFN vsubs nfet L=0.15U W=1U
Mp7p BOT_p7 SELp7 VREFP VDD pfet L=0.15U W=2U
Cp8_0 BOT_p8 TOP_P 8.647288000e-15 sky130_fd_pr__model__cap_mim
Cp8_1 BOT_p8 TOP_P 8.647288000e-15 sky130_fd_pr__model__cap_mim
Cp8_2 BOT_p8 TOP_P 8.647288000e-15 sky130_fd_pr__model__cap_mim
Cp8_3 BOT_p8 TOP_P 8.647288000e-15 sky130_fd_pr__model__cap_mim
Cp8_4 BOT_p8 TOP_P 8.647288000e-15 sky130_fd_pr__model__cap_mim
Cp8_5 BOT_p8 TOP_P 8.647288000e-15 sky130_fd_pr__model__cap_mim
Cp8_6 BOT_p8 TOP_P 8.647288000e-15 sky130_fd_pr__model__cap_mim
Cp8_7 BOT_p8 TOP_P 8.647288000e-15 sky130_fd_pr__model__cap_mim
Cp8_8 BOT_p8 TOP_P 8.647288000e-15 sky130_fd_pr__model__cap_mim
Cp8_9 BOT_p8 TOP_P 8.647288000e-15 sky130_fd_pr__model__cap_mim
Cp8_10 BOT_p8 TOP_P 8.647288000e-15 sky130_fd_pr__model__cap_mim
Cp8_11 BOT_p8 TOP_P 8.647288000e-15 sky130_fd_pr__model__cap_mim
Cp8_12 BOT_p8 TOP_P 8.647288000e-15 sky130_fd_pr__model__cap_mim
Cp8_13 BOT_p8 TOP_P 8.647288000e-15 sky130_fd_pr__model__cap_mim
Cp8_14 BOT_p8 TOP_P 8.647288000e-15 sky130_fd_pr__model__cap_mim
Cp8_15 BOT_p8 TOP_P 8.647288000e-15 sky130_fd_pr__model__cap_mim
Cp8_16 BOT_p8 TOP_P 8.647288000e-15 sky130_fd_pr__model__cap_mim
Cp8_17 BOT_p8 TOP_P 8.647288000e-15 sky130_fd_pr__model__cap_mim
Cp8_18 BOT_p8 TOP_P 8.647288000e-15 sky130_fd_pr__model__cap_mim
Cp8_19 BOT_p8 TOP_P 8.647288000e-15 sky130_fd_pr__model__cap_mim
Cp8_20 BOT_p8 TOP_P 8.647288000e-15 sky130_fd_pr__model__cap_mim
Cp8_21 BOT_p8 TOP_P 8.647288000e-15 sky130_fd_pr__model__cap_mim
Cp8_22 BOT_p8 TOP_P 8.647288000e-15 sky130_fd_pr__model__cap_mim
Cp8_23 BOT_p8 TOP_P 8.647288000e-15 sky130_fd_pr__model__cap_mim
Cp8_24 BOT_p8 TOP_P 8.647288000e-15 sky130_fd_pr__model__cap_mim
Cp8_25 BOT_p8 TOP_P 8.647288000e-15 sky130_fd_pr__model__cap_mim
Cp8_26 BOT_p8 TOP_P 8.647288000e-15 sky130_fd_pr__model__cap_mim
Cp8_27 BOT_p8 TOP_P 8.647288000e-15 sky130_fd_pr__model__cap_mim
Cp8_28 BOT_p8 TOP_P 8.647288000e-15 sky130_fd_pr__model__cap_mim
Cp8_29 BOT_p8 TOP_P 8.647288000e-15 sky130_fd_pr__model__cap_mim
Cp8_30 BOT_p8 TOP_P 8.647288000e-15 sky130_fd_pr__model__cap_mim
Cp8_31 BOT_p8 TOP_P 8.647288000e-15 sky130_fd_pr__model__cap_mim
Cp8_32 BOT_p8 TOP_P 8.647288000e-15 sky130_fd_pr__model__cap_mim
Cp8_33 BOT_p8 TOP_P 8.647288000e-15 sky130_fd_pr__model__cap_mim
Cp8_34 BOT_p8 TOP_P 8.647288000e-15 sky130_fd_pr__model__cap_mim
Cp8_35 BOT_p8 TOP_P 8.647288000e-15 sky130_fd_pr__model__cap_mim
Cp8_36 BOT_p8 TOP_P 8.647288000e-15 sky130_fd_pr__model__cap_mim
Cp8_37 BOT_p8 TOP_P 8.647288000e-15 sky130_fd_pr__model__cap_mim
Cp8_38 BOT_p8 TOP_P 8.647288000e-15 sky130_fd_pr__model__cap_mim
Cp8_39 BOT_p8 TOP_P 8.647288000e-15 sky130_fd_pr__model__cap_mim
Cp8_40 BOT_p8 TOP_P 8.647288000e-15 sky130_fd_pr__model__cap_mim
Cp8_41 BOT_p8 TOP_P 8.647288000e-15 sky130_fd_pr__model__cap_mim
Cp8_42 BOT_p8 TOP_P 8.647288000e-15 sky130_fd_pr__model__cap_mim
Cp8_43 BOT_p8 TOP_P 8.647288000e-15 sky130_fd_pr__model__cap_mim
Cp8_44 BOT_p8 TOP_P 8.647288000e-15 sky130_fd_pr__model__cap_mim
Cp8_45 BOT_p8 TOP_P 8.647288000e-15 sky130_fd_pr__model__cap_mim
Cp8_46 BOT_p8 TOP_P 8.647288000e-15 sky130_fd_pr__model__cap_mim
Cp8_47 BOT_p8 TOP_P 8.647288000e-15 sky130_fd_pr__model__cap_mim
Cp8_48 BOT_p8 TOP_P 8.647288000e-15 sky130_fd_pr__model__cap_mim
Cp8_49 BOT_p8 TOP_P 8.647288000e-15 sky130_fd_pr__model__cap_mim
Cp8_50 BOT_p8 TOP_P 8.647288000e-15 sky130_fd_pr__model__cap_mim
Cp8_51 BOT_p8 TOP_P 8.647288000e-15 sky130_fd_pr__model__cap_mim
Cp8_52 BOT_p8 TOP_P 8.647288000e-15 sky130_fd_pr__model__cap_mim
Cp8_53 BOT_p8 TOP_P 8.647288000e-15 sky130_fd_pr__model__cap_mim
Cp8_54 BOT_p8 TOP_P 8.647288000e-15 sky130_fd_pr__model__cap_mim
Cp8_55 BOT_p8 TOP_P 8.647288000e-15 sky130_fd_pr__model__cap_mim
Cp8_56 BOT_p8 TOP_P 8.647288000e-15 sky130_fd_pr__model__cap_mim
Cp8_57 BOT_p8 TOP_P 8.647288000e-15 sky130_fd_pr__model__cap_mim
Cp8_58 BOT_p8 TOP_P 8.647288000e-15 sky130_fd_pr__model__cap_mim
Cp8_59 BOT_p8 TOP_P 8.647288000e-15 sky130_fd_pr__model__cap_mim
Cp8_60 BOT_p8 TOP_P 8.647288000e-15 sky130_fd_pr__model__cap_mim
Cp8_61 BOT_p8 TOP_P 8.647288000e-15 sky130_fd_pr__model__cap_mim
Cp8_62 BOT_p8 TOP_P 8.647288000e-15 sky130_fd_pr__model__cap_mim
Cp8_63 BOT_p8 TOP_P 8.647288000e-15 sky130_fd_pr__model__cap_mim
Cp8_64 BOT_p8 TOP_P 8.647288000e-15 sky130_fd_pr__model__cap_mim
Cp8_65 BOT_p8 TOP_P 8.647288000e-15 sky130_fd_pr__model__cap_mim
Cp8_66 BOT_p8 TOP_P 8.647288000e-15 sky130_fd_pr__model__cap_mim
Cp8_67 BOT_p8 TOP_P 8.647288000e-15 sky130_fd_pr__model__cap_mim
Cp8_68 BOT_p8 TOP_P 8.647288000e-15 sky130_fd_pr__model__cap_mim
Cp8_69 BOT_p8 TOP_P 8.647288000e-15 sky130_fd_pr__model__cap_mim
Cp8_70 BOT_p8 TOP_P 8.647288000e-15 sky130_fd_pr__model__cap_mim
Cp8_71 BOT_p8 TOP_P 8.647288000e-15 sky130_fd_pr__model__cap_mim
Cp8_72 BOT_p8 TOP_P 8.647288000e-15 sky130_fd_pr__model__cap_mim
Cp8_73 BOT_p8 TOP_P 8.647288000e-15 sky130_fd_pr__model__cap_mim
Cp8_74 BOT_p8 TOP_P 8.647288000e-15 sky130_fd_pr__model__cap_mim
Cp8_75 BOT_p8 TOP_P 8.647288000e-15 sky130_fd_pr__model__cap_mim
Cp8_76 BOT_p8 TOP_P 8.647288000e-15 sky130_fd_pr__model__cap_mim
Cp8_77 BOT_p8 TOP_P 8.647288000e-15 sky130_fd_pr__model__cap_mim
Cp8_78 BOT_p8 TOP_P 8.647288000e-15 sky130_fd_pr__model__cap_mim
Cp8_79 BOT_p8 TOP_P 8.647288000e-15 sky130_fd_pr__model__cap_mim
Cp8_80 BOT_p8 TOP_P 8.647288000e-15 sky130_fd_pr__model__cap_mim
Cp8_81 BOT_p8 TOP_P 8.647288000e-15 sky130_fd_pr__model__cap_mim
Cp8_82 BOT_p8 TOP_P 8.647288000e-15 sky130_fd_pr__model__cap_mim
Cp8_83 BOT_p8 TOP_P 8.647288000e-15 sky130_fd_pr__model__cap_mim
Cp8_84 BOT_p8 TOP_P 8.647288000e-15 sky130_fd_pr__model__cap_mim
Cp8_85 BOT_p8 TOP_P 8.647288000e-15 sky130_fd_pr__model__cap_mim
Cp8_86 BOT_p8 TOP_P 8.647288000e-15 sky130_fd_pr__model__cap_mim
Cp8_87 BOT_p8 TOP_P 8.647288000e-15 sky130_fd_pr__model__cap_mim
Cp8_88 BOT_p8 TOP_P 8.647288000e-15 sky130_fd_pr__model__cap_mim
Cp8_89 BOT_p8 TOP_P 8.647288000e-15 sky130_fd_pr__model__cap_mim
Cp8_90 BOT_p8 TOP_P 8.647288000e-15 sky130_fd_pr__model__cap_mim
Cp8_91 BOT_p8 TOP_P 8.647288000e-15 sky130_fd_pr__model__cap_mim
Cp8_92 BOT_p8 TOP_P 8.647288000e-15 sky130_fd_pr__model__cap_mim
Cp8_93 BOT_p8 TOP_P 8.647288000e-15 sky130_fd_pr__model__cap_mim
Cp8_94 BOT_p8 TOP_P 8.647288000e-15 sky130_fd_pr__model__cap_mim
Cp8_95 BOT_p8 TOP_P 8.647288000e-15 sky130_fd_pr__model__cap_mim
Cp8_96 BOT_p8 TOP_P 8.647288000e-15 sky130_fd_pr__model__cap_mim
Cp8_97 BOT_p8 TOP_P 8.647288000e-15 sky130_fd_pr__model__cap_mim
Cp8_98 BOT_p8 TOP_P 8.647288000e-15 sky130_fd_pr__model__cap_mim
Cp8_99 BOT_p8 TOP_P 8.647288000e-15 sky130_fd_pr__model__cap_mim
Cp8_100 BOT_p8 TOP_P 8.647288000e-15 sky130_fd_pr__model__cap_mim
Cp8_101 BOT_p8 TOP_P 8.647288000e-15 sky130_fd_pr__model__cap_mim
Cp8_102 BOT_p8 TOP_P 8.647288000e-15 sky130_fd_pr__model__cap_mim
Cp8_103 BOT_p8 TOP_P 8.647288000e-15 sky130_fd_pr__model__cap_mim
Cp8_104 BOT_p8 TOP_P 8.647288000e-15 sky130_fd_pr__model__cap_mim
Cp8_105 BOT_p8 TOP_P 8.647288000e-15 sky130_fd_pr__model__cap_mim
Cp8_106 BOT_p8 TOP_P 8.647288000e-15 sky130_fd_pr__model__cap_mim
Cp8_107 BOT_p8 TOP_P 8.647288000e-15 sky130_fd_pr__model__cap_mim
Cp8_108 BOT_p8 TOP_P 8.647288000e-15 sky130_fd_pr__model__cap_mim
Cp8_109 BOT_p8 TOP_P 8.647288000e-15 sky130_fd_pr__model__cap_mim
Cp8_110 BOT_p8 TOP_P 8.647288000e-15 sky130_fd_pr__model__cap_mim
Cp8_111 BOT_p8 TOP_P 8.647288000e-15 sky130_fd_pr__model__cap_mim
Cp8_112 BOT_p8 TOP_P 8.647288000e-15 sky130_fd_pr__model__cap_mim
Cp8_113 BOT_p8 TOP_P 8.647288000e-15 sky130_fd_pr__model__cap_mim
Cp8_114 BOT_p8 TOP_P 8.647288000e-15 sky130_fd_pr__model__cap_mim
Cp8_115 BOT_p8 TOP_P 8.647288000e-15 sky130_fd_pr__model__cap_mim
Cp8_116 BOT_p8 TOP_P 8.647288000e-15 sky130_fd_pr__model__cap_mim
Cp8_117 BOT_p8 TOP_P 8.647288000e-15 sky130_fd_pr__model__cap_mim
Cp8_118 BOT_p8 TOP_P 8.647288000e-15 sky130_fd_pr__model__cap_mim
Cp8_119 BOT_p8 TOP_P 8.647288000e-15 sky130_fd_pr__model__cap_mim
Cp8_120 BOT_p8 TOP_P 8.647288000e-15 sky130_fd_pr__model__cap_mim
Cp8_121 BOT_p8 TOP_P 8.647288000e-15 sky130_fd_pr__model__cap_mim
Cp8_122 BOT_p8 TOP_P 8.647288000e-15 sky130_fd_pr__model__cap_mim
Cp8_123 BOT_p8 TOP_P 8.647288000e-15 sky130_fd_pr__model__cap_mim
Cp8_124 BOT_p8 TOP_P 8.647288000e-15 sky130_fd_pr__model__cap_mim
Cp8_125 BOT_p8 TOP_P 8.647288000e-15 sky130_fd_pr__model__cap_mim
Cp8_126 BOT_p8 TOP_P 8.647288000e-15 sky130_fd_pr__model__cap_mim
Cp8_127 BOT_p8 TOP_P 8.647288000e-15 sky130_fd_pr__model__cap_mim
Cp8_128 BOT_p8 TOP_P 8.647288000e-15 sky130_fd_pr__model__cap_mim
Cp8_129 BOT_p8 TOP_P 8.647288000e-15 sky130_fd_pr__model__cap_mim
Cp8_130 BOT_p8 TOP_P 8.647288000e-15 sky130_fd_pr__model__cap_mim
Cp8_131 BOT_p8 TOP_P 8.647288000e-15 sky130_fd_pr__model__cap_mim
Cp8_132 BOT_p8 TOP_P 8.647288000e-15 sky130_fd_pr__model__cap_mim
Cp8_133 BOT_p8 TOP_P 8.647288000e-15 sky130_fd_pr__model__cap_mim
Cp8_134 BOT_p8 TOP_P 8.647288000e-15 sky130_fd_pr__model__cap_mim
Cp8_135 BOT_p8 TOP_P 8.647288000e-15 sky130_fd_pr__model__cap_mim
Cp8_136 BOT_p8 TOP_P 8.647288000e-15 sky130_fd_pr__model__cap_mim
Cp8_137 BOT_p8 TOP_P 8.647288000e-15 sky130_fd_pr__model__cap_mim
Cp8_138 BOT_p8 TOP_P 8.647288000e-15 sky130_fd_pr__model__cap_mim
Cp8_139 BOT_p8 TOP_P 8.647288000e-15 sky130_fd_pr__model__cap_mim
Cp8_140 BOT_p8 TOP_P 8.647288000e-15 sky130_fd_pr__model__cap_mim
Cp8_141 BOT_p8 TOP_P 8.647288000e-15 sky130_fd_pr__model__cap_mim
Cp8_142 BOT_p8 TOP_P 8.647288000e-15 sky130_fd_pr__model__cap_mim
Cp8_143 BOT_p8 TOP_P 8.647288000e-15 sky130_fd_pr__model__cap_mim
Cp8_144 BOT_p8 TOP_P 8.647288000e-15 sky130_fd_pr__model__cap_mim
Cp8_145 BOT_p8 TOP_P 8.647288000e-15 sky130_fd_pr__model__cap_mim
Cp8_146 BOT_p8 TOP_P 8.647288000e-15 sky130_fd_pr__model__cap_mim
Cp8_147 BOT_p8 TOP_P 8.647288000e-15 sky130_fd_pr__model__cap_mim
Cp8_148 BOT_p8 TOP_P 8.647288000e-15 sky130_fd_pr__model__cap_mim
Cp8_149 BOT_p8 TOP_P 8.647288000e-15 sky130_fd_pr__model__cap_mim
Cp8_150 BOT_p8 TOP_P 8.647288000e-15 sky130_fd_pr__model__cap_mim
Cp8_151 BOT_p8 TOP_P 8.647288000e-15 sky130_fd_pr__model__cap_mim
Cp8_152 BOT_p8 TOP_P 8.647288000e-15 sky130_fd_pr__model__cap_mim
Cp8_153 BOT_p8 TOP_P 8.647288000e-15 sky130_fd_pr__model__cap_mim
Cp8_154 BOT_p8 TOP_P 8.647288000e-15 sky130_fd_pr__model__cap_mim
Cp8_155 BOT_p8 TOP_P 8.647288000e-15 sky130_fd_pr__model__cap_mim
Cp8_156 BOT_p8 TOP_P 8.647288000e-15 sky130_fd_pr__model__cap_mim
Cp8_157 BOT_p8 TOP_P 8.647288000e-15 sky130_fd_pr__model__cap_mim
Cp8_158 BOT_p8 TOP_P 8.647288000e-15 sky130_fd_pr__model__cap_mim
Cp8_159 BOT_p8 TOP_P 8.647288000e-15 sky130_fd_pr__model__cap_mim
Cp8_160 BOT_p8 TOP_P 8.647288000e-15 sky130_fd_pr__model__cap_mim
Cp8_161 BOT_p8 TOP_P 8.647288000e-15 sky130_fd_pr__model__cap_mim
Cp8_162 BOT_p8 TOP_P 8.647288000e-15 sky130_fd_pr__model__cap_mim
Cp8_163 BOT_p8 TOP_P 8.647288000e-15 sky130_fd_pr__model__cap_mim
Cp8_164 BOT_p8 TOP_P 8.647288000e-15 sky130_fd_pr__model__cap_mim
Cp8_165 BOT_p8 TOP_P 8.647288000e-15 sky130_fd_pr__model__cap_mim
Cp8_166 BOT_p8 TOP_P 8.647288000e-15 sky130_fd_pr__model__cap_mim
Cp8_167 BOT_p8 TOP_P 8.647288000e-15 sky130_fd_pr__model__cap_mim
Cp8_168 BOT_p8 TOP_P 8.647288000e-15 sky130_fd_pr__model__cap_mim
Cp8_169 BOT_p8 TOP_P 8.647288000e-15 sky130_fd_pr__model__cap_mim
Cp8_170 BOT_p8 TOP_P 8.647288000e-15 sky130_fd_pr__model__cap_mim
Cp8_171 BOT_p8 TOP_P 8.647288000e-15 sky130_fd_pr__model__cap_mim
Cp8_172 BOT_p8 TOP_P 8.647288000e-15 sky130_fd_pr__model__cap_mim
Cp8_173 BOT_p8 TOP_P 8.647288000e-15 sky130_fd_pr__model__cap_mim
Cp8_174 BOT_p8 TOP_P 8.647288000e-15 sky130_fd_pr__model__cap_mim
Cp8_175 BOT_p8 TOP_P 8.647288000e-15 sky130_fd_pr__model__cap_mim
Cp8_176 BOT_p8 TOP_P 8.647288000e-15 sky130_fd_pr__model__cap_mim
Cp8_177 BOT_p8 TOP_P 8.647288000e-15 sky130_fd_pr__model__cap_mim
Cp8_178 BOT_p8 TOP_P 8.647288000e-15 sky130_fd_pr__model__cap_mim
Cp8_179 BOT_p8 TOP_P 8.647288000e-15 sky130_fd_pr__model__cap_mim
Cp8_180 BOT_p8 TOP_P 8.647288000e-15 sky130_fd_pr__model__cap_mim
Cp8_181 BOT_p8 TOP_P 8.647288000e-15 sky130_fd_pr__model__cap_mim
Cp8_182 BOT_p8 TOP_P 8.647288000e-15 sky130_fd_pr__model__cap_mim
Cp8_183 BOT_p8 TOP_P 8.647288000e-15 sky130_fd_pr__model__cap_mim
Cp8_184 BOT_p8 TOP_P 8.647288000e-15 sky130_fd_pr__model__cap_mim
Cp8_185 BOT_p8 TOP_P 8.647288000e-15 sky130_fd_pr__model__cap_mim
Cp8_186 BOT_p8 TOP_P 8.647288000e-15 sky130_fd_pr__model__cap_mim
Cp8_187 BOT_p8 TOP_P 8.647288000e-15 sky130_fd_pr__model__cap_mim
Cp8_188 BOT_p8 TOP_P 8.647288000e-15 sky130_fd_pr__model__cap_mim
Cp8_189 BOT_p8 TOP_P 8.647288000e-15 sky130_fd_pr__model__cap_mim
Cp8_190 BOT_p8 TOP_P 8.647288000e-15 sky130_fd_pr__model__cap_mim
Cp8_191 BOT_p8 TOP_P 8.647288000e-15 sky130_fd_pr__model__cap_mim
Cp8_192 BOT_p8 TOP_P 8.647288000e-15 sky130_fd_pr__model__cap_mim
Cp8_193 BOT_p8 TOP_P 8.647288000e-15 sky130_fd_pr__model__cap_mim
Cp8_194 BOT_p8 TOP_P 8.647288000e-15 sky130_fd_pr__model__cap_mim
Cp8_195 BOT_p8 TOP_P 8.647288000e-15 sky130_fd_pr__model__cap_mim
Cp8_196 BOT_p8 TOP_P 8.647288000e-15 sky130_fd_pr__model__cap_mim
Cp8_197 BOT_p8 TOP_P 8.647288000e-15 sky130_fd_pr__model__cap_mim
Cp8_198 BOT_p8 TOP_P 8.647288000e-15 sky130_fd_pr__model__cap_mim
Cp8_199 BOT_p8 TOP_P 8.647288000e-15 sky130_fd_pr__model__cap_mim
Cp8_200 BOT_p8 TOP_P 8.647288000e-15 sky130_fd_pr__model__cap_mim
Cp8_201 BOT_p8 TOP_P 8.647288000e-15 sky130_fd_pr__model__cap_mim
Cp8_202 BOT_p8 TOP_P 8.647288000e-15 sky130_fd_pr__model__cap_mim
Cp8_203 BOT_p8 TOP_P 8.647288000e-15 sky130_fd_pr__model__cap_mim
Cp8_204 BOT_p8 TOP_P 8.647288000e-15 sky130_fd_pr__model__cap_mim
Cp8_205 BOT_p8 TOP_P 8.647288000e-15 sky130_fd_pr__model__cap_mim
Cp8_206 BOT_p8 TOP_P 8.647288000e-15 sky130_fd_pr__model__cap_mim
Cp8_207 BOT_p8 TOP_P 8.647288000e-15 sky130_fd_pr__model__cap_mim
Cp8_208 BOT_p8 TOP_P 8.647288000e-15 sky130_fd_pr__model__cap_mim
Cp8_209 BOT_p8 TOP_P 8.647288000e-15 sky130_fd_pr__model__cap_mim
Cp8_210 BOT_p8 TOP_P 8.647288000e-15 sky130_fd_pr__model__cap_mim
Cp8_211 BOT_p8 TOP_P 8.647288000e-15 sky130_fd_pr__model__cap_mim
Cp8_212 BOT_p8 TOP_P 8.647288000e-15 sky130_fd_pr__model__cap_mim
Cp8_213 BOT_p8 TOP_P 8.647288000e-15 sky130_fd_pr__model__cap_mim
Cp8_214 BOT_p8 TOP_P 8.647288000e-15 sky130_fd_pr__model__cap_mim
Cp8_215 BOT_p8 TOP_P 8.647288000e-15 sky130_fd_pr__model__cap_mim
Cp8_216 BOT_p8 TOP_P 8.647288000e-15 sky130_fd_pr__model__cap_mim
Cp8_217 BOT_p8 TOP_P 8.647288000e-15 sky130_fd_pr__model__cap_mim
Cp8_218 BOT_p8 TOP_P 8.647288000e-15 sky130_fd_pr__model__cap_mim
Cp8_219 BOT_p8 TOP_P 8.647288000e-15 sky130_fd_pr__model__cap_mim
Cp8_220 BOT_p8 TOP_P 8.647288000e-15 sky130_fd_pr__model__cap_mim
Cp8_221 BOT_p8 TOP_P 8.647288000e-15 sky130_fd_pr__model__cap_mim
Cp8_222 BOT_p8 TOP_P 8.647288000e-15 sky130_fd_pr__model__cap_mim
Cp8_223 BOT_p8 TOP_P 8.647288000e-15 sky130_fd_pr__model__cap_mim
Cp8_224 BOT_p8 TOP_P 8.647288000e-15 sky130_fd_pr__model__cap_mim
Cp8_225 BOT_p8 TOP_P 8.647288000e-15 sky130_fd_pr__model__cap_mim
Cp8_226 BOT_p8 TOP_P 8.647288000e-15 sky130_fd_pr__model__cap_mim
Cp8_227 BOT_p8 TOP_P 8.647288000e-15 sky130_fd_pr__model__cap_mim
Cp8_228 BOT_p8 TOP_P 8.647288000e-15 sky130_fd_pr__model__cap_mim
Cp8_229 BOT_p8 TOP_P 8.647288000e-15 sky130_fd_pr__model__cap_mim
Cp8_230 BOT_p8 TOP_P 8.647288000e-15 sky130_fd_pr__model__cap_mim
Cp8_231 BOT_p8 TOP_P 8.647288000e-15 sky130_fd_pr__model__cap_mim
Cp8_232 BOT_p8 TOP_P 8.647288000e-15 sky130_fd_pr__model__cap_mim
Cp8_233 BOT_p8 TOP_P 8.647288000e-15 sky130_fd_pr__model__cap_mim
Cp8_234 BOT_p8 TOP_P 8.647288000e-15 sky130_fd_pr__model__cap_mim
Cp8_235 BOT_p8 TOP_P 8.647288000e-15 sky130_fd_pr__model__cap_mim
Cp8_236 BOT_p8 TOP_P 8.647288000e-15 sky130_fd_pr__model__cap_mim
Cp8_237 BOT_p8 TOP_P 8.647288000e-15 sky130_fd_pr__model__cap_mim
Cp8_238 BOT_p8 TOP_P 8.647288000e-15 sky130_fd_pr__model__cap_mim
Cp8_239 BOT_p8 TOP_P 8.647288000e-15 sky130_fd_pr__model__cap_mim
Cp8_240 BOT_p8 TOP_P 8.647288000e-15 sky130_fd_pr__model__cap_mim
Cp8_241 BOT_p8 TOP_P 8.647288000e-15 sky130_fd_pr__model__cap_mim
Cp8_242 BOT_p8 TOP_P 8.647288000e-15 sky130_fd_pr__model__cap_mim
Cp8_243 BOT_p8 TOP_P 8.647288000e-15 sky130_fd_pr__model__cap_mim
Cp8_244 BOT_p8 TOP_P 8.647288000e-15 sky130_fd_pr__model__cap_mim
Cp8_245 BOT_p8 TOP_P 8.647288000e-15 sky130_fd_pr__model__cap_mim
Cp8_246 BOT_p8 TOP_P 8.647288000e-15 sky130_fd_pr__model__cap_mim
Cp8_247 BOT_p8 TOP_P 8.647288000e-15 sky130_fd_pr__model__cap_mim
Cp8_248 BOT_p8 TOP_P 8.647288000e-15 sky130_fd_pr__model__cap_mim
Cp8_249 BOT_p8 TOP_P 8.647288000e-15 sky130_fd_pr__model__cap_mim
Cp8_250 BOT_p8 TOP_P 8.647288000e-15 sky130_fd_pr__model__cap_mim
Cp8_251 BOT_p8 TOP_P 8.647288000e-15 sky130_fd_pr__model__cap_mim
Cp8_252 BOT_p8 TOP_P 8.647288000e-15 sky130_fd_pr__model__cap_mim
Cp8_253 BOT_p8 TOP_P 8.647288000e-15 sky130_fd_pr__model__cap_mim
Cp8_254 BOT_p8 TOP_P 8.647288000e-15 sky130_fd_pr__model__cap_mim
Cp8_255 BOT_p8 TOP_P 8.647288000e-15 sky130_fd_pr__model__cap_mim
Mp8n BOT_p8 SELp8 VREFN vsubs nfet L=0.15U W=1U
Mp8p BOT_p8 SELp8 VREFP VDD pfet L=0.15U W=2U
Cp_term VREFN TOP_P 8.647288000e-15 sky130_fd_pr__model__cap_mim
Cn0 BOT_n0 TOP_N 8.647288000e-15 sky130_fd_pr__model__cap_mim
Mn0n BOT_n0 SELn0 VREFN vsubs nfet L=0.15U W=1U
Mn0p BOT_n0 SELn0 VREFP VDD pfet L=0.15U W=2U
Cn1_0 BOT_n1 TOP_N 8.647288000e-15 sky130_fd_pr__model__cap_mim
Cn1_1 BOT_n1 TOP_N 8.647288000e-15 sky130_fd_pr__model__cap_mim
Mn1n BOT_n1 SELn1 VREFN vsubs nfet L=0.15U W=1U
Mn1p BOT_n1 SELn1 VREFP VDD pfet L=0.15U W=2U
Cn2_0 BOT_n2 TOP_N 8.647288000e-15 sky130_fd_pr__model__cap_mim
Cn2_1 BOT_n2 TOP_N 8.647288000e-15 sky130_fd_pr__model__cap_mim
Cn2_2 BOT_n2 TOP_N 8.647288000e-15 sky130_fd_pr__model__cap_mim
Cn2_3 BOT_n2 TOP_N 8.647288000e-15 sky130_fd_pr__model__cap_mim
Mn2n BOT_n2 SELn2 VREFN vsubs nfet L=0.15U W=1U
Mn2p BOT_n2 SELn2 VREFP VDD pfet L=0.15U W=2U
Cn3_0 BOT_n3 TOP_N 8.647288000e-15 sky130_fd_pr__model__cap_mim
Cn3_1 BOT_n3 TOP_N 8.647288000e-15 sky130_fd_pr__model__cap_mim
Cn3_2 BOT_n3 TOP_N 8.647288000e-15 sky130_fd_pr__model__cap_mim
Cn3_3 BOT_n3 TOP_N 8.647288000e-15 sky130_fd_pr__model__cap_mim
Cn3_4 BOT_n3 TOP_N 8.647288000e-15 sky130_fd_pr__model__cap_mim
Cn3_5 BOT_n3 TOP_N 8.647288000e-15 sky130_fd_pr__model__cap_mim
Cn3_6 BOT_n3 TOP_N 8.647288000e-15 sky130_fd_pr__model__cap_mim
Cn3_7 BOT_n3 TOP_N 8.647288000e-15 sky130_fd_pr__model__cap_mim
Mn3n BOT_n3 SELn3 VREFN vsubs nfet L=0.15U W=1U
Mn3p BOT_n3 SELn3 VREFP VDD pfet L=0.15U W=2U
Cn4_0 BOT_n4 TOP_N 8.647288000e-15 sky130_fd_pr__model__cap_mim
Cn4_1 BOT_n4 TOP_N 8.647288000e-15 sky130_fd_pr__model__cap_mim
Cn4_2 BOT_n4 TOP_N 8.647288000e-15 sky130_fd_pr__model__cap_mim
Cn4_3 BOT_n4 TOP_N 8.647288000e-15 sky130_fd_pr__model__cap_mim
Cn4_4 BOT_n4 TOP_N 8.647288000e-15 sky130_fd_pr__model__cap_mim
Cn4_5 BOT_n4 TOP_N 8.647288000e-15 sky130_fd_pr__model__cap_mim
Cn4_6 BOT_n4 TOP_N 8.647288000e-15 sky130_fd_pr__model__cap_mim
Cn4_7 BOT_n4 TOP_N 8.647288000e-15 sky130_fd_pr__model__cap_mim
Cn4_8 BOT_n4 TOP_N 8.647288000e-15 sky130_fd_pr__model__cap_mim
Cn4_9 BOT_n4 TOP_N 8.647288000e-15 sky130_fd_pr__model__cap_mim
Cn4_10 BOT_n4 TOP_N 8.647288000e-15 sky130_fd_pr__model__cap_mim
Cn4_11 BOT_n4 TOP_N 8.647288000e-15 sky130_fd_pr__model__cap_mim
Cn4_12 BOT_n4 TOP_N 8.647288000e-15 sky130_fd_pr__model__cap_mim
Cn4_13 BOT_n4 TOP_N 8.647288000e-15 sky130_fd_pr__model__cap_mim
Cn4_14 BOT_n4 TOP_N 8.647288000e-15 sky130_fd_pr__model__cap_mim
Cn4_15 BOT_n4 TOP_N 8.647288000e-15 sky130_fd_pr__model__cap_mim
Mn4n BOT_n4 SELn4 VREFN vsubs nfet L=0.15U W=1U
Mn4p BOT_n4 SELn4 VREFP VDD pfet L=0.15U W=2U
Cn5_0 BOT_n5 TOP_N 8.647288000e-15 sky130_fd_pr__model__cap_mim
Cn5_1 BOT_n5 TOP_N 8.647288000e-15 sky130_fd_pr__model__cap_mim
Cn5_2 BOT_n5 TOP_N 8.647288000e-15 sky130_fd_pr__model__cap_mim
Cn5_3 BOT_n5 TOP_N 8.647288000e-15 sky130_fd_pr__model__cap_mim
Cn5_4 BOT_n5 TOP_N 8.647288000e-15 sky130_fd_pr__model__cap_mim
Cn5_5 BOT_n5 TOP_N 8.647288000e-15 sky130_fd_pr__model__cap_mim
Cn5_6 BOT_n5 TOP_N 8.647288000e-15 sky130_fd_pr__model__cap_mim
Cn5_7 BOT_n5 TOP_N 8.647288000e-15 sky130_fd_pr__model__cap_mim
Cn5_8 BOT_n5 TOP_N 8.647288000e-15 sky130_fd_pr__model__cap_mim
Cn5_9 BOT_n5 TOP_N 8.647288000e-15 sky130_fd_pr__model__cap_mim
Cn5_10 BOT_n5 TOP_N 8.647288000e-15 sky130_fd_pr__model__cap_mim
Cn5_11 BOT_n5 TOP_N 8.647288000e-15 sky130_fd_pr__model__cap_mim
Cn5_12 BOT_n5 TOP_N 8.647288000e-15 sky130_fd_pr__model__cap_mim
Cn5_13 BOT_n5 TOP_N 8.647288000e-15 sky130_fd_pr__model__cap_mim
Cn5_14 BOT_n5 TOP_N 8.647288000e-15 sky130_fd_pr__model__cap_mim
Cn5_15 BOT_n5 TOP_N 8.647288000e-15 sky130_fd_pr__model__cap_mim
Cn5_16 BOT_n5 TOP_N 8.647288000e-15 sky130_fd_pr__model__cap_mim
Cn5_17 BOT_n5 TOP_N 8.647288000e-15 sky130_fd_pr__model__cap_mim
Cn5_18 BOT_n5 TOP_N 8.647288000e-15 sky130_fd_pr__model__cap_mim
Cn5_19 BOT_n5 TOP_N 8.647288000e-15 sky130_fd_pr__model__cap_mim
Cn5_20 BOT_n5 TOP_N 8.647288000e-15 sky130_fd_pr__model__cap_mim
Cn5_21 BOT_n5 TOP_N 8.647288000e-15 sky130_fd_pr__model__cap_mim
Cn5_22 BOT_n5 TOP_N 8.647288000e-15 sky130_fd_pr__model__cap_mim
Cn5_23 BOT_n5 TOP_N 8.647288000e-15 sky130_fd_pr__model__cap_mim
Cn5_24 BOT_n5 TOP_N 8.647288000e-15 sky130_fd_pr__model__cap_mim
Cn5_25 BOT_n5 TOP_N 8.647288000e-15 sky130_fd_pr__model__cap_mim
Cn5_26 BOT_n5 TOP_N 8.647288000e-15 sky130_fd_pr__model__cap_mim
Cn5_27 BOT_n5 TOP_N 8.647288000e-15 sky130_fd_pr__model__cap_mim
Cn5_28 BOT_n5 TOP_N 8.647288000e-15 sky130_fd_pr__model__cap_mim
Cn5_29 BOT_n5 TOP_N 8.647288000e-15 sky130_fd_pr__model__cap_mim
Cn5_30 BOT_n5 TOP_N 8.647288000e-15 sky130_fd_pr__model__cap_mim
Cn5_31 BOT_n5 TOP_N 8.647288000e-15 sky130_fd_pr__model__cap_mim
Mn5n BOT_n5 SELn5 VREFN vsubs nfet L=0.15U W=1U
Mn5p BOT_n5 SELn5 VREFP VDD pfet L=0.15U W=2U
Cn6_0 BOT_n6 TOP_N 8.647288000e-15 sky130_fd_pr__model__cap_mim
Cn6_1 BOT_n6 TOP_N 8.647288000e-15 sky130_fd_pr__model__cap_mim
Cn6_2 BOT_n6 TOP_N 8.647288000e-15 sky130_fd_pr__model__cap_mim
Cn6_3 BOT_n6 TOP_N 8.647288000e-15 sky130_fd_pr__model__cap_mim
Cn6_4 BOT_n6 TOP_N 8.647288000e-15 sky130_fd_pr__model__cap_mim
Cn6_5 BOT_n6 TOP_N 8.647288000e-15 sky130_fd_pr__model__cap_mim
Cn6_6 BOT_n6 TOP_N 8.647288000e-15 sky130_fd_pr__model__cap_mim
Cn6_7 BOT_n6 TOP_N 8.647288000e-15 sky130_fd_pr__model__cap_mim
Cn6_8 BOT_n6 TOP_N 8.647288000e-15 sky130_fd_pr__model__cap_mim
Cn6_9 BOT_n6 TOP_N 8.647288000e-15 sky130_fd_pr__model__cap_mim
Cn6_10 BOT_n6 TOP_N 8.647288000e-15 sky130_fd_pr__model__cap_mim
Cn6_11 BOT_n6 TOP_N 8.647288000e-15 sky130_fd_pr__model__cap_mim
Cn6_12 BOT_n6 TOP_N 8.647288000e-15 sky130_fd_pr__model__cap_mim
Cn6_13 BOT_n6 TOP_N 8.647288000e-15 sky130_fd_pr__model__cap_mim
Cn6_14 BOT_n6 TOP_N 8.647288000e-15 sky130_fd_pr__model__cap_mim
Cn6_15 BOT_n6 TOP_N 8.647288000e-15 sky130_fd_pr__model__cap_mim
Cn6_16 BOT_n6 TOP_N 8.647288000e-15 sky130_fd_pr__model__cap_mim
Cn6_17 BOT_n6 TOP_N 8.647288000e-15 sky130_fd_pr__model__cap_mim
Cn6_18 BOT_n6 TOP_N 8.647288000e-15 sky130_fd_pr__model__cap_mim
Cn6_19 BOT_n6 TOP_N 8.647288000e-15 sky130_fd_pr__model__cap_mim
Cn6_20 BOT_n6 TOP_N 8.647288000e-15 sky130_fd_pr__model__cap_mim
Cn6_21 BOT_n6 TOP_N 8.647288000e-15 sky130_fd_pr__model__cap_mim
Cn6_22 BOT_n6 TOP_N 8.647288000e-15 sky130_fd_pr__model__cap_mim
Cn6_23 BOT_n6 TOP_N 8.647288000e-15 sky130_fd_pr__model__cap_mim
Cn6_24 BOT_n6 TOP_N 8.647288000e-15 sky130_fd_pr__model__cap_mim
Cn6_25 BOT_n6 TOP_N 8.647288000e-15 sky130_fd_pr__model__cap_mim
Cn6_26 BOT_n6 TOP_N 8.647288000e-15 sky130_fd_pr__model__cap_mim
Cn6_27 BOT_n6 TOP_N 8.647288000e-15 sky130_fd_pr__model__cap_mim
Cn6_28 BOT_n6 TOP_N 8.647288000e-15 sky130_fd_pr__model__cap_mim
Cn6_29 BOT_n6 TOP_N 8.647288000e-15 sky130_fd_pr__model__cap_mim
Cn6_30 BOT_n6 TOP_N 8.647288000e-15 sky130_fd_pr__model__cap_mim
Cn6_31 BOT_n6 TOP_N 8.647288000e-15 sky130_fd_pr__model__cap_mim
Cn6_32 BOT_n6 TOP_N 8.647288000e-15 sky130_fd_pr__model__cap_mim
Cn6_33 BOT_n6 TOP_N 8.647288000e-15 sky130_fd_pr__model__cap_mim
Cn6_34 BOT_n6 TOP_N 8.647288000e-15 sky130_fd_pr__model__cap_mim
Cn6_35 BOT_n6 TOP_N 8.647288000e-15 sky130_fd_pr__model__cap_mim
Cn6_36 BOT_n6 TOP_N 8.647288000e-15 sky130_fd_pr__model__cap_mim
Cn6_37 BOT_n6 TOP_N 8.647288000e-15 sky130_fd_pr__model__cap_mim
Cn6_38 BOT_n6 TOP_N 8.647288000e-15 sky130_fd_pr__model__cap_mim
Cn6_39 BOT_n6 TOP_N 8.647288000e-15 sky130_fd_pr__model__cap_mim
Cn6_40 BOT_n6 TOP_N 8.647288000e-15 sky130_fd_pr__model__cap_mim
Cn6_41 BOT_n6 TOP_N 8.647288000e-15 sky130_fd_pr__model__cap_mim
Cn6_42 BOT_n6 TOP_N 8.647288000e-15 sky130_fd_pr__model__cap_mim
Cn6_43 BOT_n6 TOP_N 8.647288000e-15 sky130_fd_pr__model__cap_mim
Cn6_44 BOT_n6 TOP_N 8.647288000e-15 sky130_fd_pr__model__cap_mim
Cn6_45 BOT_n6 TOP_N 8.647288000e-15 sky130_fd_pr__model__cap_mim
Cn6_46 BOT_n6 TOP_N 8.647288000e-15 sky130_fd_pr__model__cap_mim
Cn6_47 BOT_n6 TOP_N 8.647288000e-15 sky130_fd_pr__model__cap_mim
Cn6_48 BOT_n6 TOP_N 8.647288000e-15 sky130_fd_pr__model__cap_mim
Cn6_49 BOT_n6 TOP_N 8.647288000e-15 sky130_fd_pr__model__cap_mim
Cn6_50 BOT_n6 TOP_N 8.647288000e-15 sky130_fd_pr__model__cap_mim
Cn6_51 BOT_n6 TOP_N 8.647288000e-15 sky130_fd_pr__model__cap_mim
Cn6_52 BOT_n6 TOP_N 8.647288000e-15 sky130_fd_pr__model__cap_mim
Cn6_53 BOT_n6 TOP_N 8.647288000e-15 sky130_fd_pr__model__cap_mim
Cn6_54 BOT_n6 TOP_N 8.647288000e-15 sky130_fd_pr__model__cap_mim
Cn6_55 BOT_n6 TOP_N 8.647288000e-15 sky130_fd_pr__model__cap_mim
Cn6_56 BOT_n6 TOP_N 8.647288000e-15 sky130_fd_pr__model__cap_mim
Cn6_57 BOT_n6 TOP_N 8.647288000e-15 sky130_fd_pr__model__cap_mim
Cn6_58 BOT_n6 TOP_N 8.647288000e-15 sky130_fd_pr__model__cap_mim
Cn6_59 BOT_n6 TOP_N 8.647288000e-15 sky130_fd_pr__model__cap_mim
Cn6_60 BOT_n6 TOP_N 8.647288000e-15 sky130_fd_pr__model__cap_mim
Cn6_61 BOT_n6 TOP_N 8.647288000e-15 sky130_fd_pr__model__cap_mim
Cn6_62 BOT_n6 TOP_N 8.647288000e-15 sky130_fd_pr__model__cap_mim
Cn6_63 BOT_n6 TOP_N 8.647288000e-15 sky130_fd_pr__model__cap_mim
Mn6n BOT_n6 SELn6 VREFN vsubs nfet L=0.15U W=1U
Mn6p BOT_n6 SELn6 VREFP VDD pfet L=0.15U W=2U
Cn7_0 BOT_n7 TOP_N 8.647288000e-15 sky130_fd_pr__model__cap_mim
Cn7_1 BOT_n7 TOP_N 8.647288000e-15 sky130_fd_pr__model__cap_mim
Cn7_2 BOT_n7 TOP_N 8.647288000e-15 sky130_fd_pr__model__cap_mim
Cn7_3 BOT_n7 TOP_N 8.647288000e-15 sky130_fd_pr__model__cap_mim
Cn7_4 BOT_n7 TOP_N 8.647288000e-15 sky130_fd_pr__model__cap_mim
Cn7_5 BOT_n7 TOP_N 8.647288000e-15 sky130_fd_pr__model__cap_mim
Cn7_6 BOT_n7 TOP_N 8.647288000e-15 sky130_fd_pr__model__cap_mim
Cn7_7 BOT_n7 TOP_N 8.647288000e-15 sky130_fd_pr__model__cap_mim
Cn7_8 BOT_n7 TOP_N 8.647288000e-15 sky130_fd_pr__model__cap_mim
Cn7_9 BOT_n7 TOP_N 8.647288000e-15 sky130_fd_pr__model__cap_mim
Cn7_10 BOT_n7 TOP_N 8.647288000e-15 sky130_fd_pr__model__cap_mim
Cn7_11 BOT_n7 TOP_N 8.647288000e-15 sky130_fd_pr__model__cap_mim
Cn7_12 BOT_n7 TOP_N 8.647288000e-15 sky130_fd_pr__model__cap_mim
Cn7_13 BOT_n7 TOP_N 8.647288000e-15 sky130_fd_pr__model__cap_mim
Cn7_14 BOT_n7 TOP_N 8.647288000e-15 sky130_fd_pr__model__cap_mim
Cn7_15 BOT_n7 TOP_N 8.647288000e-15 sky130_fd_pr__model__cap_mim
Cn7_16 BOT_n7 TOP_N 8.647288000e-15 sky130_fd_pr__model__cap_mim
Cn7_17 BOT_n7 TOP_N 8.647288000e-15 sky130_fd_pr__model__cap_mim
Cn7_18 BOT_n7 TOP_N 8.647288000e-15 sky130_fd_pr__model__cap_mim
Cn7_19 BOT_n7 TOP_N 8.647288000e-15 sky130_fd_pr__model__cap_mim
Cn7_20 BOT_n7 TOP_N 8.647288000e-15 sky130_fd_pr__model__cap_mim
Cn7_21 BOT_n7 TOP_N 8.647288000e-15 sky130_fd_pr__model__cap_mim
Cn7_22 BOT_n7 TOP_N 8.647288000e-15 sky130_fd_pr__model__cap_mim
Cn7_23 BOT_n7 TOP_N 8.647288000e-15 sky130_fd_pr__model__cap_mim
Cn7_24 BOT_n7 TOP_N 8.647288000e-15 sky130_fd_pr__model__cap_mim
Cn7_25 BOT_n7 TOP_N 8.647288000e-15 sky130_fd_pr__model__cap_mim
Cn7_26 BOT_n7 TOP_N 8.647288000e-15 sky130_fd_pr__model__cap_mim
Cn7_27 BOT_n7 TOP_N 8.647288000e-15 sky130_fd_pr__model__cap_mim
Cn7_28 BOT_n7 TOP_N 8.647288000e-15 sky130_fd_pr__model__cap_mim
Cn7_29 BOT_n7 TOP_N 8.647288000e-15 sky130_fd_pr__model__cap_mim
Cn7_30 BOT_n7 TOP_N 8.647288000e-15 sky130_fd_pr__model__cap_mim
Cn7_31 BOT_n7 TOP_N 8.647288000e-15 sky130_fd_pr__model__cap_mim
Cn7_32 BOT_n7 TOP_N 8.647288000e-15 sky130_fd_pr__model__cap_mim
Cn7_33 BOT_n7 TOP_N 8.647288000e-15 sky130_fd_pr__model__cap_mim
Cn7_34 BOT_n7 TOP_N 8.647288000e-15 sky130_fd_pr__model__cap_mim
Cn7_35 BOT_n7 TOP_N 8.647288000e-15 sky130_fd_pr__model__cap_mim
Cn7_36 BOT_n7 TOP_N 8.647288000e-15 sky130_fd_pr__model__cap_mim
Cn7_37 BOT_n7 TOP_N 8.647288000e-15 sky130_fd_pr__model__cap_mim
Cn7_38 BOT_n7 TOP_N 8.647288000e-15 sky130_fd_pr__model__cap_mim
Cn7_39 BOT_n7 TOP_N 8.647288000e-15 sky130_fd_pr__model__cap_mim
Cn7_40 BOT_n7 TOP_N 8.647288000e-15 sky130_fd_pr__model__cap_mim
Cn7_41 BOT_n7 TOP_N 8.647288000e-15 sky130_fd_pr__model__cap_mim
Cn7_42 BOT_n7 TOP_N 8.647288000e-15 sky130_fd_pr__model__cap_mim
Cn7_43 BOT_n7 TOP_N 8.647288000e-15 sky130_fd_pr__model__cap_mim
Cn7_44 BOT_n7 TOP_N 8.647288000e-15 sky130_fd_pr__model__cap_mim
Cn7_45 BOT_n7 TOP_N 8.647288000e-15 sky130_fd_pr__model__cap_mim
Cn7_46 BOT_n7 TOP_N 8.647288000e-15 sky130_fd_pr__model__cap_mim
Cn7_47 BOT_n7 TOP_N 8.647288000e-15 sky130_fd_pr__model__cap_mim
Cn7_48 BOT_n7 TOP_N 8.647288000e-15 sky130_fd_pr__model__cap_mim
Cn7_49 BOT_n7 TOP_N 8.647288000e-15 sky130_fd_pr__model__cap_mim
Cn7_50 BOT_n7 TOP_N 8.647288000e-15 sky130_fd_pr__model__cap_mim
Cn7_51 BOT_n7 TOP_N 8.647288000e-15 sky130_fd_pr__model__cap_mim
Cn7_52 BOT_n7 TOP_N 8.647288000e-15 sky130_fd_pr__model__cap_mim
Cn7_53 BOT_n7 TOP_N 8.647288000e-15 sky130_fd_pr__model__cap_mim
Cn7_54 BOT_n7 TOP_N 8.647288000e-15 sky130_fd_pr__model__cap_mim
Cn7_55 BOT_n7 TOP_N 8.647288000e-15 sky130_fd_pr__model__cap_mim
Cn7_56 BOT_n7 TOP_N 8.647288000e-15 sky130_fd_pr__model__cap_mim
Cn7_57 BOT_n7 TOP_N 8.647288000e-15 sky130_fd_pr__model__cap_mim
Cn7_58 BOT_n7 TOP_N 8.647288000e-15 sky130_fd_pr__model__cap_mim
Cn7_59 BOT_n7 TOP_N 8.647288000e-15 sky130_fd_pr__model__cap_mim
Cn7_60 BOT_n7 TOP_N 8.647288000e-15 sky130_fd_pr__model__cap_mim
Cn7_61 BOT_n7 TOP_N 8.647288000e-15 sky130_fd_pr__model__cap_mim
Cn7_62 BOT_n7 TOP_N 8.647288000e-15 sky130_fd_pr__model__cap_mim
Cn7_63 BOT_n7 TOP_N 8.647288000e-15 sky130_fd_pr__model__cap_mim
Cn7_64 BOT_n7 TOP_N 8.647288000e-15 sky130_fd_pr__model__cap_mim
Cn7_65 BOT_n7 TOP_N 8.647288000e-15 sky130_fd_pr__model__cap_mim
Cn7_66 BOT_n7 TOP_N 8.647288000e-15 sky130_fd_pr__model__cap_mim
Cn7_67 BOT_n7 TOP_N 8.647288000e-15 sky130_fd_pr__model__cap_mim
Cn7_68 BOT_n7 TOP_N 8.647288000e-15 sky130_fd_pr__model__cap_mim
Cn7_69 BOT_n7 TOP_N 8.647288000e-15 sky130_fd_pr__model__cap_mim
Cn7_70 BOT_n7 TOP_N 8.647288000e-15 sky130_fd_pr__model__cap_mim
Cn7_71 BOT_n7 TOP_N 8.647288000e-15 sky130_fd_pr__model__cap_mim
Cn7_72 BOT_n7 TOP_N 8.647288000e-15 sky130_fd_pr__model__cap_mim
Cn7_73 BOT_n7 TOP_N 8.647288000e-15 sky130_fd_pr__model__cap_mim
Cn7_74 BOT_n7 TOP_N 8.647288000e-15 sky130_fd_pr__model__cap_mim
Cn7_75 BOT_n7 TOP_N 8.647288000e-15 sky130_fd_pr__model__cap_mim
Cn7_76 BOT_n7 TOP_N 8.647288000e-15 sky130_fd_pr__model__cap_mim
Cn7_77 BOT_n7 TOP_N 8.647288000e-15 sky130_fd_pr__model__cap_mim
Cn7_78 BOT_n7 TOP_N 8.647288000e-15 sky130_fd_pr__model__cap_mim
Cn7_79 BOT_n7 TOP_N 8.647288000e-15 sky130_fd_pr__model__cap_mim
Cn7_80 BOT_n7 TOP_N 8.647288000e-15 sky130_fd_pr__model__cap_mim
Cn7_81 BOT_n7 TOP_N 8.647288000e-15 sky130_fd_pr__model__cap_mim
Cn7_82 BOT_n7 TOP_N 8.647288000e-15 sky130_fd_pr__model__cap_mim
Cn7_83 BOT_n7 TOP_N 8.647288000e-15 sky130_fd_pr__model__cap_mim
Cn7_84 BOT_n7 TOP_N 8.647288000e-15 sky130_fd_pr__model__cap_mim
Cn7_85 BOT_n7 TOP_N 8.647288000e-15 sky130_fd_pr__model__cap_mim
Cn7_86 BOT_n7 TOP_N 8.647288000e-15 sky130_fd_pr__model__cap_mim
Cn7_87 BOT_n7 TOP_N 8.647288000e-15 sky130_fd_pr__model__cap_mim
Cn7_88 BOT_n7 TOP_N 8.647288000e-15 sky130_fd_pr__model__cap_mim
Cn7_89 BOT_n7 TOP_N 8.647288000e-15 sky130_fd_pr__model__cap_mim
Cn7_90 BOT_n7 TOP_N 8.647288000e-15 sky130_fd_pr__model__cap_mim
Cn7_91 BOT_n7 TOP_N 8.647288000e-15 sky130_fd_pr__model__cap_mim
Cn7_92 BOT_n7 TOP_N 8.647288000e-15 sky130_fd_pr__model__cap_mim
Cn7_93 BOT_n7 TOP_N 8.647288000e-15 sky130_fd_pr__model__cap_mim
Cn7_94 BOT_n7 TOP_N 8.647288000e-15 sky130_fd_pr__model__cap_mim
Cn7_95 BOT_n7 TOP_N 8.647288000e-15 sky130_fd_pr__model__cap_mim
Cn7_96 BOT_n7 TOP_N 8.647288000e-15 sky130_fd_pr__model__cap_mim
Cn7_97 BOT_n7 TOP_N 8.647288000e-15 sky130_fd_pr__model__cap_mim
Cn7_98 BOT_n7 TOP_N 8.647288000e-15 sky130_fd_pr__model__cap_mim
Cn7_99 BOT_n7 TOP_N 8.647288000e-15 sky130_fd_pr__model__cap_mim
Cn7_100 BOT_n7 TOP_N 8.647288000e-15 sky130_fd_pr__model__cap_mim
Cn7_101 BOT_n7 TOP_N 8.647288000e-15 sky130_fd_pr__model__cap_mim
Cn7_102 BOT_n7 TOP_N 8.647288000e-15 sky130_fd_pr__model__cap_mim
Cn7_103 BOT_n7 TOP_N 8.647288000e-15 sky130_fd_pr__model__cap_mim
Cn7_104 BOT_n7 TOP_N 8.647288000e-15 sky130_fd_pr__model__cap_mim
Cn7_105 BOT_n7 TOP_N 8.647288000e-15 sky130_fd_pr__model__cap_mim
Cn7_106 BOT_n7 TOP_N 8.647288000e-15 sky130_fd_pr__model__cap_mim
Cn7_107 BOT_n7 TOP_N 8.647288000e-15 sky130_fd_pr__model__cap_mim
Cn7_108 BOT_n7 TOP_N 8.647288000e-15 sky130_fd_pr__model__cap_mim
Cn7_109 BOT_n7 TOP_N 8.647288000e-15 sky130_fd_pr__model__cap_mim
Cn7_110 BOT_n7 TOP_N 8.647288000e-15 sky130_fd_pr__model__cap_mim
Cn7_111 BOT_n7 TOP_N 8.647288000e-15 sky130_fd_pr__model__cap_mim
Cn7_112 BOT_n7 TOP_N 8.647288000e-15 sky130_fd_pr__model__cap_mim
Cn7_113 BOT_n7 TOP_N 8.647288000e-15 sky130_fd_pr__model__cap_mim
Cn7_114 BOT_n7 TOP_N 8.647288000e-15 sky130_fd_pr__model__cap_mim
Cn7_115 BOT_n7 TOP_N 8.647288000e-15 sky130_fd_pr__model__cap_mim
Cn7_116 BOT_n7 TOP_N 8.647288000e-15 sky130_fd_pr__model__cap_mim
Cn7_117 BOT_n7 TOP_N 8.647288000e-15 sky130_fd_pr__model__cap_mim
Cn7_118 BOT_n7 TOP_N 8.647288000e-15 sky130_fd_pr__model__cap_mim
Cn7_119 BOT_n7 TOP_N 8.647288000e-15 sky130_fd_pr__model__cap_mim
Cn7_120 BOT_n7 TOP_N 8.647288000e-15 sky130_fd_pr__model__cap_mim
Cn7_121 BOT_n7 TOP_N 8.647288000e-15 sky130_fd_pr__model__cap_mim
Cn7_122 BOT_n7 TOP_N 8.647288000e-15 sky130_fd_pr__model__cap_mim
Cn7_123 BOT_n7 TOP_N 8.647288000e-15 sky130_fd_pr__model__cap_mim
Cn7_124 BOT_n7 TOP_N 8.647288000e-15 sky130_fd_pr__model__cap_mim
Cn7_125 BOT_n7 TOP_N 8.647288000e-15 sky130_fd_pr__model__cap_mim
Cn7_126 BOT_n7 TOP_N 8.647288000e-15 sky130_fd_pr__model__cap_mim
Cn7_127 BOT_n7 TOP_N 8.647288000e-15 sky130_fd_pr__model__cap_mim
Mn7n BOT_n7 SELn7 VREFN vsubs nfet L=0.15U W=1U
Mn7p BOT_n7 SELn7 VREFP VDD pfet L=0.15U W=2U
Cn8_0 BOT_n8 TOP_N 8.647288000e-15 sky130_fd_pr__model__cap_mim
Cn8_1 BOT_n8 TOP_N 8.647288000e-15 sky130_fd_pr__model__cap_mim
Cn8_2 BOT_n8 TOP_N 8.647288000e-15 sky130_fd_pr__model__cap_mim
Cn8_3 BOT_n8 TOP_N 8.647288000e-15 sky130_fd_pr__model__cap_mim
Cn8_4 BOT_n8 TOP_N 8.647288000e-15 sky130_fd_pr__model__cap_mim
Cn8_5 BOT_n8 TOP_N 8.647288000e-15 sky130_fd_pr__model__cap_mim
Cn8_6 BOT_n8 TOP_N 8.647288000e-15 sky130_fd_pr__model__cap_mim
Cn8_7 BOT_n8 TOP_N 8.647288000e-15 sky130_fd_pr__model__cap_mim
Cn8_8 BOT_n8 TOP_N 8.647288000e-15 sky130_fd_pr__model__cap_mim
Cn8_9 BOT_n8 TOP_N 8.647288000e-15 sky130_fd_pr__model__cap_mim
Cn8_10 BOT_n8 TOP_N 8.647288000e-15 sky130_fd_pr__model__cap_mim
Cn8_11 BOT_n8 TOP_N 8.647288000e-15 sky130_fd_pr__model__cap_mim
Cn8_12 BOT_n8 TOP_N 8.647288000e-15 sky130_fd_pr__model__cap_mim
Cn8_13 BOT_n8 TOP_N 8.647288000e-15 sky130_fd_pr__model__cap_mim
Cn8_14 BOT_n8 TOP_N 8.647288000e-15 sky130_fd_pr__model__cap_mim
Cn8_15 BOT_n8 TOP_N 8.647288000e-15 sky130_fd_pr__model__cap_mim
Cn8_16 BOT_n8 TOP_N 8.647288000e-15 sky130_fd_pr__model__cap_mim
Cn8_17 BOT_n8 TOP_N 8.647288000e-15 sky130_fd_pr__model__cap_mim
Cn8_18 BOT_n8 TOP_N 8.647288000e-15 sky130_fd_pr__model__cap_mim
Cn8_19 BOT_n8 TOP_N 8.647288000e-15 sky130_fd_pr__model__cap_mim
Cn8_20 BOT_n8 TOP_N 8.647288000e-15 sky130_fd_pr__model__cap_mim
Cn8_21 BOT_n8 TOP_N 8.647288000e-15 sky130_fd_pr__model__cap_mim
Cn8_22 BOT_n8 TOP_N 8.647288000e-15 sky130_fd_pr__model__cap_mim
Cn8_23 BOT_n8 TOP_N 8.647288000e-15 sky130_fd_pr__model__cap_mim
Cn8_24 BOT_n8 TOP_N 8.647288000e-15 sky130_fd_pr__model__cap_mim
Cn8_25 BOT_n8 TOP_N 8.647288000e-15 sky130_fd_pr__model__cap_mim
Cn8_26 BOT_n8 TOP_N 8.647288000e-15 sky130_fd_pr__model__cap_mim
Cn8_27 BOT_n8 TOP_N 8.647288000e-15 sky130_fd_pr__model__cap_mim
Cn8_28 BOT_n8 TOP_N 8.647288000e-15 sky130_fd_pr__model__cap_mim
Cn8_29 BOT_n8 TOP_N 8.647288000e-15 sky130_fd_pr__model__cap_mim
Cn8_30 BOT_n8 TOP_N 8.647288000e-15 sky130_fd_pr__model__cap_mim
Cn8_31 BOT_n8 TOP_N 8.647288000e-15 sky130_fd_pr__model__cap_mim
Cn8_32 BOT_n8 TOP_N 8.647288000e-15 sky130_fd_pr__model__cap_mim
Cn8_33 BOT_n8 TOP_N 8.647288000e-15 sky130_fd_pr__model__cap_mim
Cn8_34 BOT_n8 TOP_N 8.647288000e-15 sky130_fd_pr__model__cap_mim
Cn8_35 BOT_n8 TOP_N 8.647288000e-15 sky130_fd_pr__model__cap_mim
Cn8_36 BOT_n8 TOP_N 8.647288000e-15 sky130_fd_pr__model__cap_mim
Cn8_37 BOT_n8 TOP_N 8.647288000e-15 sky130_fd_pr__model__cap_mim
Cn8_38 BOT_n8 TOP_N 8.647288000e-15 sky130_fd_pr__model__cap_mim
Cn8_39 BOT_n8 TOP_N 8.647288000e-15 sky130_fd_pr__model__cap_mim
Cn8_40 BOT_n8 TOP_N 8.647288000e-15 sky130_fd_pr__model__cap_mim
Cn8_41 BOT_n8 TOP_N 8.647288000e-15 sky130_fd_pr__model__cap_mim
Cn8_42 BOT_n8 TOP_N 8.647288000e-15 sky130_fd_pr__model__cap_mim
Cn8_43 BOT_n8 TOP_N 8.647288000e-15 sky130_fd_pr__model__cap_mim
Cn8_44 BOT_n8 TOP_N 8.647288000e-15 sky130_fd_pr__model__cap_mim
Cn8_45 BOT_n8 TOP_N 8.647288000e-15 sky130_fd_pr__model__cap_mim
Cn8_46 BOT_n8 TOP_N 8.647288000e-15 sky130_fd_pr__model__cap_mim
Cn8_47 BOT_n8 TOP_N 8.647288000e-15 sky130_fd_pr__model__cap_mim
Cn8_48 BOT_n8 TOP_N 8.647288000e-15 sky130_fd_pr__model__cap_mim
Cn8_49 BOT_n8 TOP_N 8.647288000e-15 sky130_fd_pr__model__cap_mim
Cn8_50 BOT_n8 TOP_N 8.647288000e-15 sky130_fd_pr__model__cap_mim
Cn8_51 BOT_n8 TOP_N 8.647288000e-15 sky130_fd_pr__model__cap_mim
Cn8_52 BOT_n8 TOP_N 8.647288000e-15 sky130_fd_pr__model__cap_mim
Cn8_53 BOT_n8 TOP_N 8.647288000e-15 sky130_fd_pr__model__cap_mim
Cn8_54 BOT_n8 TOP_N 8.647288000e-15 sky130_fd_pr__model__cap_mim
Cn8_55 BOT_n8 TOP_N 8.647288000e-15 sky130_fd_pr__model__cap_mim
Cn8_56 BOT_n8 TOP_N 8.647288000e-15 sky130_fd_pr__model__cap_mim
Cn8_57 BOT_n8 TOP_N 8.647288000e-15 sky130_fd_pr__model__cap_mim
Cn8_58 BOT_n8 TOP_N 8.647288000e-15 sky130_fd_pr__model__cap_mim
Cn8_59 BOT_n8 TOP_N 8.647288000e-15 sky130_fd_pr__model__cap_mim
Cn8_60 BOT_n8 TOP_N 8.647288000e-15 sky130_fd_pr__model__cap_mim
Cn8_61 BOT_n8 TOP_N 8.647288000e-15 sky130_fd_pr__model__cap_mim
Cn8_62 BOT_n8 TOP_N 8.647288000e-15 sky130_fd_pr__model__cap_mim
Cn8_63 BOT_n8 TOP_N 8.647288000e-15 sky130_fd_pr__model__cap_mim
Cn8_64 BOT_n8 TOP_N 8.647288000e-15 sky130_fd_pr__model__cap_mim
Cn8_65 BOT_n8 TOP_N 8.647288000e-15 sky130_fd_pr__model__cap_mim
Cn8_66 BOT_n8 TOP_N 8.647288000e-15 sky130_fd_pr__model__cap_mim
Cn8_67 BOT_n8 TOP_N 8.647288000e-15 sky130_fd_pr__model__cap_mim
Cn8_68 BOT_n8 TOP_N 8.647288000e-15 sky130_fd_pr__model__cap_mim
Cn8_69 BOT_n8 TOP_N 8.647288000e-15 sky130_fd_pr__model__cap_mim
Cn8_70 BOT_n8 TOP_N 8.647288000e-15 sky130_fd_pr__model__cap_mim
Cn8_71 BOT_n8 TOP_N 8.647288000e-15 sky130_fd_pr__model__cap_mim
Cn8_72 BOT_n8 TOP_N 8.647288000e-15 sky130_fd_pr__model__cap_mim
Cn8_73 BOT_n8 TOP_N 8.647288000e-15 sky130_fd_pr__model__cap_mim
Cn8_74 BOT_n8 TOP_N 8.647288000e-15 sky130_fd_pr__model__cap_mim
Cn8_75 BOT_n8 TOP_N 8.647288000e-15 sky130_fd_pr__model__cap_mim
Cn8_76 BOT_n8 TOP_N 8.647288000e-15 sky130_fd_pr__model__cap_mim
Cn8_77 BOT_n8 TOP_N 8.647288000e-15 sky130_fd_pr__model__cap_mim
Cn8_78 BOT_n8 TOP_N 8.647288000e-15 sky130_fd_pr__model__cap_mim
Cn8_79 BOT_n8 TOP_N 8.647288000e-15 sky130_fd_pr__model__cap_mim
Cn8_80 BOT_n8 TOP_N 8.647288000e-15 sky130_fd_pr__model__cap_mim
Cn8_81 BOT_n8 TOP_N 8.647288000e-15 sky130_fd_pr__model__cap_mim
Cn8_82 BOT_n8 TOP_N 8.647288000e-15 sky130_fd_pr__model__cap_mim
Cn8_83 BOT_n8 TOP_N 8.647288000e-15 sky130_fd_pr__model__cap_mim
Cn8_84 BOT_n8 TOP_N 8.647288000e-15 sky130_fd_pr__model__cap_mim
Cn8_85 BOT_n8 TOP_N 8.647288000e-15 sky130_fd_pr__model__cap_mim
Cn8_86 BOT_n8 TOP_N 8.647288000e-15 sky130_fd_pr__model__cap_mim
Cn8_87 BOT_n8 TOP_N 8.647288000e-15 sky130_fd_pr__model__cap_mim
Cn8_88 BOT_n8 TOP_N 8.647288000e-15 sky130_fd_pr__model__cap_mim
Cn8_89 BOT_n8 TOP_N 8.647288000e-15 sky130_fd_pr__model__cap_mim
Cn8_90 BOT_n8 TOP_N 8.647288000e-15 sky130_fd_pr__model__cap_mim
Cn8_91 BOT_n8 TOP_N 8.647288000e-15 sky130_fd_pr__model__cap_mim
Cn8_92 BOT_n8 TOP_N 8.647288000e-15 sky130_fd_pr__model__cap_mim
Cn8_93 BOT_n8 TOP_N 8.647288000e-15 sky130_fd_pr__model__cap_mim
Cn8_94 BOT_n8 TOP_N 8.647288000e-15 sky130_fd_pr__model__cap_mim
Cn8_95 BOT_n8 TOP_N 8.647288000e-15 sky130_fd_pr__model__cap_mim
Cn8_96 BOT_n8 TOP_N 8.647288000e-15 sky130_fd_pr__model__cap_mim
Cn8_97 BOT_n8 TOP_N 8.647288000e-15 sky130_fd_pr__model__cap_mim
Cn8_98 BOT_n8 TOP_N 8.647288000e-15 sky130_fd_pr__model__cap_mim
Cn8_99 BOT_n8 TOP_N 8.647288000e-15 sky130_fd_pr__model__cap_mim
Cn8_100 BOT_n8 TOP_N 8.647288000e-15 sky130_fd_pr__model__cap_mim
Cn8_101 BOT_n8 TOP_N 8.647288000e-15 sky130_fd_pr__model__cap_mim
Cn8_102 BOT_n8 TOP_N 8.647288000e-15 sky130_fd_pr__model__cap_mim
Cn8_103 BOT_n8 TOP_N 8.647288000e-15 sky130_fd_pr__model__cap_mim
Cn8_104 BOT_n8 TOP_N 8.647288000e-15 sky130_fd_pr__model__cap_mim
Cn8_105 BOT_n8 TOP_N 8.647288000e-15 sky130_fd_pr__model__cap_mim
Cn8_106 BOT_n8 TOP_N 8.647288000e-15 sky130_fd_pr__model__cap_mim
Cn8_107 BOT_n8 TOP_N 8.647288000e-15 sky130_fd_pr__model__cap_mim
Cn8_108 BOT_n8 TOP_N 8.647288000e-15 sky130_fd_pr__model__cap_mim
Cn8_109 BOT_n8 TOP_N 8.647288000e-15 sky130_fd_pr__model__cap_mim
Cn8_110 BOT_n8 TOP_N 8.647288000e-15 sky130_fd_pr__model__cap_mim
Cn8_111 BOT_n8 TOP_N 8.647288000e-15 sky130_fd_pr__model__cap_mim
Cn8_112 BOT_n8 TOP_N 8.647288000e-15 sky130_fd_pr__model__cap_mim
Cn8_113 BOT_n8 TOP_N 8.647288000e-15 sky130_fd_pr__model__cap_mim
Cn8_114 BOT_n8 TOP_N 8.647288000e-15 sky130_fd_pr__model__cap_mim
Cn8_115 BOT_n8 TOP_N 8.647288000e-15 sky130_fd_pr__model__cap_mim
Cn8_116 BOT_n8 TOP_N 8.647288000e-15 sky130_fd_pr__model__cap_mim
Cn8_117 BOT_n8 TOP_N 8.647288000e-15 sky130_fd_pr__model__cap_mim
Cn8_118 BOT_n8 TOP_N 8.647288000e-15 sky130_fd_pr__model__cap_mim
Cn8_119 BOT_n8 TOP_N 8.647288000e-15 sky130_fd_pr__model__cap_mim
Cn8_120 BOT_n8 TOP_N 8.647288000e-15 sky130_fd_pr__model__cap_mim
Cn8_121 BOT_n8 TOP_N 8.647288000e-15 sky130_fd_pr__model__cap_mim
Cn8_122 BOT_n8 TOP_N 8.647288000e-15 sky130_fd_pr__model__cap_mim
Cn8_123 BOT_n8 TOP_N 8.647288000e-15 sky130_fd_pr__model__cap_mim
Cn8_124 BOT_n8 TOP_N 8.647288000e-15 sky130_fd_pr__model__cap_mim
Cn8_125 BOT_n8 TOP_N 8.647288000e-15 sky130_fd_pr__model__cap_mim
Cn8_126 BOT_n8 TOP_N 8.647288000e-15 sky130_fd_pr__model__cap_mim
Cn8_127 BOT_n8 TOP_N 8.647288000e-15 sky130_fd_pr__model__cap_mim
Cn8_128 BOT_n8 TOP_N 8.647288000e-15 sky130_fd_pr__model__cap_mim
Cn8_129 BOT_n8 TOP_N 8.647288000e-15 sky130_fd_pr__model__cap_mim
Cn8_130 BOT_n8 TOP_N 8.647288000e-15 sky130_fd_pr__model__cap_mim
Cn8_131 BOT_n8 TOP_N 8.647288000e-15 sky130_fd_pr__model__cap_mim
Cn8_132 BOT_n8 TOP_N 8.647288000e-15 sky130_fd_pr__model__cap_mim
Cn8_133 BOT_n8 TOP_N 8.647288000e-15 sky130_fd_pr__model__cap_mim
Cn8_134 BOT_n8 TOP_N 8.647288000e-15 sky130_fd_pr__model__cap_mim
Cn8_135 BOT_n8 TOP_N 8.647288000e-15 sky130_fd_pr__model__cap_mim
Cn8_136 BOT_n8 TOP_N 8.647288000e-15 sky130_fd_pr__model__cap_mim
Cn8_137 BOT_n8 TOP_N 8.647288000e-15 sky130_fd_pr__model__cap_mim
Cn8_138 BOT_n8 TOP_N 8.647288000e-15 sky130_fd_pr__model__cap_mim
Cn8_139 BOT_n8 TOP_N 8.647288000e-15 sky130_fd_pr__model__cap_mim
Cn8_140 BOT_n8 TOP_N 8.647288000e-15 sky130_fd_pr__model__cap_mim
Cn8_141 BOT_n8 TOP_N 8.647288000e-15 sky130_fd_pr__model__cap_mim
Cn8_142 BOT_n8 TOP_N 8.647288000e-15 sky130_fd_pr__model__cap_mim
Cn8_143 BOT_n8 TOP_N 8.647288000e-15 sky130_fd_pr__model__cap_mim
Cn8_144 BOT_n8 TOP_N 8.647288000e-15 sky130_fd_pr__model__cap_mim
Cn8_145 BOT_n8 TOP_N 8.647288000e-15 sky130_fd_pr__model__cap_mim
Cn8_146 BOT_n8 TOP_N 8.647288000e-15 sky130_fd_pr__model__cap_mim
Cn8_147 BOT_n8 TOP_N 8.647288000e-15 sky130_fd_pr__model__cap_mim
Cn8_148 BOT_n8 TOP_N 8.647288000e-15 sky130_fd_pr__model__cap_mim
Cn8_149 BOT_n8 TOP_N 8.647288000e-15 sky130_fd_pr__model__cap_mim
Cn8_150 BOT_n8 TOP_N 8.647288000e-15 sky130_fd_pr__model__cap_mim
Cn8_151 BOT_n8 TOP_N 8.647288000e-15 sky130_fd_pr__model__cap_mim
Cn8_152 BOT_n8 TOP_N 8.647288000e-15 sky130_fd_pr__model__cap_mim
Cn8_153 BOT_n8 TOP_N 8.647288000e-15 sky130_fd_pr__model__cap_mim
Cn8_154 BOT_n8 TOP_N 8.647288000e-15 sky130_fd_pr__model__cap_mim
Cn8_155 BOT_n8 TOP_N 8.647288000e-15 sky130_fd_pr__model__cap_mim
Cn8_156 BOT_n8 TOP_N 8.647288000e-15 sky130_fd_pr__model__cap_mim
Cn8_157 BOT_n8 TOP_N 8.647288000e-15 sky130_fd_pr__model__cap_mim
Cn8_158 BOT_n8 TOP_N 8.647288000e-15 sky130_fd_pr__model__cap_mim
Cn8_159 BOT_n8 TOP_N 8.647288000e-15 sky130_fd_pr__model__cap_mim
Cn8_160 BOT_n8 TOP_N 8.647288000e-15 sky130_fd_pr__model__cap_mim
Cn8_161 BOT_n8 TOP_N 8.647288000e-15 sky130_fd_pr__model__cap_mim
Cn8_162 BOT_n8 TOP_N 8.647288000e-15 sky130_fd_pr__model__cap_mim
Cn8_163 BOT_n8 TOP_N 8.647288000e-15 sky130_fd_pr__model__cap_mim
Cn8_164 BOT_n8 TOP_N 8.647288000e-15 sky130_fd_pr__model__cap_mim
Cn8_165 BOT_n8 TOP_N 8.647288000e-15 sky130_fd_pr__model__cap_mim
Cn8_166 BOT_n8 TOP_N 8.647288000e-15 sky130_fd_pr__model__cap_mim
Cn8_167 BOT_n8 TOP_N 8.647288000e-15 sky130_fd_pr__model__cap_mim
Cn8_168 BOT_n8 TOP_N 8.647288000e-15 sky130_fd_pr__model__cap_mim
Cn8_169 BOT_n8 TOP_N 8.647288000e-15 sky130_fd_pr__model__cap_mim
Cn8_170 BOT_n8 TOP_N 8.647288000e-15 sky130_fd_pr__model__cap_mim
Cn8_171 BOT_n8 TOP_N 8.647288000e-15 sky130_fd_pr__model__cap_mim
Cn8_172 BOT_n8 TOP_N 8.647288000e-15 sky130_fd_pr__model__cap_mim
Cn8_173 BOT_n8 TOP_N 8.647288000e-15 sky130_fd_pr__model__cap_mim
Cn8_174 BOT_n8 TOP_N 8.647288000e-15 sky130_fd_pr__model__cap_mim
Cn8_175 BOT_n8 TOP_N 8.647288000e-15 sky130_fd_pr__model__cap_mim
Cn8_176 BOT_n8 TOP_N 8.647288000e-15 sky130_fd_pr__model__cap_mim
Cn8_177 BOT_n8 TOP_N 8.647288000e-15 sky130_fd_pr__model__cap_mim
Cn8_178 BOT_n8 TOP_N 8.647288000e-15 sky130_fd_pr__model__cap_mim
Cn8_179 BOT_n8 TOP_N 8.647288000e-15 sky130_fd_pr__model__cap_mim
Cn8_180 BOT_n8 TOP_N 8.647288000e-15 sky130_fd_pr__model__cap_mim
Cn8_181 BOT_n8 TOP_N 8.647288000e-15 sky130_fd_pr__model__cap_mim
Cn8_182 BOT_n8 TOP_N 8.647288000e-15 sky130_fd_pr__model__cap_mim
Cn8_183 BOT_n8 TOP_N 8.647288000e-15 sky130_fd_pr__model__cap_mim
Cn8_184 BOT_n8 TOP_N 8.647288000e-15 sky130_fd_pr__model__cap_mim
Cn8_185 BOT_n8 TOP_N 8.647288000e-15 sky130_fd_pr__model__cap_mim
Cn8_186 BOT_n8 TOP_N 8.647288000e-15 sky130_fd_pr__model__cap_mim
Cn8_187 BOT_n8 TOP_N 8.647288000e-15 sky130_fd_pr__model__cap_mim
Cn8_188 BOT_n8 TOP_N 8.647288000e-15 sky130_fd_pr__model__cap_mim
Cn8_189 BOT_n8 TOP_N 8.647288000e-15 sky130_fd_pr__model__cap_mim
Cn8_190 BOT_n8 TOP_N 8.647288000e-15 sky130_fd_pr__model__cap_mim
Cn8_191 BOT_n8 TOP_N 8.647288000e-15 sky130_fd_pr__model__cap_mim
Cn8_192 BOT_n8 TOP_N 8.647288000e-15 sky130_fd_pr__model__cap_mim
Cn8_193 BOT_n8 TOP_N 8.647288000e-15 sky130_fd_pr__model__cap_mim
Cn8_194 BOT_n8 TOP_N 8.647288000e-15 sky130_fd_pr__model__cap_mim
Cn8_195 BOT_n8 TOP_N 8.647288000e-15 sky130_fd_pr__model__cap_mim
Cn8_196 BOT_n8 TOP_N 8.647288000e-15 sky130_fd_pr__model__cap_mim
Cn8_197 BOT_n8 TOP_N 8.647288000e-15 sky130_fd_pr__model__cap_mim
Cn8_198 BOT_n8 TOP_N 8.647288000e-15 sky130_fd_pr__model__cap_mim
Cn8_199 BOT_n8 TOP_N 8.647288000e-15 sky130_fd_pr__model__cap_mim
Cn8_200 BOT_n8 TOP_N 8.647288000e-15 sky130_fd_pr__model__cap_mim
Cn8_201 BOT_n8 TOP_N 8.647288000e-15 sky130_fd_pr__model__cap_mim
Cn8_202 BOT_n8 TOP_N 8.647288000e-15 sky130_fd_pr__model__cap_mim
Cn8_203 BOT_n8 TOP_N 8.647288000e-15 sky130_fd_pr__model__cap_mim
Cn8_204 BOT_n8 TOP_N 8.647288000e-15 sky130_fd_pr__model__cap_mim
Cn8_205 BOT_n8 TOP_N 8.647288000e-15 sky130_fd_pr__model__cap_mim
Cn8_206 BOT_n8 TOP_N 8.647288000e-15 sky130_fd_pr__model__cap_mim
Cn8_207 BOT_n8 TOP_N 8.647288000e-15 sky130_fd_pr__model__cap_mim
Cn8_208 BOT_n8 TOP_N 8.647288000e-15 sky130_fd_pr__model__cap_mim
Cn8_209 BOT_n8 TOP_N 8.647288000e-15 sky130_fd_pr__model__cap_mim
Cn8_210 BOT_n8 TOP_N 8.647288000e-15 sky130_fd_pr__model__cap_mim
Cn8_211 BOT_n8 TOP_N 8.647288000e-15 sky130_fd_pr__model__cap_mim
Cn8_212 BOT_n8 TOP_N 8.647288000e-15 sky130_fd_pr__model__cap_mim
Cn8_213 BOT_n8 TOP_N 8.647288000e-15 sky130_fd_pr__model__cap_mim
Cn8_214 BOT_n8 TOP_N 8.647288000e-15 sky130_fd_pr__model__cap_mim
Cn8_215 BOT_n8 TOP_N 8.647288000e-15 sky130_fd_pr__model__cap_mim
Cn8_216 BOT_n8 TOP_N 8.647288000e-15 sky130_fd_pr__model__cap_mim
Cn8_217 BOT_n8 TOP_N 8.647288000e-15 sky130_fd_pr__model__cap_mim
Cn8_218 BOT_n8 TOP_N 8.647288000e-15 sky130_fd_pr__model__cap_mim
Cn8_219 BOT_n8 TOP_N 8.647288000e-15 sky130_fd_pr__model__cap_mim
Cn8_220 BOT_n8 TOP_N 8.647288000e-15 sky130_fd_pr__model__cap_mim
Cn8_221 BOT_n8 TOP_N 8.647288000e-15 sky130_fd_pr__model__cap_mim
Cn8_222 BOT_n8 TOP_N 8.647288000e-15 sky130_fd_pr__model__cap_mim
Cn8_223 BOT_n8 TOP_N 8.647288000e-15 sky130_fd_pr__model__cap_mim
Cn8_224 BOT_n8 TOP_N 8.647288000e-15 sky130_fd_pr__model__cap_mim
Cn8_225 BOT_n8 TOP_N 8.647288000e-15 sky130_fd_pr__model__cap_mim
Cn8_226 BOT_n8 TOP_N 8.647288000e-15 sky130_fd_pr__model__cap_mim
Cn8_227 BOT_n8 TOP_N 8.647288000e-15 sky130_fd_pr__model__cap_mim
Cn8_228 BOT_n8 TOP_N 8.647288000e-15 sky130_fd_pr__model__cap_mim
Cn8_229 BOT_n8 TOP_N 8.647288000e-15 sky130_fd_pr__model__cap_mim
Cn8_230 BOT_n8 TOP_N 8.647288000e-15 sky130_fd_pr__model__cap_mim
Cn8_231 BOT_n8 TOP_N 8.647288000e-15 sky130_fd_pr__model__cap_mim
Cn8_232 BOT_n8 TOP_N 8.647288000e-15 sky130_fd_pr__model__cap_mim
Cn8_233 BOT_n8 TOP_N 8.647288000e-15 sky130_fd_pr__model__cap_mim
Cn8_234 BOT_n8 TOP_N 8.647288000e-15 sky130_fd_pr__model__cap_mim
Cn8_235 BOT_n8 TOP_N 8.647288000e-15 sky130_fd_pr__model__cap_mim
Cn8_236 BOT_n8 TOP_N 8.647288000e-15 sky130_fd_pr__model__cap_mim
Cn8_237 BOT_n8 TOP_N 8.647288000e-15 sky130_fd_pr__model__cap_mim
Cn8_238 BOT_n8 TOP_N 8.647288000e-15 sky130_fd_pr__model__cap_mim
Cn8_239 BOT_n8 TOP_N 8.647288000e-15 sky130_fd_pr__model__cap_mim
Cn8_240 BOT_n8 TOP_N 8.647288000e-15 sky130_fd_pr__model__cap_mim
Cn8_241 BOT_n8 TOP_N 8.647288000e-15 sky130_fd_pr__model__cap_mim
Cn8_242 BOT_n8 TOP_N 8.647288000e-15 sky130_fd_pr__model__cap_mim
Cn8_243 BOT_n8 TOP_N 8.647288000e-15 sky130_fd_pr__model__cap_mim
Cn8_244 BOT_n8 TOP_N 8.647288000e-15 sky130_fd_pr__model__cap_mim
Cn8_245 BOT_n8 TOP_N 8.647288000e-15 sky130_fd_pr__model__cap_mim
Cn8_246 BOT_n8 TOP_N 8.647288000e-15 sky130_fd_pr__model__cap_mim
Cn8_247 BOT_n8 TOP_N 8.647288000e-15 sky130_fd_pr__model__cap_mim
Cn8_248 BOT_n8 TOP_N 8.647288000e-15 sky130_fd_pr__model__cap_mim
Cn8_249 BOT_n8 TOP_N 8.647288000e-15 sky130_fd_pr__model__cap_mim
Cn8_250 BOT_n8 TOP_N 8.647288000e-15 sky130_fd_pr__model__cap_mim
Cn8_251 BOT_n8 TOP_N 8.647288000e-15 sky130_fd_pr__model__cap_mim
Cn8_252 BOT_n8 TOP_N 8.647288000e-15 sky130_fd_pr__model__cap_mim
Cn8_253 BOT_n8 TOP_N 8.647288000e-15 sky130_fd_pr__model__cap_mim
Cn8_254 BOT_n8 TOP_N 8.647288000e-15 sky130_fd_pr__model__cap_mim
Cn8_255 BOT_n8 TOP_N 8.647288000e-15 sky130_fd_pr__model__cap_mim
Mn8n BOT_n8 SELn8 VREFN vsubs nfet L=0.15U W=1U
Mn8p BOT_n8 SELn8 VREFP VDD pfet L=0.15U W=2U
Cn_term VREFN TOP_N 8.647288000e-15 sky130_fd_pr__model__cap_mim
.ENDS cdac_array
