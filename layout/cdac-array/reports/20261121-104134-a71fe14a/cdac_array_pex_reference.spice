* cdac_array_pex_reference.spice -- schematic-equivalent DUT for this
* `klt pex` run (issue #1017), GENERATED by run_pex.py: the per-bit
* device pattern of sim/cdac-array-transfer/testbench/
* tb_cdac_array_transfer.spice (issue #53), wrapped in the extracted
* netlist's own .SUBCKT name and pin order (asserted equal to
* testbench.spice's hardcoded list before this file was written).
.SUBCKT cdac_array SELn0 SELn1 SELn2 SELn3 SELn4 SELn5 SELn6 SELn7 SELn8 SELp0 SELp1 SELp2 SELp3 SELp4 SELp5 SELp6 SELp7 SELp8 TOP_N TOP_P VDD VREFN VREFP VSS
* ---- p side: 9 weighted positions + termination cap ----
Xc_p0 BOT_p0 TOP_P sky130_fd_pr__cap_mim_m3_1 W=1.9000 L=1.9000 MF=1 m=1
Xn_p0 BOT_p0 SELp0 VREFN VSS sky130_fd_pr__nfet_01v8 L=0.15 W=1 nf=1
Xp_p0 BOT_p0 SELp0 VREFP VDD sky130_fd_pr__pfet_01v8 L=0.15 W=2 nf=1
Xc_p1 BOT_p1 TOP_P sky130_fd_pr__cap_mim_m3_1 W=1.9000 L=1.9000 MF=2 m=2
Xn_p1 BOT_p1 SELp1 VREFN VSS sky130_fd_pr__nfet_01v8 L=0.15 W=1 nf=1
Xp_p1 BOT_p1 SELp1 VREFP VDD sky130_fd_pr__pfet_01v8 L=0.15 W=2 nf=1
Xc_p2 BOT_p2 TOP_P sky130_fd_pr__cap_mim_m3_1 W=1.9000 L=1.9000 MF=4 m=4
Xn_p2 BOT_p2 SELp2 VREFN VSS sky130_fd_pr__nfet_01v8 L=0.15 W=1 nf=1
Xp_p2 BOT_p2 SELp2 VREFP VDD sky130_fd_pr__pfet_01v8 L=0.15 W=2 nf=1
Xc_p3 BOT_p3 TOP_P sky130_fd_pr__cap_mim_m3_1 W=1.9000 L=1.9000 MF=8 m=8
Xn_p3 BOT_p3 SELp3 VREFN VSS sky130_fd_pr__nfet_01v8 L=0.15 W=1 nf=1
Xp_p3 BOT_p3 SELp3 VREFP VDD sky130_fd_pr__pfet_01v8 L=0.15 W=2 nf=1
Xc_p4 BOT_p4 TOP_P sky130_fd_pr__cap_mim_m3_1 W=1.9000 L=1.9000 MF=16 m=16
Xn_p4 BOT_p4 SELp4 VREFN VSS sky130_fd_pr__nfet_01v8 L=0.15 W=1 nf=1
Xp_p4 BOT_p4 SELp4 VREFP VDD sky130_fd_pr__pfet_01v8 L=0.15 W=2 nf=1
Xc_p5 BOT_p5 TOP_P sky130_fd_pr__cap_mim_m3_1 W=1.9000 L=1.9000 MF=32 m=32
Xn_p5 BOT_p5 SELp5 VREFN VSS sky130_fd_pr__nfet_01v8 L=0.15 W=1 nf=1
Xp_p5 BOT_p5 SELp5 VREFP VDD sky130_fd_pr__pfet_01v8 L=0.15 W=2 nf=1
Xc_p6 BOT_p6 TOP_P sky130_fd_pr__cap_mim_m3_1 W=1.9000 L=1.9000 MF=64 m=64
Xn_p6 BOT_p6 SELp6 VREFN VSS sky130_fd_pr__nfet_01v8 L=0.15 W=1 nf=1
Xp_p6 BOT_p6 SELp6 VREFP VDD sky130_fd_pr__pfet_01v8 L=0.15 W=2 nf=1
Xc_p7 BOT_p7 TOP_P sky130_fd_pr__cap_mim_m3_1 W=1.9000 L=1.9000 MF=128 m=128
Xn_p7 BOT_p7 SELp7 VREFN VSS sky130_fd_pr__nfet_01v8 L=0.15 W=1 nf=1
Xp_p7 BOT_p7 SELp7 VREFP VDD sky130_fd_pr__pfet_01v8 L=0.15 W=2 nf=1
Xc_p8 BOT_p8 TOP_P sky130_fd_pr__cap_mim_m3_1 W=1.9000 L=1.9000 MF=256 m=256
Xn_p8 BOT_p8 SELp8 VREFN VSS sky130_fd_pr__nfet_01v8 L=0.15 W=1 nf=1
Xp_p8 BOT_p8 SELp8 VREFP VDD sky130_fd_pr__pfet_01v8 L=0.15 W=2 nf=1
Xterm_p VREFN TOP_P sky130_fd_pr__cap_mim_m3_1 W=1.9000 L=1.9000 MF=1 m=1
* ---- n side: 9 weighted positions + termination cap ----
Xc_n0 BOT_n0 TOP_N sky130_fd_pr__cap_mim_m3_1 W=1.9000 L=1.9000 MF=1 m=1
Xn_n0 BOT_n0 SELn0 VREFN VSS sky130_fd_pr__nfet_01v8 L=0.15 W=1 nf=1
Xp_n0 BOT_n0 SELn0 VREFP VDD sky130_fd_pr__pfet_01v8 L=0.15 W=2 nf=1
Xc_n1 BOT_n1 TOP_N sky130_fd_pr__cap_mim_m3_1 W=1.9000 L=1.9000 MF=2 m=2
Xn_n1 BOT_n1 SELn1 VREFN VSS sky130_fd_pr__nfet_01v8 L=0.15 W=1 nf=1
Xp_n1 BOT_n1 SELn1 VREFP VDD sky130_fd_pr__pfet_01v8 L=0.15 W=2 nf=1
Xc_n2 BOT_n2 TOP_N sky130_fd_pr__cap_mim_m3_1 W=1.9000 L=1.9000 MF=4 m=4
Xn_n2 BOT_n2 SELn2 VREFN VSS sky130_fd_pr__nfet_01v8 L=0.15 W=1 nf=1
Xp_n2 BOT_n2 SELn2 VREFP VDD sky130_fd_pr__pfet_01v8 L=0.15 W=2 nf=1
Xc_n3 BOT_n3 TOP_N sky130_fd_pr__cap_mim_m3_1 W=1.9000 L=1.9000 MF=8 m=8
Xn_n3 BOT_n3 SELn3 VREFN VSS sky130_fd_pr__nfet_01v8 L=0.15 W=1 nf=1
Xp_n3 BOT_n3 SELn3 VREFP VDD sky130_fd_pr__pfet_01v8 L=0.15 W=2 nf=1
Xc_n4 BOT_n4 TOP_N sky130_fd_pr__cap_mim_m3_1 W=1.9000 L=1.9000 MF=16 m=16
Xn_n4 BOT_n4 SELn4 VREFN VSS sky130_fd_pr__nfet_01v8 L=0.15 W=1 nf=1
Xp_n4 BOT_n4 SELn4 VREFP VDD sky130_fd_pr__pfet_01v8 L=0.15 W=2 nf=1
Xc_n5 BOT_n5 TOP_N sky130_fd_pr__cap_mim_m3_1 W=1.9000 L=1.9000 MF=32 m=32
Xn_n5 BOT_n5 SELn5 VREFN VSS sky130_fd_pr__nfet_01v8 L=0.15 W=1 nf=1
Xp_n5 BOT_n5 SELn5 VREFP VDD sky130_fd_pr__pfet_01v8 L=0.15 W=2 nf=1
Xc_n6 BOT_n6 TOP_N sky130_fd_pr__cap_mim_m3_1 W=1.9000 L=1.9000 MF=64 m=64
Xn_n6 BOT_n6 SELn6 VREFN VSS sky130_fd_pr__nfet_01v8 L=0.15 W=1 nf=1
Xp_n6 BOT_n6 SELn6 VREFP VDD sky130_fd_pr__pfet_01v8 L=0.15 W=2 nf=1
Xc_n7 BOT_n7 TOP_N sky130_fd_pr__cap_mim_m3_1 W=1.9000 L=1.9000 MF=128 m=128
Xn_n7 BOT_n7 SELn7 VREFN VSS sky130_fd_pr__nfet_01v8 L=0.15 W=1 nf=1
Xp_n7 BOT_n7 SELn7 VREFP VDD sky130_fd_pr__pfet_01v8 L=0.15 W=2 nf=1
Xc_n8 BOT_n8 TOP_N sky130_fd_pr__cap_mim_m3_1 W=1.9000 L=1.9000 MF=256 m=256
Xn_n8 BOT_n8 SELn8 VREFN VSS sky130_fd_pr__nfet_01v8 L=0.15 W=1 nf=1
Xp_n8 BOT_n8 SELn8 VREFP VDD sky130_fd_pr__pfet_01v8 L=0.15 W=2 nf=1
Xterm_n VREFN TOP_N sky130_fd_pr__cap_mim_m3_1 W=1.9000 L=1.9000 MF=1 m=1
.ENDS cdac_array
