* extracted by klt extract --deck sky130

* cell gen_compose_0
* pin BOOST_N
* pin BOOST_P
* pin BPREF_N
* pin BPREF_P
* pin BSBOT_N
* pin BSBOT_P
* pin G_N
* pin G_P
* pin SAMPLE
* pin SAMPLEB
* pin VCM
* pin VDD
* pin VINN
* pin VINP
.SUBCKT gen_compose_0 BOOST_N BOOST_P BPREF_N BPREF_P BSBOT_N BSBOT_P G_N G_P
+ SAMPLE SAMPLEB VCM VDD VINN VINP
* device instance $1 r0 *1 2.67,0.5 pfet
M$1 BOOST_P SAMPLE VDD BOOST_P pfet L=0.5U W=1U AS=0.42P AD=0.42P PS=2.84U
+ PD=2.84U
* device instance $2 r0 *1 5.745,0.5 pfet
M$2 G_P SAMPLEB BOOST_P BOOST_P pfet L=0.15U W=1U AS=0.47P AD=0.47P PS=2.94U
+ PD=2.94U
* device instance $3 r0 *1 10.885,0.5 pfet
M$3 BSBOT_P SAMPLEB VINP VDD pfet L=0.15U W=1U AS=0.47P AD=0.47P PS=2.94U
+ PD=2.94U
* device instance $4 r0 *1 14.085,0.5 pfet
M$4 BPREF_P SAMPLEB VCM VDD pfet L=0.15U W=1U AS=0.47P AD=0.47P PS=2.94U
+ PD=2.94U
* device instance $5 r0 *1 20.485,0.5 pfet
M$5 BPREF_N SAMPLEB VCM VDD pfet L=0.15U W=1U AS=0.47P AD=0.47P PS=2.94U
+ PD=2.94U
* device instance $6 r0 *1 23.685,0.5 pfet
M$6 BSBOT_N SAMPLEB VINN VDD pfet L=0.15U W=1U AS=0.47P AD=0.47P PS=2.94U
+ PD=2.94U
* device instance $7 r0 *1 28.825,0.5 pfet
M$7 G_N SAMPLEB BOOST_N BOOST_N pfet L=0.15U W=1U AS=0.47P AD=0.47P PS=2.94U
+ PD=2.94U
* device instance $8 r0 *1 32.15,0.5 pfet
M$8 BOOST_N SAMPLE VDD BOOST_N pfet L=0.5U W=1U AS=0.42P AD=0.42P PS=2.84U
+ PD=2.84U
* device instance $9 r0 *1 17.285,1 pfet
M$9 SAMPLEB SAMPLE VDD VDD pfet L=0.15U W=2U AS=0.94P AD=0.94P PS=4.94U PD=4.94U
.ENDS gen_compose_0
