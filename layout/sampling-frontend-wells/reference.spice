* Hand-written LVS reference netlist for the sampling front end's PFET set
* and its three n-well body-tie domains (issue #122), against which
* layout/sampling-frontend-wells/bin/run-flow.sh's composed layout is
* compared.
*
* Scope: the nine `sky130_fd_pr__pfet_01v8` instances of
* design/sampling_frontend.sch and nothing else. This is deliberately a
* slice, not the whole sub-block (that is #99): the subject of #122 is the
* n-well/body-tie structure, which only the PFETs have. Every NFET in that
* schematic ties its body to the p-substrate, which `klt extract` synthesizes
* as one shared net regardless of drawn geometry, so no NFET can participate
* in -- or falsify -- a well-isolation claim.
*
* Topology and device sizing are transcribed 1:1 from
* sim/sampling-frontend/testbench/sampling_frontend_dut.spice -- the xschem
* -derived, already-simulated device fragment for design/sampling_frontend.sch
* (issue #52) -- keeping only its `sky130_fd_pr__pfet_01v8` cards and
* generalizing them to the generic `pfet` device class `klt extract --deck
* sky130`'s curated deck reports (the same convention
* layout/comparator/reference.spice and layout/trivial-cell/reference.spice
* use, and for the same reason: the layout side can only ever report the
* generic class).
*
* THE BODY COLUMN IS THE POINT OF THIS FILE.
* In an M-card `M<name> D G S B ...` the fourth net is the body terminal. Here
* four of the nine devices declare a body that is NOT VDD:
*
*   M_SA_P / M_SE_P  -> BOOST_P
*   M_SA_N / M_SE_N  -> BOOST_N
*
* which is design/sampling_frontend.sch's DR-004 requirement, verbatim: BOOST_x
* rises above VDD during sampling, so a VDD-tied body would forward-bias these
* devices' drain/body junction once BOOST exceeds VDD by a diode drop. The
* other five PFETs (Scp_p, Cmswp_p, Invp, Cmswp_n, Scp_n) tie body to VDD
* normally.
*
* These body terminals are REAL, not aspirational: bin/build_layout.py draws
* three physically separate n-well islands and routes each island's tap to its
* own domain net, so `klt extract` resolves the body of each PMOS from the
* island it actually sits in. run-flow.sh asserts that separately from the LVS
* verdict (`unbiased_pmos_body_nets` must be empty, and the four boosted
* bodies must read BOOST_P/BOOST_N), and reference.broken-body-tie.spice is
* the negative control that proves LVS can *see* the body column at all -- an
* LVS "match" against a reference that declared the wrong body would otherwise
* be indistinguishable from one that declared the right one.
*
* Net names below match design/sampling_frontend.sch's own net names;
* `klt lvs`/`NetlistComparer` compares topology rather than net names, but the
* layout side draws the same fourteen names as met2.pin labels so the reported
* net correspondence reads directly.
*
* Provenance: pattern (generic device classes, schematic-derived topology,
* combine_devices, positive + negative controls) follows
* layout/comparator/reference.spice and layout/trivial-cell/reference.spice;
* the device list is re-derived from this repo's own
* design/sampling_frontend.sch, not copied from any sibling or external
* implementation -- clean-room, per CLAUDE.md.
.SUBCKT sampling_frontend_pwells VDD SAMPLE SAMPLEB VINP VINN VCM BOOST_P BOOST_N G_P G_N BSBOT_P BSBOT_N BPREF_P BPREF_N
M_SA_P    BOOST_P SAMPLE  VDD     BOOST_P pfet L=0.5U  W=1U
M_SE_P    G_P     SAMPLEB BOOST_P BOOST_P pfet L=0.15U W=1U
M_SCP_P   BSBOT_P SAMPLEB VINP    VDD     pfet L=0.15U W=1U
M_CMSWP_P BPREF_P SAMPLEB VCM     VDD     pfet L=0.15U W=1U
M_INVP    SAMPLEB SAMPLE  VDD     VDD     pfet L=0.15U W=2U
M_CMSWP_N BPREF_N SAMPLEB VCM     VDD     pfet L=0.15U W=1U
M_SCP_N   BSBOT_N SAMPLEB VINN    VDD     pfet L=0.15U W=1U
M_SE_N    G_N     SAMPLEB BOOST_N BOOST_N pfet L=0.15U W=1U
M_SA_N    BOOST_N SAMPLE  VDD     BOOST_N pfet L=0.5U  W=1U
.ENDS sampling_frontend_pwells
