* Hand-written LVS reference netlist for `trivial_mos_array`, the trivial
* known-good cell this flow is proven against (issue #2).
*
* Topology only, matching `klt gen mos_array`'s pinned-default output
* (rows=2, cols=2, dummy=1, flavor=nfet -- 2x2 "real" devices plus one
* dummy column on each side of each row = 8 physically drawn unit NMOS
* transistors, no well/body layer drawn): 8 independent unit NMOS devices,
* each with its own isolated source/drain/gate net (this generator draws
* no GDS pin-label text, so there is nothing to name these nets after),
* bodies tied to the single shared `vsubs` pin. `klt lvs`/`NetlistComparer`
* compares topology, not net names, so the arbitrary `d*/g*/s*` names here
* do not need to match the extracted netlist's own (also arbitrary,
* `$N`-style) net names.
*
* 8 M-cards, not 4: the pinned klt release (layout/requirements.txt,
* klayout-tools==0.2.0 from PyPI) predates the dummy-device-suppression fix
* 2AMLogic/sky130-bandgap's later layout/trivial-cell/reference.spice
* revision documents (klayout-tools#491/#494, only on that repo's git-commit
* pin, not yet in this PyPI release) -- `klt extract --deck sky130` on this
* pin reports device_count=8, dummy_devices_dropped=0 for this generator's
* default params. A dummy unit has no schematic counterpart by construction
* (per the mos_array generator's own docs), but until the running `klt`
* build can tell the difference, the topologically-correct reference for
* *this pin* is all 8 physically drawn units.
*
* Provenance: pattern (LVS reference authored against the generator's own
* documented default topology, dummy-count caveat called out explicitly)
* ported from 2AMLogic/sky130-bandgap's layout/trivial-cell/reference.spice
* (commit 1f04e8524cc2d8c2c7154773749b1b2d3be2ce64), per CLAUDE.md's
* "Harness bootstrap" instruction -- device count and header re-derived
* against this repo's own pinned klt version, not copied.
.SUBCKT trivial_mos_array vsubs
M1 d1 g1 s1 vsubs nfet L=0.28U W=0.42U
M2 d2 g2 s2 vsubs nfet L=0.28U W=0.42U
M3 d3 g3 s3 vsubs nfet L=0.28U W=0.42U
M4 d4 g4 s4 vsubs nfet L=0.28U W=0.42U
M5 d5 g5 s5 vsubs nfet L=0.28U W=0.42U
M6 d6 g6 s6 vsubs nfet L=0.28U W=0.42U
M7 d7 g7 s7 vsubs nfet L=0.28U W=0.42U
M8 d8 g8 s8 vsubs nfet L=0.28U W=0.42U
.ENDS trivial_mos_array
