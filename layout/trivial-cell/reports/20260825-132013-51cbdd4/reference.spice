* Hand-written LVS reference netlist for `trivial_mos_array`, the trivial
* known-good cell this flow is proven against (issue #2).
*
* Topology only, matching `klt gen mos_array`'s pinned-default output
* (rows=2, cols=2, dummy=1, flavor=nfet -- 2x2 "real" devices plus one
* dummy column on each side of each row): 4 independent unit NMOS devices,
* each with its own isolated source/drain/gate net (this generator draws
* no GDS pin-label text, so there is nothing to name these nets after),
* bodies tied to the single shared `vsubs` pin. `klt lvs`/`NetlistComparer`
* compares topology, not net names, so the arbitrary `d*/g*/s*` names here
* do not need to match the extracted netlist's own (also arbitrary,
* `$N`-style) net names.
*
* 4 M-cards, not 8 (issue #100 revision): layout/requirements.txt now pins
* klayout-tools==0.3.0 (bumped from 0.2.0 by issue #100, whose own LVS
* acceptance criterion needs 0.3.0's met2-met5/via2-4 connectivity and MiM
* top-plate-via extension -- see design/cdac/README.md's layout-stage notes
* and this repo's issue #100 PR description for the full derivation). 0.3.0
* ships the dummy-device-suppression fix this file's previous revision
* (8 M-cards) explicitly anticipated ("until the running `klt` build can
* tell the difference, the topologically-correct reference for *this pin*
* is all 8 physically drawn units") -- `klt extract --deck sky130` on the
* new pin reports device_count=4, dummy_devices_dropped=4 for this
* generator's default params (verified against a live re-run of this exact
* flow, `layout/bin/run-trivial-cell-flow.sh`, after the pin bump): only
* the 2x2 "real" array's own 4 unit transistors are extracted as devices,
* the two dummy columns' NMOS instances are recognised and dropped as
* dummies (`ExtractionDeck.dummy`/`--pdk sky130A`'s `(83, 20)` marker layer,
* per `klayout_tools/decks/sky130.py`'s 0.3.0 revision) rather than being
* left as ordinary, schematic-visible devices the way the 0.2.0 pin did.
*
* Provenance: pattern (LVS reference authored against the generator's own
* documented default topology, dummy-count caveat called out explicitly)
* ported from 2AMLogic/sky130-bandgap's layout/trivial-cell/reference.spice
* (commit 1f04e8524cc2d8c2c7154773749b1b2d3be2ce64), per CLAUDE.md's
* "Harness bootstrap" instruction -- device count and header re-derived
* against this repo's own pinned klt version, not copied. Revised for the
* klt 0.3.0 pin bump by issue #100 (mechanical fallout of a shared-fixture
* dependency bump, not a scope expansion of that issue's own CDAC-array
* deliverable -- see that issue's PR description).
.SUBCKT trivial_mos_array vsubs
M1 d1 g1 s1 vsubs nfet L=0.28U W=0.42U
M2 d2 g2 s2 vsubs nfet L=0.28U W=0.42U
M3 d3 g3 s3 vsubs nfet L=0.28U W=0.42U
M4 d4 g4 s4 vsubs nfet L=0.28U W=0.42U
.ENDS trivial_mos_array
