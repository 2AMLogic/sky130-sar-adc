* extracted by klt extract --deck sky130

* cell gen_compose_0
* pin A,A0,B,DOUT0,Q
* pin A,A0,B,DOUT1,Q
* pin A,A0,B,DOUT2,Q
* pin A,A0,B,DOUT3,Q
* pin A,A0,B,DOUT4,Q
* pin A,A0,B,DOUT5,Q
* pin A,A0,B,DOUT6,Q
* pin A,A0,B,DOUT7,Q
* pin A,A0,B,DOUT8,Q
* pin A,A0,B,DOUT9,Q
* pin A,B,BUSY,X
* pin A,CLK
* pin GND,VGND,VSS
* pin RESET_B,RST_B
* pin VCM
* pin VDD
* pin VINN
* pin VINP
* pin VPB,VPWR
* pin VREFN
* pin VREFP
.SUBCKT gen_compose_0 A|A0|B|DOUT0|Q A|A0|B|DOUT1|Q A|A0|B|DOUT2|Q
+ A|A0|B|DOUT3|Q A|A0|B|DOUT4|Q A|A0|B|DOUT5|Q A|A0|B|DOUT6|Q A|A0|B|DOUT7|Q
+ A|A0|B|DOUT8|Q A|A0|B|DOUT9|Q A|B|BUSY|X A|CLK GND|VGND|VSS RESET_B|RST_B VCM
+ VDD VINN VINP VPB|VPWR VREFN VREFP
* device instance $1 r0 *1 51.948,-146.835 nfet
M$1 GND|VGND|VSS A|CLK|X \$3 GND|VGND|VSS nfet L=0.15U W=0.42U AS=0.1092P
+ AD=0.0567P PS=1.36U PD=0.69U
* device instance $2 r0 *1 52.368,-146.835 nfet
M$2 \$4 \$3 GND|VGND|VSS GND|VGND|VSS nfet L=0.15U W=0.42U AS=0.0567P
+ AD=0.1092P PS=0.69U PD=1.36U
* device instance $3 r0 *1 54.118,-146.865 nfet
M$3 \$7 \$3 \$6 GND|VGND|VSS nfet L=0.15U W=0.36U AS=0.066P AD=0.0594P
+ PS=0.745U PD=0.69U
* device instance $4 r0 *1 54.598,-146.865 nfet
M$4 \$13 \$4 \$7 GND|VGND|VSS nfet L=0.15U W=0.36U AS=0.0594P AD=0.1401P
+ PS=0.69U PD=1.1U
* device instance $5 r0 *1 56.943,-146.865 nfet
M$5 \$10 \$4 \$9 GND|VGND|VSS nfet L=0.15U W=0.36U AS=0.0999P AD=0.0711P
+ PS=0.985U PD=0.755U
* device instance $6 r0 *1 57.488,-146.865 nfet
M$6 \$15 \$3 \$10 GND|VGND|VSS nfet L=0.15U W=0.36U AS=0.0711P AD=0.0669P
+ PS=0.755U PD=0.75U
* device instance $7 r0 *1 53.643,-146.835 nfet
M$7 \$6 B|D|PH_B8|Q|S GND|VGND|VSS GND|VGND|VSS nfet L=0.15U W=0.42U AS=0.2205P
+ AD=0.066P PS=1.89U PD=0.745U
* device instance $8 r0 *1 55.428,-146.835 nfet
M$8 \$14 \$9 \$13 GND|VGND|VSS nfet L=0.15U W=0.42U AS=0.1401P AD=0.0441P
+ PS=1.1U PD=0.63U
* device instance $9 r0 *1 55.788,-146.835 nfet
M$9 GND|VGND|VSS RESET_B|RST_B \$14 GND|VGND|VSS nfet L=0.15U W=0.42U
+ AS=0.0441P AD=0.1346P PS=0.63U PD=1.15U
* device instance $10 r0 *1 57.968,-146.835 nfet
M$10 GND|VGND|VSS \$11 \$15 GND|VGND|VSS nfet L=0.15U W=0.42U AS=0.0669P
+ AD=0.12495P PS=0.75U PD=1.015U
* device instance $11 r0 *1 58.713,-146.835 nfet
M$11 \$16 RESET_B|RST_B GND|VGND|VSS GND|VGND|VSS nfet L=0.15U W=0.42U
+ AS=0.12495P AD=0.06405P PS=1.015U PD=0.725U
* device instance $12 r0 *1 59.168,-146.835 nfet
M$12 \$11 \$10 \$16 GND|VGND|VSS nfet L=0.15U W=0.42U AS=0.06405P AD=0.1092P
+ PS=0.725U PD=1.36U
* device instance $13 r0 *1 56.448,-146.725 nfet
M$13 \$9 \$7 GND|VGND|VSS GND|VGND|VSS nfet L=0.15U W=0.64U AS=0.1346P
+ AD=0.0999P PS=1.15U PD=0.985U
* device instance $14 r0 *1 60.208,-146.72 nfet
M$14 C|D|PH_B7|Q|S \$11 GND|VGND|VSS GND|VGND|VSS nfet L=0.15U W=0.65U
+ AS=0.2087P AD=0.169P PS=2.02U PD=1.82U
* device instance $15 r0 *1 35.388,-142.285 nfet
M$15 GND|VGND|VSS A|CLK|X \$18 GND|VGND|VSS nfet L=0.15U W=0.42U AS=0.1092P
+ AD=0.0567P PS=1.36U PD=0.69U
* device instance $16 r0 *1 35.808,-142.285 nfet
M$16 \$19 \$18 GND|VGND|VSS GND|VGND|VSS nfet L=0.15U W=0.42U AS=0.0567P
+ AD=0.1092P PS=0.69U PD=1.36U
* device instance $17 r0 *1 37.083,-142.285 nfet
M$17 \$21 D|X GND|VGND|VSS GND|VGND|VSS nfet L=0.15U W=0.42U AS=0.2205P
+ AD=0.066P PS=1.89U PD=0.745U
* device instance $18 r0 *1 37.558,-142.255 nfet
M$18 \$22 \$18 \$21 GND|VGND|VSS nfet L=0.15U W=0.36U AS=0.066P AD=0.0594P
+ PS=0.745U PD=0.69U
* device instance $19 r0 *1 38.038,-142.255 nfet
M$19 \$22 \$19 \$38 GND|VGND|VSS nfet L=0.15U W=0.36U AS=0.1401P AD=0.0594P
+ PS=1.1U PD=0.69U
* device instance $20 r0 *1 38.868,-142.285 nfet
M$20 \$39 \$25 \$38 GND|VGND|VSS nfet L=0.15U W=0.42U AS=0.1401P AD=0.0441P
+ PS=1.1U PD=0.63U
* device instance $21 r0 *1 39.228,-142.285 nfet
M$21 \$39 RESET_B|RST_B GND|VGND|VSS GND|VGND|VSS nfet L=0.15U W=0.42U
+ AS=0.1346P AD=0.0441P PS=1.15U PD=0.63U
* device instance $22 r0 *1 39.888,-142.395 nfet
M$22 \$25 \$22 GND|VGND|VSS GND|VGND|VSS nfet L=0.15U W=0.64U AS=0.1346P
+ AD=0.0999P PS=1.15U PD=0.985U
* device instance $23 r0 *1 40.383,-142.255 nfet
M$23 \$26 \$19 \$25 GND|VGND|VSS nfet L=0.15U W=0.36U AS=0.0999P AD=0.0711P
+ PS=0.985U PD=0.755U
* device instance $24 r0 *1 40.928,-142.255 nfet
M$24 \$26 \$18 \$40 GND|VGND|VSS nfet L=0.15U W=0.36U AS=0.0669P AD=0.0711P
+ PS=0.75U PD=0.755U
* device instance $25 r0 *1 41.408,-142.285 nfet
M$25 GND|VGND|VSS \$27 \$40 GND|VGND|VSS nfet L=0.15U W=0.42U AS=0.0669P
+ AD=0.12495P PS=0.75U PD=1.015U
* device instance $26 r0 *1 42.153,-142.285 nfet
M$26 \$42 RESET_B|RST_B GND|VGND|VSS GND|VGND|VSS nfet L=0.15U W=0.42U
+ AS=0.12495P AD=0.06405P PS=1.015U PD=0.725U
* device instance $27 r0 *1 42.608,-142.285 nfet
M$27 \$27 \$26 \$42 GND|VGND|VSS nfet L=0.15U W=0.42U AS=0.06405P AD=0.1092P
+ PS=0.725U PD=1.36U
* device instance $28 r0 *1 43.648,-142.4 nfet
M$28 A|A0|B|DOUT6|Q \$27 GND|VGND|VSS GND|VGND|VSS nfet L=0.15U W=0.65U
+ AS=0.2087P AD=0.169P PS=2.02U PD=1.82U
* device instance $29 r0 *1 51.948,-142.285 nfet
M$29 GND|VGND|VSS A|CLK|X \$29 GND|VGND|VSS nfet L=0.15U W=0.42U AS=0.1092P
+ AD=0.0567P PS=1.36U PD=0.69U
* device instance $30 r0 *1 52.368,-142.285 nfet
M$30 \$30 \$29 GND|VGND|VSS GND|VGND|VSS nfet L=0.15U W=0.42U AS=0.0567P
+ AD=0.1092P PS=0.69U PD=1.36U
* device instance $31 r0 *1 53.643,-142.285 nfet
M$31 \$32 D|X$1 GND|VGND|VSS GND|VGND|VSS nfet L=0.15U W=0.42U AS=0.2205P
+ AD=0.066P PS=1.89U PD=0.745U
* device instance $32 r0 *1 54.118,-142.255 nfet
M$32 \$33 \$29 \$32 GND|VGND|VSS nfet L=0.15U W=0.36U AS=0.066P AD=0.0594P
+ PS=0.745U PD=0.69U
* device instance $33 r0 *1 54.598,-142.255 nfet
M$33 \$33 \$30 \$43 GND|VGND|VSS nfet L=0.15U W=0.36U AS=0.1401P AD=0.0594P
+ PS=1.1U PD=0.69U
* device instance $34 r0 *1 55.428,-142.285 nfet
M$34 \$44 \$35 \$43 GND|VGND|VSS nfet L=0.15U W=0.42U AS=0.1401P AD=0.0441P
+ PS=1.1U PD=0.63U
* device instance $35 r0 *1 55.788,-142.285 nfet
M$35 \$44 RESET_B|RST_B GND|VGND|VSS GND|VGND|VSS nfet L=0.15U W=0.42U
+ AS=0.1346P AD=0.0441P PS=1.15U PD=0.63U
* device instance $36 r0 *1 56.448,-142.395 nfet
M$36 \$35 \$33 GND|VGND|VSS GND|VGND|VSS nfet L=0.15U W=0.64U AS=0.1346P
+ AD=0.0999P PS=1.15U PD=0.985U
* device instance $37 r0 *1 56.943,-142.255 nfet
M$37 \$36 \$30 \$35 GND|VGND|VSS nfet L=0.15U W=0.36U AS=0.0999P AD=0.0711P
+ PS=0.985U PD=0.755U
* device instance $38 r0 *1 57.488,-142.255 nfet
M$38 \$36 \$29 \$46 GND|VGND|VSS nfet L=0.15U W=0.36U AS=0.0669P AD=0.0711P
+ PS=0.75U PD=0.755U
* device instance $39 r0 *1 57.968,-142.285 nfet
M$39 GND|VGND|VSS \$37 \$46 GND|VGND|VSS nfet L=0.15U W=0.42U AS=0.0669P
+ AD=0.12495P PS=0.75U PD=1.015U
* device instance $40 r0 *1 58.713,-142.285 nfet
M$40 \$47 RESET_B|RST_B GND|VGND|VSS GND|VGND|VSS nfet L=0.15U W=0.42U
+ AS=0.12495P AD=0.06405P PS=1.015U PD=0.725U
* device instance $41 r0 *1 59.168,-142.285 nfet
M$41 \$37 \$36 \$47 GND|VGND|VSS nfet L=0.15U W=0.42U AS=0.06405P AD=0.1092P
+ PS=0.725U PD=1.36U
* device instance $42 r0 *1 60.208,-142.4 nfet
M$42 A|A0|B|DOUT8|Q \$37 GND|VGND|VSS GND|VGND|VSS nfet L=0.15U W=0.65U
+ AS=0.2087P AD=0.169P PS=2.02U PD=1.82U
* device instance $43 r0 *1 28.488,-141.395 nfet
M$43 GND|VGND|VSS A|CLK|X \$48 GND|VGND|VSS nfet L=0.15U W=0.42U AS=0.1092P
+ AD=0.0567P PS=1.36U PD=0.69U
* device instance $44 r0 *1 28.908,-141.395 nfet
M$44 \$49 \$48 GND|VGND|VSS GND|VGND|VSS nfet L=0.15U W=0.42U AS=0.0567P
+ AD=0.1092P PS=0.69U PD=1.36U
* device instance $45 r0 *1 30.658,-141.425 nfet
M$45 \$52 \$48 \$51 GND|VGND|VSS nfet L=0.15U W=0.36U AS=0.066P AD=0.0594P
+ PS=0.745U PD=0.69U
* device instance $46 r0 *1 31.138,-141.425 nfet
M$46 \$67 \$49 \$52 GND|VGND|VSS nfet L=0.15U W=0.36U AS=0.0594P AD=0.1401P
+ PS=0.69U PD=1.1U
* device instance $47 r0 *1 33.483,-141.425 nfet
M$47 \$55 \$49 \$54 GND|VGND|VSS nfet L=0.15U W=0.36U AS=0.0999P AD=0.0711P
+ PS=0.985U PD=0.755U
* device instance $48 r0 *1 34.028,-141.425 nfet
M$48 \$69 \$48 \$55 GND|VGND|VSS nfet L=0.15U W=0.36U AS=0.0711P AD=0.0669P
+ PS=0.755U PD=0.75U
* device instance $49 r0 *1 30.183,-141.395 nfet
M$49 \$51 D|X$2 GND|VGND|VSS GND|VGND|VSS nfet L=0.15U W=0.42U AS=0.2205P
+ AD=0.066P PS=1.89U PD=0.745U
* device instance $50 r0 *1 31.968,-141.395 nfet
M$50 \$68 \$54 \$67 GND|VGND|VSS nfet L=0.15U W=0.42U AS=0.1401P AD=0.0441P
+ PS=1.1U PD=0.63U
* device instance $51 r0 *1 32.328,-141.395 nfet
M$51 GND|VGND|VSS RESET_B|RST_B \$68 GND|VGND|VSS nfet L=0.15U W=0.42U
+ AS=0.0441P AD=0.1346P PS=0.63U PD=1.15U
* device instance $52 r0 *1 34.508,-141.395 nfet
M$52 GND|VGND|VSS \$56 \$69 GND|VGND|VSS nfet L=0.15U W=0.42U AS=0.0669P
+ AD=0.12495P PS=0.75U PD=1.015U
* device instance $53 r0 *1 35.253,-141.395 nfet
M$53 \$70 RESET_B|RST_B GND|VGND|VSS GND|VGND|VSS nfet L=0.15U W=0.42U
+ AS=0.12495P AD=0.06405P PS=1.015U PD=0.725U
* device instance $54 r0 *1 35.708,-141.395 nfet
M$54 \$56 \$55 \$70 GND|VGND|VSS nfet L=0.15U W=0.42U AS=0.06405P AD=0.1092P
+ PS=0.725U PD=1.36U
* device instance $55 r0 *1 32.988,-141.285 nfet
M$55 \$54 \$52 GND|VGND|VSS GND|VGND|VSS nfet L=0.15U W=0.64U AS=0.1346P
+ AD=0.0999P PS=1.15U PD=0.985U
* device instance $56 r0 *1 36.748,-141.28 nfet
M$56 A|A0|B|DOUT5|Q \$56 GND|VGND|VSS GND|VGND|VSS nfet L=0.15U W=0.65U
+ AS=0.2087P AD=0.169P PS=2.02U PD=1.82U
* device instance $57 r0 *1 44.793,-141.28 nfet
M$57 Y A|CLK|X GND|VGND|VSS GND|VGND|VSS nfet L=0.15U W=0.65U AS=0.169P
+ AD=0.169P PS=1.82U PD=1.82U
* device instance $58 r0 *1 50.108,-141.395 nfet
M$58 GND|VGND|VSS A|CLK|X \$59 GND|VGND|VSS nfet L=0.15U W=0.42U AS=0.1092P
+ AD=0.0567P PS=1.36U PD=0.69U
* device instance $59 r0 *1 50.528,-141.395 nfet
M$59 \$60 \$59 GND|VGND|VSS GND|VGND|VSS nfet L=0.15U W=0.42U AS=0.0567P
+ AD=0.1092P PS=0.69U PD=1.36U
* device instance $60 r0 *1 52.278,-141.425 nfet
M$60 \$62 \$59 \$61 GND|VGND|VSS nfet L=0.15U W=0.36U AS=0.066P AD=0.0594P
+ PS=0.745U PD=0.69U
* device instance $61 r0 *1 52.758,-141.425 nfet
M$61 \$71 \$60 \$62 GND|VGND|VSS nfet L=0.15U W=0.36U AS=0.0594P AD=0.1401P
+ PS=0.69U PD=1.1U
* device instance $62 r0 *1 55.103,-141.425 nfet
M$62 \$65 \$60 \$64 GND|VGND|VSS nfet L=0.15U W=0.36U AS=0.0999P AD=0.0711P
+ PS=0.985U PD=0.755U
* device instance $63 r0 *1 55.648,-141.425 nfet
M$63 \$73 \$59 \$65 GND|VGND|VSS nfet L=0.15U W=0.36U AS=0.0711P AD=0.0669P
+ PS=0.755U PD=0.75U
* device instance $64 r0 *1 51.803,-141.395 nfet
M$64 \$61 C|D|PH_B7|Q|S GND|VGND|VSS GND|VGND|VSS nfet L=0.15U W=0.42U
+ AS=0.2205P AD=0.066P PS=1.89U PD=0.745U
* device instance $65 r0 *1 53.588,-141.395 nfet
M$65 \$72 \$64 \$71 GND|VGND|VSS nfet L=0.15U W=0.42U AS=0.1401P AD=0.0441P
+ PS=1.1U PD=0.63U
* device instance $66 r0 *1 53.948,-141.395 nfet
M$66 GND|VGND|VSS RESET_B|RST_B \$72 GND|VGND|VSS nfet L=0.15U W=0.42U
+ AS=0.0441P AD=0.1346P PS=0.63U PD=1.15U
* device instance $67 r0 *1 56.128,-141.395 nfet
M$67 GND|VGND|VSS \$66 \$73 GND|VGND|VSS nfet L=0.15U W=0.42U AS=0.0669P
+ AD=0.12495P PS=0.75U PD=1.015U
* device instance $68 r0 *1 56.873,-141.395 nfet
M$68 \$74 RESET_B|RST_B GND|VGND|VSS GND|VGND|VSS nfet L=0.15U W=0.42U
+ AS=0.12495P AD=0.06405P PS=1.015U PD=0.725U
* device instance $69 r0 *1 57.328,-141.395 nfet
M$69 \$66 \$65 \$74 GND|VGND|VSS nfet L=0.15U W=0.42U AS=0.06405P AD=0.1092P
+ PS=0.725U PD=1.36U
* device instance $70 r0 *1 54.608,-141.285 nfet
M$70 \$64 \$62 GND|VGND|VSS GND|VGND|VSS nfet L=0.15U W=0.64U AS=0.1346P
+ AD=0.0999P PS=1.15U PD=0.985U
* device instance $71 r0 *1 58.368,-141.28 nfet
M$71 D|PH_B6|Q|S \$66 GND|VGND|VSS GND|VGND|VSS nfet L=0.15U W=0.65U AS=0.2087P
+ AD=0.169P PS=2.02U PD=1.82U
* device instance $72 r0 *1 33.173,-135.955 nfet
M$72 \$129 C|D|PH_B3|Q|S GND|VGND|VSS GND|VGND|VSS nfet L=0.15U W=0.42U
+ AS=0.11285P AD=0.0693P PS=1.045U PD=0.75U
* device instance $73 r0 *1 33.653,-135.955 nfet
M$73 \$108 A1|COMP_OUT|OUTP \$129 GND|VGND|VSS nfet L=0.15U W=0.42U AS=0.0693P
+ AD=0.09975P PS=0.75U PD=0.895U
* device instance $74 r0 *1 34.278,-135.955 nfet
M$74 \$130 A|A0|B|DOUT3|Q \$108 GND|VGND|VSS nfet L=0.15U W=0.42U AS=0.09975P
+ AD=0.0693P PS=0.895U PD=0.75U
* device instance $75 r0 *1 34.758,-135.955 nfet
M$75 GND|VGND|VSS \$111 \$130 GND|VGND|VSS nfet L=0.15U W=0.42U AS=0.0693P
+ AD=0.1449P PS=0.75U PD=1.11U
* device instance $76 r0 *1 35.598,-135.955 nfet
M$76 \$111 C|D|PH_B3|Q|S GND|VGND|VSS GND|VGND|VSS nfet L=0.15U W=0.42U
+ AS=0.1449P AD=0.1092P PS=1.11U PD=1.36U
* device instance $77 r0 *1 32.628,-135.84 nfet
M$77 GND|VGND|VSS \$108 D|X$4 GND|VGND|VSS nfet L=0.15U W=0.65U AS=0.169P
+ AD=0.11285P PS=1.82U PD=1.045U
* device instance $78 r0 *1 32.628,-136.96 nfet
M$78 GND|VGND|VSS \$77 D|X$2 GND|VGND|VSS nfet L=0.15U W=0.65U AS=0.169P
+ AD=0.11285P PS=1.82U PD=1.045U
* device instance $79 r0 *1 33.173,-136.845 nfet
M$79 \$91 A|D|PH_B5|Q|S GND|VGND|VSS GND|VGND|VSS nfet L=0.15U W=0.42U
+ AS=0.11285P AD=0.0693P PS=1.045U PD=0.75U
* device instance $80 r0 *1 33.653,-136.845 nfet
M$80 \$77 A1|COMP_OUT|OUTP \$91 GND|VGND|VSS nfet L=0.15U W=0.42U AS=0.0693P
+ AD=0.09975P PS=0.75U PD=0.895U
* device instance $81 r0 *1 34.278,-136.845 nfet
M$81 \$94 A|A0|B|DOUT5|Q \$77 GND|VGND|VSS nfet L=0.15U W=0.42U AS=0.09975P
+ AD=0.0693P PS=0.895U PD=0.75U
* device instance $82 r0 *1 34.758,-136.845 nfet
M$82 GND|VGND|VSS \$80 \$94 GND|VGND|VSS nfet L=0.15U W=0.42U AS=0.0693P
+ AD=0.1449P PS=0.75U PD=1.11U
* device instance $83 r0 *1 35.598,-136.845 nfet
M$83 \$80 A|D|PH_B5|Q|S GND|VGND|VSS GND|VGND|VSS nfet L=0.15U W=0.42U
+ AS=0.1449P AD=0.1092P PS=1.11U PD=1.36U
* device instance $84 r0 *1 39.068,-136.96 nfet
M$84 GND|VGND|VSS \$81 D|X GND|VGND|VSS nfet L=0.15U W=0.65U AS=0.169P
+ AD=0.11285P PS=1.82U PD=1.045U
* device instance $85 r0 *1 39.613,-136.845 nfet
M$85 \$96 D|PH_B6|Q|S GND|VGND|VSS GND|VGND|VSS nfet L=0.15U W=0.42U
+ AS=0.11285P AD=0.0693P PS=1.045U PD=0.75U
* device instance $86 r0 *1 40.093,-136.845 nfet
M$86 \$81 A1|COMP_OUT|OUTP \$96 GND|VGND|VSS nfet L=0.15U W=0.42U AS=0.0693P
+ AD=0.09975P PS=0.75U PD=0.895U
* device instance $87 r0 *1 40.718,-136.845 nfet
M$87 \$97 A|A0|B|DOUT6|Q \$81 GND|VGND|VSS nfet L=0.15U W=0.42U AS=0.09975P
+ AD=0.0693P PS=0.895U PD=0.75U
* device instance $88 r0 *1 41.198,-136.845 nfet
M$88 GND|VGND|VSS \$83 \$97 GND|VGND|VSS nfet L=0.15U W=0.42U AS=0.0693P
+ AD=0.1449P PS=0.75U PD=1.11U
* device instance $89 r0 *1 42.038,-136.845 nfet
M$89 \$83 D|PH_B6|Q|S GND|VGND|VSS GND|VGND|VSS nfet L=0.15U W=0.42U AS=0.1449P
+ AD=0.1092P PS=1.11U PD=1.36U
* device instance $90 r0 *1 40.448,-135.955 nfet
M$90 GND|VGND|VSS A|CLK|X \$112 GND|VGND|VSS nfet L=0.15U W=0.42U AS=0.1092P
+ AD=0.0567P PS=1.36U PD=0.69U
* device instance $91 r0 *1 40.868,-135.955 nfet
M$91 \$113 \$112 GND|VGND|VSS GND|VGND|VSS nfet L=0.15U W=0.42U AS=0.0567P
+ AD=0.1092P PS=0.69U PD=1.36U
* device instance $92 r0 *1 42.618,-135.985 nfet
M$92 \$115 \$112 \$114 GND|VGND|VSS nfet L=0.15U W=0.36U AS=0.066P AD=0.0594P
+ PS=0.745U PD=0.69U
* device instance $93 r0 *1 43.098,-135.985 nfet
M$93 \$132 \$113 \$115 GND|VGND|VSS nfet L=0.15U W=0.36U AS=0.0594P AD=0.1401P
+ PS=0.69U PD=1.1U
* device instance $94 r0 *1 45.443,-135.985 nfet
M$94 \$118 \$113 \$117 GND|VGND|VSS nfet L=0.15U W=0.36U AS=0.0999P AD=0.0711P
+ PS=0.985U PD=0.755U
* device instance $95 r0 *1 45.988,-135.985 nfet
M$95 \$133 \$112 \$118 GND|VGND|VSS nfet L=0.15U W=0.36U AS=0.0711P AD=0.0669P
+ PS=0.755U PD=0.75U
* device instance $96 r0 *1 42.143,-135.955 nfet
M$96 \$114 D|PH_B6|Q|S GND|VGND|VSS GND|VGND|VSS nfet L=0.15U W=0.42U
+ AS=0.2205P AD=0.066P PS=1.89U PD=0.745U
* device instance $97 r0 *1 43.928,-135.955 nfet
M$97 \$131 \$117 \$132 GND|VGND|VSS nfet L=0.15U W=0.42U AS=0.1401P AD=0.0441P
+ PS=1.1U PD=0.63U
* device instance $98 r0 *1 44.288,-135.955 nfet
M$98 GND|VGND|VSS RESET_B|RST_B \$131 GND|VGND|VSS nfet L=0.15U W=0.42U
+ AS=0.0441P AD=0.1346P PS=0.63U PD=1.15U
* device instance $99 r0 *1 46.468,-135.955 nfet
M$99 GND|VGND|VSS \$119 \$133 GND|VGND|VSS nfet L=0.15U W=0.42U AS=0.0669P
+ AD=0.12495P PS=0.75U PD=1.015U
* device instance $100 r0 *1 47.213,-135.955 nfet
M$100 \$134 RESET_B|RST_B GND|VGND|VSS GND|VGND|VSS nfet L=0.15U W=0.42U
+ AS=0.12495P AD=0.06405P PS=1.015U PD=0.725U
* device instance $101 r0 *1 47.668,-135.955 nfet
M$101 \$119 \$118 \$134 GND|VGND|VSS nfet L=0.15U W=0.42U AS=0.06405P
+ AD=0.1092P PS=0.725U PD=1.36U
* device instance $102 r0 *1 44.948,-135.845 nfet
M$102 \$117 \$115 GND|VGND|VSS GND|VGND|VSS nfet L=0.15U W=0.64U AS=0.1346P
+ AD=0.0999P PS=1.15U PD=0.985U
* device instance $103 r0 *1 44.588,-136.96 nfet
M$103 GND|VGND|VSS A|X$1 \$84 GND|VGND|VSS nfet L=0.15U W=0.65U AS=0.169P
+ AD=0.08775P PS=1.82U PD=0.92U
* device instance $104 r0 *1 45.008,-136.96 nfet
M$104 A|CLK|X \$84 GND|VGND|VSS GND|VGND|VSS nfet L=0.15U W=0.65U AS=0.08775P
+ AD=0.08775P PS=0.92U PD=0.92U
* device instance $105 r0 *1 45.428,-136.96 nfet
M$105 GND|VGND|VSS \$84 A|CLK|X GND|VGND|VSS nfet L=0.15U W=0.65U AS=0.08775P
+ AD=0.08775P PS=0.92U PD=0.92U
* device instance $106 r0 *1 45.848,-136.96 nfet
M$106 A|CLK|X \$84 GND|VGND|VSS GND|VGND|VSS nfet L=0.15U W=0.65U AS=0.08775P
+ AD=0.08775P PS=0.92U PD=0.92U
* device instance $107 r0 *1 46.268,-136.96 nfet
M$107 GND|VGND|VSS \$84 A|CLK|X GND|VGND|VSS nfet L=0.15U W=0.65U AS=0.08775P
+ AD=0.169P PS=0.92U PD=1.82U
* device instance $108 r0 *1 48.708,-135.84 nfet
M$108 A|D|PH_B5|Q|S \$119 GND|VGND|VSS GND|VGND|VSS nfet L=0.15U W=0.65U
+ AS=0.2087P AD=0.169P PS=2.02U PD=1.82U
* device instance $109 r0 *1 50.568,-135.955 nfet
M$109 GND|VGND|VSS A|CLK|X \$121 GND|VGND|VSS nfet L=0.15U W=0.42U AS=0.1092P
+ AD=0.0567P PS=1.36U PD=0.69U
* device instance $110 r0 *1 50.988,-135.955 nfet
M$110 \$122 \$121 GND|VGND|VSS GND|VGND|VSS nfet L=0.15U W=0.42U AS=0.0567P
+ AD=0.1092P PS=0.69U PD=1.36U
* device instance $111 r0 *1 51.948,-136.96 nfet
M$111 GND|VGND|VSS \$86 D|X$3 GND|VGND|VSS nfet L=0.15U W=0.65U AS=0.169P
+ AD=0.11285P PS=1.82U PD=1.045U
* device instance $112 r0 *1 52.493,-136.845 nfet
M$112 \$99 C|D|PH_B7|Q|S GND|VGND|VSS GND|VGND|VSS nfet L=0.15U W=0.42U
+ AS=0.11285P AD=0.0693P PS=1.045U PD=0.75U
* device instance $113 r0 *1 52.973,-136.845 nfet
M$113 \$86 A1|COMP_OUT|OUTP \$99 GND|VGND|VSS nfet L=0.15U W=0.42U AS=0.0693P
+ AD=0.09975P PS=0.75U PD=0.895U
* device instance $114 r0 *1 53.598,-136.845 nfet
M$114 \$102 A|A0|B|DOUT7|Q \$86 GND|VGND|VSS nfet L=0.15U W=0.42U AS=0.09975P
+ AD=0.0693P PS=0.895U PD=0.75U
* device instance $115 r0 *1 54.078,-136.845 nfet
M$115 GND|VGND|VSS \$88 \$102 GND|VGND|VSS nfet L=0.15U W=0.42U AS=0.0693P
+ AD=0.1449P PS=0.75U PD=1.11U
* device instance $116 r0 *1 54.918,-136.845 nfet
M$116 \$88 C|D|PH_B7|Q|S GND|VGND|VSS GND|VGND|VSS nfet L=0.15U W=0.42U
+ AS=0.1449P AD=0.1092P PS=1.11U PD=1.36U
* device instance $117 r0 *1 52.738,-135.985 nfet
M$117 \$124 \$121 \$123 GND|VGND|VSS nfet L=0.15U W=0.36U AS=0.066P AD=0.0594P
+ PS=0.745U PD=0.69U
* device instance $118 r0 *1 53.218,-135.985 nfet
M$118 \$135 \$122 \$124 GND|VGND|VSS nfet L=0.15U W=0.36U AS=0.0594P AD=0.1401P
+ PS=0.69U PD=1.1U
* device instance $119 r0 *1 55.563,-135.985 nfet
M$119 \$127 \$122 \$126 GND|VGND|VSS nfet L=0.15U W=0.36U AS=0.0999P AD=0.0711P
+ PS=0.985U PD=0.755U
* device instance $120 r0 *1 56.108,-135.985 nfet
M$120 \$137 \$121 \$127 GND|VGND|VSS nfet L=0.15U W=0.36U AS=0.0711P AD=0.0669P
+ PS=0.755U PD=0.75U
* device instance $121 r0 *1 52.263,-135.955 nfet
M$121 \$123 A|A_N|D|PH_B9|Q|S GND|VGND|VSS GND|VGND|VSS nfet L=0.15U W=0.42U
+ AS=0.2205P AD=0.066P PS=1.89U PD=0.745U
* device instance $122 r0 *1 54.048,-135.955 nfet
M$122 \$136 \$126 \$135 GND|VGND|VSS nfet L=0.15U W=0.42U AS=0.1401P AD=0.0441P
+ PS=1.1U PD=0.63U
* device instance $123 r0 *1 54.408,-135.955 nfet
M$123 GND|VGND|VSS RESET_B|RST_B \$136 GND|VGND|VSS nfet L=0.15U W=0.42U
+ AS=0.0441P AD=0.1346P PS=0.63U PD=1.15U
* device instance $124 r0 *1 56.588,-135.955 nfet
M$124 GND|VGND|VSS \$128 \$137 GND|VGND|VSS nfet L=0.15U W=0.42U AS=0.0669P
+ AD=0.12495P PS=0.75U PD=1.015U
* device instance $125 r0 *1 57.333,-135.955 nfet
M$125 \$138 RESET_B|RST_B GND|VGND|VSS GND|VGND|VSS nfet L=0.15U W=0.42U
+ AS=0.12495P AD=0.06405P PS=1.015U PD=0.725U
* device instance $126 r0 *1 57.788,-135.955 nfet
M$126 \$128 \$127 \$138 GND|VGND|VSS nfet L=0.15U W=0.42U AS=0.06405P
+ AD=0.1092P PS=0.725U PD=1.36U
* device instance $127 r0 *1 55.068,-135.845 nfet
M$127 \$126 \$124 GND|VGND|VSS GND|VGND|VSS nfet L=0.15U W=0.64U AS=0.1346P
+ AD=0.0999P PS=1.15U PD=0.985U
* device instance $128 r0 *1 56.088,-136.96 nfet
M$128 GND|VGND|VSS \$89 D|X$1 GND|VGND|VSS nfet L=0.15U W=0.65U AS=0.169P
+ AD=0.11285P PS=1.82U PD=1.045U
* device instance $129 r0 *1 56.633,-136.845 nfet
M$129 \$103 B|D|PH_B8|Q|S GND|VGND|VSS GND|VGND|VSS nfet L=0.15U W=0.42U
+ AS=0.11285P AD=0.0693P PS=1.045U PD=0.75U
* device instance $130 r0 *1 57.113,-136.845 nfet
M$130 \$89 A1|COMP_OUT|OUTP \$103 GND|VGND|VSS nfet L=0.15U W=0.42U AS=0.0693P
+ AD=0.09975P PS=0.75U PD=0.895U
* device instance $131 r0 *1 57.738,-136.845 nfet
M$131 \$106 A|A0|B|DOUT8|Q \$89 GND|VGND|VSS nfet L=0.15U W=0.42U AS=0.09975P
+ AD=0.0693P PS=0.895U PD=0.75U
* device instance $132 r0 *1 58.218,-136.845 nfet
M$132 GND|VGND|VSS \$90 \$106 GND|VGND|VSS nfet L=0.15U W=0.42U AS=0.0693P
+ AD=0.1449P PS=0.75U PD=1.11U
* device instance $133 r0 *1 59.058,-136.845 nfet
M$133 \$90 B|D|PH_B8|Q|S GND|VGND|VSS GND|VGND|VSS nfet L=0.15U W=0.42U
+ AS=0.1449P AD=0.1092P PS=1.11U PD=1.36U
* device instance $134 r0 *1 58.828,-135.84 nfet
M$134 B|D|PH_B8|Q|S \$128 GND|VGND|VSS GND|VGND|VSS nfet L=0.15U W=0.65U
+ AS=0.2087P AD=0.169P PS=2.02U PD=1.82U
* device instance $135 r0 *1 29.868,-131.405 nfet
M$135 GND|VGND|VSS A|CLK|X \$143 GND|VGND|VSS nfet L=0.15U W=0.42U AS=0.1092P
+ AD=0.0567P PS=1.36U PD=0.69U
* device instance $136 r0 *1 30.288,-131.405 nfet
M$136 \$144 \$143 GND|VGND|VSS GND|VGND|VSS nfet L=0.15U W=0.42U AS=0.0567P
+ AD=0.1092P PS=0.69U PD=1.36U
* device instance $137 r0 *1 31.563,-131.405 nfet
M$137 \$146 D|X$5 GND|VGND|VSS GND|VGND|VSS nfet L=0.15U W=0.42U AS=0.2205P
+ AD=0.066P PS=1.89U PD=0.745U
* device instance $138 r0 *1 32.038,-131.375 nfet
M$138 \$147 \$143 \$146 GND|VGND|VSS nfet L=0.15U W=0.36U AS=0.066P AD=0.0594P
+ PS=0.745U PD=0.69U
* device instance $139 r0 *1 32.518,-131.375 nfet
M$139 \$147 \$144 \$173 GND|VGND|VSS nfet L=0.15U W=0.36U AS=0.1401P AD=0.0594P
+ PS=1.1U PD=0.69U
* device instance $140 r0 *1 33.348,-131.405 nfet
M$140 \$175 \$149 \$173 GND|VGND|VSS nfet L=0.15U W=0.42U AS=0.1401P AD=0.0441P
+ PS=1.1U PD=0.63U
* device instance $141 r0 *1 33.708,-131.405 nfet
M$141 \$175 RESET_B|RST_B GND|VGND|VSS GND|VGND|VSS nfet L=0.15U W=0.42U
+ AS=0.1346P AD=0.0441P PS=1.15U PD=0.63U
* device instance $142 r0 *1 34.368,-131.515 nfet
M$142 \$149 \$147 GND|VGND|VSS GND|VGND|VSS nfet L=0.15U W=0.64U AS=0.1346P
+ AD=0.0999P PS=1.15U PD=0.985U
* device instance $143 r0 *1 34.863,-131.375 nfet
M$143 \$150 \$144 \$149 GND|VGND|VSS nfet L=0.15U W=0.36U AS=0.0999P AD=0.0711P
+ PS=0.985U PD=0.755U
* device instance $144 r0 *1 35.408,-131.375 nfet
M$144 \$150 \$143 \$174 GND|VGND|VSS nfet L=0.15U W=0.36U AS=0.0669P AD=0.0711P
+ PS=0.75U PD=0.755U
* device instance $145 r0 *1 35.888,-131.405 nfet
M$145 GND|VGND|VSS \$151 \$174 GND|VGND|VSS nfet L=0.15U W=0.42U AS=0.0669P
+ AD=0.12495P PS=0.75U PD=1.015U
* device instance $146 r0 *1 36.633,-131.405 nfet
M$146 \$172 RESET_B|RST_B GND|VGND|VSS GND|VGND|VSS nfet L=0.15U W=0.42U
+ AS=0.12495P AD=0.06405P PS=1.015U PD=0.725U
* device instance $147 r0 *1 37.088,-131.405 nfet
M$147 \$151 \$150 \$172 GND|VGND|VSS nfet L=0.15U W=0.42U AS=0.06405P
+ AD=0.1092P PS=0.725U PD=1.36U
* device instance $148 r0 *1 34.093,-130.515 nfet
M$148 \$190 D|PH_B2|Q|S GND|VGND|VSS GND|VGND|VSS nfet L=0.15U W=0.42U
+ AS=0.11285P AD=0.0693P PS=1.045U PD=0.75U
* device instance $149 r0 *1 34.573,-130.515 nfet
M$149 \$176 A1|COMP_OUT|OUTP \$190 GND|VGND|VSS nfet L=0.15U W=0.42U AS=0.0693P
+ AD=0.09975P PS=0.75U PD=0.895U
* device instance $150 r0 *1 35.198,-130.515 nfet
M$150 \$193 A|A0|B|DOUT2|Q \$176 GND|VGND|VSS nfet L=0.15U W=0.42U AS=0.09975P
+ AD=0.0693P PS=0.895U PD=0.75U
* device instance $151 r0 *1 35.678,-130.515 nfet
M$151 GND|VGND|VSS \$178 \$193 GND|VGND|VSS nfet L=0.15U W=0.42U AS=0.0693P
+ AD=0.1449P PS=0.75U PD=1.11U
* device instance $152 r0 *1 36.518,-130.515 nfet
M$152 \$178 D|PH_B2|Q|S GND|VGND|VSS GND|VGND|VSS nfet L=0.15U W=0.42U
+ AS=0.1449P AD=0.1092P PS=1.11U PD=1.36U
* device instance $153 r0 *1 33.548,-130.4 nfet
M$153 GND|VGND|VSS \$176 D|X$5 GND|VGND|VSS nfet L=0.15U W=0.65U AS=0.169P
+ AD=0.11285P PS=1.82U PD=1.045U
* device instance $154 r0 *1 38.128,-131.52 nfet
M$154 A|A0|B|DOUT2|Q \$151 GND|VGND|VSS GND|VGND|VSS nfet L=0.15U W=0.65U
+ AS=0.2087P AD=0.169P PS=2.02U PD=1.82U
* device instance $155 r0 *1 40.448,-130.4 nfet
M$155 GND|VGND|VSS A|CLK \$180 GND|VGND|VSS nfet L=0.15U W=0.65U AS=0.169P
+ AD=0.08775P PS=1.82U PD=0.92U
* device instance $156 r0 *1 40.868,-130.4 nfet
M$156 A|X$1 \$180 GND|VGND|VSS GND|VGND|VSS nfet L=0.15U W=0.65U AS=0.08775P
+ AD=0.08775P PS=0.92U PD=0.92U
* device instance $157 r0 *1 41.288,-130.4 nfet
M$157 GND|VGND|VSS \$180 A|X$1 GND|VGND|VSS nfet L=0.15U W=0.65U AS=0.08775P
+ AD=0.08775P PS=0.92U PD=0.92U
* device instance $158 r0 *1 41.708,-130.4 nfet
M$158 A|X$1 \$180 GND|VGND|VSS GND|VGND|VSS nfet L=0.15U W=0.65U AS=0.08775P
+ AD=0.08775P PS=0.92U PD=0.92U
* device instance $159 r0 *1 42.128,-130.4 nfet
M$159 GND|VGND|VSS \$180 A|X$1 GND|VGND|VSS nfet L=0.15U W=0.65U AS=0.08775P
+ AD=0.169P PS=0.92U PD=1.82U
* device instance $160 r0 *1 48.728,-131.435 nfet
M$160 \$152 D|PH_B6|Q|S GND|VGND|VSS GND|VGND|VSS nfet L=0.15U W=0.42U
+ AS=0.1092P AD=0.0693P PS=1.36U PD=0.75U
* device instance $161 r0 *1 49.208,-131.435 nfet
M$161 GND|VGND|VSS C|D|PH_B7|Q|S \$152 GND|VGND|VSS nfet L=0.15U W=0.42U
+ AS=0.0693P AD=0.0567P PS=0.75U PD=0.69U
* device instance $162 r0 *1 49.628,-131.435 nfet
M$162 \$152 B|D|PH_B8|Q|S GND|VGND|VSS GND|VGND|VSS nfet L=0.15U W=0.42U
+ AS=0.0567P AD=0.0567P PS=0.69U PD=0.69U
* device instance $163 r0 *1 50.048,-131.435 nfet
M$163 \$152 A|A_N|D|PH_B9|Q|S GND|VGND|VSS GND|VGND|VSS nfet L=0.15U W=0.42U
+ AS=0.101875P AD=0.0567P PS=0.99U PD=0.69U
* device instance $164 r0 *1 50.538,-131.52 nfet
M$164 A|X \$152 GND|VGND|VSS GND|VGND|VSS nfet L=0.15U W=0.65U AS=0.101875P
+ AD=0.1755P PS=0.99U PD=1.84U
* device instance $165 r0 *1 49.188,-130.515 nfet
M$165 GND|VGND|VSS A|CLK|X \$182 GND|VGND|VSS nfet L=0.15U W=0.42U AS=0.1092P
+ AD=0.0567P PS=1.36U PD=0.69U
* device instance $166 r0 *1 49.608,-130.515 nfet
M$166 \$183 \$182 GND|VGND|VSS GND|VGND|VSS nfet L=0.15U W=0.42U AS=0.0567P
+ AD=0.1092P PS=0.69U PD=1.36U
* device instance $167 r0 *1 51.358,-130.545 nfet
M$167 \$185 \$182 \$184 GND|VGND|VSS nfet L=0.15U W=0.36U AS=0.066P AD=0.0594P
+ PS=0.745U PD=0.69U
* device instance $168 r0 *1 51.838,-130.545 nfet
M$168 \$194 \$183 \$185 GND|VGND|VSS nfet L=0.15U W=0.36U AS=0.0594P AD=0.1401P
+ PS=0.69U PD=1.1U
* device instance $169 r0 *1 54.183,-130.545 nfet
M$169 \$188 \$183 \$187 GND|VGND|VSS nfet L=0.15U W=0.36U AS=0.0999P AD=0.0711P
+ PS=0.985U PD=0.755U
* device instance $170 r0 *1 54.728,-130.545 nfet
M$170 \$197 \$182 \$188 GND|VGND|VSS nfet L=0.15U W=0.36U AS=0.0711P AD=0.0669P
+ PS=0.755U PD=0.75U
* device instance $171 r0 *1 50.883,-130.515 nfet
M$171 \$184 D|X$3 GND|VGND|VSS GND|VGND|VSS nfet L=0.15U W=0.42U AS=0.2205P
+ AD=0.066P PS=1.89U PD=0.745U
* device instance $172 r0 *1 52.668,-130.515 nfet
M$172 \$195 \$187 \$194 GND|VGND|VSS nfet L=0.15U W=0.42U AS=0.1401P AD=0.0441P
+ PS=1.1U PD=0.63U
* device instance $173 r0 *1 53.028,-130.515 nfet
M$173 GND|VGND|VSS RESET_B|RST_B \$195 GND|VGND|VSS nfet L=0.15U W=0.42U
+ AS=0.0441P AD=0.1346P PS=0.63U PD=1.15U
* device instance $174 r0 *1 55.208,-130.515 nfet
M$174 GND|VGND|VSS \$189 \$197 GND|VGND|VSS nfet L=0.15U W=0.42U AS=0.0669P
+ AD=0.12495P PS=0.75U PD=1.015U
* device instance $175 r0 *1 55.953,-130.515 nfet
M$175 \$198 RESET_B|RST_B GND|VGND|VSS GND|VGND|VSS nfet L=0.15U W=0.42U
+ AS=0.12495P AD=0.06405P PS=1.015U PD=0.725U
* device instance $176 r0 *1 56.408,-130.515 nfet
M$176 \$189 \$188 \$198 GND|VGND|VSS nfet L=0.15U W=0.42U AS=0.06405P
+ AD=0.1092P PS=0.725U PD=1.36U
* device instance $177 r0 *1 53.688,-130.405 nfet
M$177 \$187 \$185 GND|VGND|VSS GND|VGND|VSS nfet L=0.15U W=0.64U AS=0.1346P
+ AD=0.0999P PS=1.15U PD=0.985U
* device instance $178 r0 *1 51.948,-131.405 nfet
M$178 GND|VGND|VSS A|CLK|X \$154 GND|VGND|VSS nfet L=0.15U W=0.42U AS=0.1092P
+ AD=0.0567P PS=1.36U PD=0.69U
* device instance $179 r0 *1 52.368,-131.405 nfet
M$179 \$155 \$154 GND|VGND|VSS GND|VGND|VSS nfet L=0.15U W=0.42U AS=0.0567P
+ AD=0.1092P PS=0.69U PD=1.36U
* device instance $180 r0 *1 53.643,-131.405 nfet
M$180 \$157 D|PH_SAMPLE|SAMPLE|Y GND|VGND|VSS GND|VGND|VSS nfet L=0.15U W=0.42U
+ AS=0.2205P AD=0.066P PS=1.89U PD=0.745U
* device instance $181 r0 *1 54.118,-131.375 nfet
M$181 \$158 \$154 \$157 GND|VGND|VSS nfet L=0.15U W=0.36U AS=0.066P AD=0.0594P
+ PS=0.745U PD=0.69U
* device instance $182 r0 *1 54.598,-131.375 nfet
M$182 \$158 \$155 \$171 GND|VGND|VSS nfet L=0.15U W=0.36U AS=0.1401P AD=0.0594P
+ PS=1.1U PD=0.69U
* device instance $183 r0 *1 55.428,-131.405 nfet
M$183 \$170 \$160 \$171 GND|VGND|VSS nfet L=0.15U W=0.42U AS=0.1401P AD=0.0441P
+ PS=1.1U PD=0.63U
* device instance $184 r0 *1 55.788,-131.405 nfet
M$184 \$170 RESET_B|RST_B GND|VGND|VSS GND|VGND|VSS nfet L=0.15U W=0.42U
+ AS=0.1346P AD=0.0441P PS=1.15U PD=0.63U
* device instance $185 r0 *1 56.448,-131.515 nfet
M$185 \$160 \$158 GND|VGND|VSS GND|VGND|VSS nfet L=0.15U W=0.64U AS=0.1346P
+ AD=0.0999P PS=1.15U PD=0.985U
* device instance $186 r0 *1 56.943,-131.375 nfet
M$186 \$161 \$155 \$160 GND|VGND|VSS nfet L=0.15U W=0.36U AS=0.0999P AD=0.0711P
+ PS=0.985U PD=0.755U
* device instance $187 r0 *1 57.488,-131.375 nfet
M$187 \$161 \$154 \$169 GND|VGND|VSS nfet L=0.15U W=0.36U AS=0.0669P AD=0.0711P
+ PS=0.75U PD=0.755U
* device instance $188 r0 *1 57.968,-131.405 nfet
M$188 GND|VGND|VSS \$162 \$169 GND|VGND|VSS nfet L=0.15U W=0.42U AS=0.0669P
+ AD=0.12495P PS=0.75U PD=1.015U
* device instance $189 r0 *1 58.713,-131.405 nfet
M$189 \$168 RESET_B|RST_B GND|VGND|VSS GND|VGND|VSS nfet L=0.15U W=0.42U
+ AS=0.12495P AD=0.06405P PS=1.015U PD=0.725U
* device instance $190 r0 *1 59.168,-131.405 nfet
M$190 \$162 \$161 \$168 GND|VGND|VSS nfet L=0.15U W=0.42U AS=0.06405P
+ AD=0.1092P PS=0.725U PD=1.36U
* device instance $191 r0 *1 57.448,-130.4 nfet
M$191 A|A0|B|DOUT7|Q \$189 GND|VGND|VSS GND|VGND|VSS nfet L=0.15U W=0.65U
+ AS=0.2087P AD=0.169P PS=2.02U PD=1.82U
* device instance $192 r0 *1 60.208,-131.52 nfet
M$192 A|A_N|D|PH_B9|Q|S \$162 GND|VGND|VSS GND|VGND|VSS nfet L=0.15U W=0.65U
+ AS=0.2087P AD=0.169P PS=2.02U PD=1.82U
* device instance $193 r0 *1 29.868,-125.965 nfet
M$193 GND|VGND|VSS CLK|X \$200 GND|VGND|VSS nfet L=0.15U W=0.42U AS=0.1092P
+ AD=0.0567P PS=1.36U PD=0.69U
* device instance $194 r0 *1 30.288,-125.965 nfet
M$194 \$201 \$200 GND|VGND|VSS GND|VGND|VSS nfet L=0.15U W=0.42U AS=0.0567P
+ AD=0.1092P PS=0.69U PD=1.36U
* device instance $195 r0 *1 31.563,-125.965 nfet
M$195 \$202 A|D|PH_B5|Q|S GND|VGND|VSS GND|VGND|VSS nfet L=0.15U W=0.42U
+ AS=0.2205P AD=0.066P PS=1.89U PD=0.745U
* device instance $196 r0 *1 32.038,-125.935 nfet
M$196 \$203 \$200 \$202 GND|VGND|VSS nfet L=0.15U W=0.36U AS=0.066P AD=0.0594P
+ PS=0.745U PD=0.69U
* device instance $197 r0 *1 32.518,-125.935 nfet
M$197 \$203 \$201 \$227 GND|VGND|VSS nfet L=0.15U W=0.36U AS=0.1401P AD=0.0594P
+ PS=1.1U PD=0.69U
* device instance $198 r0 *1 33.348,-125.965 nfet
M$198 \$228 \$205 \$227 GND|VGND|VSS nfet L=0.15U W=0.42U AS=0.1401P AD=0.0441P
+ PS=1.1U PD=0.63U
* device instance $199 r0 *1 33.708,-125.965 nfet
M$199 \$228 RESET_B|RST_B GND|VGND|VSS GND|VGND|VSS nfet L=0.15U W=0.42U
+ AS=0.1346P AD=0.0441P PS=1.15U PD=0.63U
* device instance $200 r0 *1 34.368,-126.075 nfet
M$200 \$205 \$203 GND|VGND|VSS GND|VGND|VSS nfet L=0.15U W=0.64U AS=0.1346P
+ AD=0.0999P PS=1.15U PD=0.985U
* device instance $201 r0 *1 34.863,-125.935 nfet
M$201 \$207 \$201 \$205 GND|VGND|VSS nfet L=0.15U W=0.36U AS=0.0999P AD=0.0711P
+ PS=0.985U PD=0.755U
* device instance $202 r0 *1 35.408,-125.935 nfet
M$202 \$207 \$200 \$229 GND|VGND|VSS nfet L=0.15U W=0.36U AS=0.0669P AD=0.0711P
+ PS=0.75U PD=0.755U
* device instance $203 r0 *1 35.888,-125.965 nfet
M$203 GND|VGND|VSS \$208 \$229 GND|VGND|VSS nfet L=0.15U W=0.42U AS=0.0669P
+ AD=0.12495P PS=0.75U PD=1.015U
* device instance $204 r0 *1 36.633,-125.965 nfet
M$204 \$230 RESET_B|RST_B GND|VGND|VSS GND|VGND|VSS nfet L=0.15U W=0.42U
+ AS=0.12495P AD=0.06405P PS=1.015U PD=0.725U
* device instance $205 r0 *1 37.088,-125.965 nfet
M$205 \$208 \$207 \$230 GND|VGND|VSS nfet L=0.15U W=0.42U AS=0.06405P
+ AD=0.1092P PS=0.725U PD=1.36U
* device instance $206 r0 *1 38.128,-126.08 nfet
M$206 B|D|PH_B4|Q|S \$208 GND|VGND|VSS GND|VGND|VSS nfet L=0.15U W=0.65U
+ AS=0.2087P AD=0.169P PS=2.02U PD=1.82U
* device instance $207 r0 *1 48.728,-125.995 nfet
M$207 \$209 D|PH_B2|Q|S GND|VGND|VSS GND|VGND|VSS nfet L=0.15U W=0.42U
+ AS=0.1092P AD=0.0693P PS=1.36U PD=0.75U
* device instance $208 r0 *1 49.208,-125.995 nfet
M$208 GND|VGND|VSS C|D|PH_B3|Q|S \$209 GND|VGND|VSS nfet L=0.15U W=0.42U
+ AS=0.0693P AD=0.0567P PS=0.75U PD=0.69U
* device instance $209 r0 *1 49.628,-125.995 nfet
M$209 \$209 B|D|PH_B4|Q|S GND|VGND|VSS GND|VGND|VSS nfet L=0.15U W=0.42U
+ AS=0.0567P AD=0.0567P PS=0.69U PD=0.69U
* device instance $210 r0 *1 50.048,-125.995 nfet
M$210 \$209 A|D|PH_B5|Q|S GND|VGND|VSS GND|VGND|VSS nfet L=0.15U W=0.42U
+ AS=0.101875P AD=0.0567P PS=0.99U PD=0.69U
* device instance $211 r0 *1 50.538,-126.08 nfet
M$211 B|X \$209 GND|VGND|VSS GND|VGND|VSS nfet L=0.15U W=0.65U AS=0.101875P
+ AD=0.1755P PS=0.99U PD=1.84U
* device instance $212 r0 *1 52.613,-126.08 nfet
M$212 D|PH_SAMPLE|SAMPLE|Y A|B|BUSY|X GND|VGND|VSS GND|VGND|VSS nfet L=0.15U
+ W=0.65U AS=0.169P AD=0.169P PS=1.82U PD=1.82U
* device instance $213 r0 *1 53.798,-125.995 nfet
M$213 GND|VGND|VSS C|X \$213 GND|VGND|VSS nfet L=0.15U W=0.42U AS=0.1092P
+ AD=0.0567P PS=1.36U PD=0.69U
* device instance $214 r0 *1 54.218,-125.995 nfet
M$214 \$213 B|X GND|VGND|VSS GND|VGND|VSS nfet L=0.15U W=0.42U AS=0.0567P
+ AD=0.0567P PS=0.69U PD=0.69U
* device instance $215 r0 *1 54.638,-125.995 nfet
M$215 \$213 A|X GND|VGND|VSS GND|VGND|VSS nfet L=0.15U W=0.42U AS=0.101875P
+ AD=0.0567P PS=0.99U PD=0.69U
* device instance $216 r0 *1 55.128,-126.08 nfet
M$216 A|B|BUSY|X \$213 GND|VGND|VSS GND|VGND|VSS nfet L=0.15U W=0.65U
+ AS=0.101875P AD=0.182P PS=0.99U PD=1.86U
* device instance $217 r0 *1 56.088,-126.08 nfet
M$217 GND|VGND|VSS \$215 D|X$6 GND|VGND|VSS nfet L=0.15U W=0.65U AS=0.169P
+ AD=0.11285P PS=1.82U PD=1.045U
* device instance $218 r0 *1 56.633,-125.965 nfet
M$218 \$226 A|A_N|D|PH_B9|Q|S GND|VGND|VSS GND|VGND|VSS nfet L=0.15U W=0.42U
+ AS=0.11285P AD=0.0693P PS=1.045U PD=0.75U
* device instance $219 r0 *1 57.113,-125.965 nfet
M$219 \$215 A1|COMP_OUT|OUTP \$226 GND|VGND|VSS nfet L=0.15U W=0.42U AS=0.0693P
+ AD=0.09975P PS=0.75U PD=0.895U
* device instance $220 r0 *1 57.738,-125.965 nfet
M$220 \$225 A|A0|B|DOUT9|Q \$215 GND|VGND|VSS nfet L=0.15U W=0.42U AS=0.09975P
+ AD=0.0693P PS=0.895U PD=0.75U
* device instance $221 r0 *1 58.218,-125.965 nfet
M$221 GND|VGND|VSS \$216 \$225 GND|VGND|VSS nfet L=0.15U W=0.42U AS=0.0693P
+ AD=0.1449P PS=0.75U PD=1.11U
* device instance $222 r0 *1 59.058,-125.965 nfet
M$222 \$216 A|A_N|D|PH_B9|Q|S GND|VGND|VSS GND|VGND|VSS nfet L=0.15U W=0.42U
+ AS=0.1449P AD=0.1092P PS=1.11U PD=1.36U
* device instance $223 r0 *1 28.488,-125.075 nfet
M$223 GND|VGND|VSS CLK|X \$231 GND|VGND|VSS nfet L=0.15U W=0.42U AS=0.1092P
+ AD=0.0567P PS=1.36U PD=0.69U
* device instance $224 r0 *1 28.908,-125.075 nfet
M$224 \$232 \$231 GND|VGND|VSS GND|VGND|VSS nfet L=0.15U W=0.42U AS=0.0567P
+ AD=0.1092P PS=0.69U PD=1.36U
* device instance $225 r0 *1 30.658,-125.105 nfet
M$225 \$234 \$231 \$233 GND|VGND|VSS nfet L=0.15U W=0.36U AS=0.066P AD=0.0594P
+ PS=0.745U PD=0.69U
* device instance $226 r0 *1 31.138,-125.105 nfet
M$226 \$247 \$232 \$234 GND|VGND|VSS nfet L=0.15U W=0.36U AS=0.0594P AD=0.1401P
+ PS=0.69U PD=1.1U
* device instance $227 r0 *1 33.483,-125.105 nfet
M$227 \$237 \$232 \$236 GND|VGND|VSS nfet L=0.15U W=0.36U AS=0.0999P AD=0.0711P
+ PS=0.985U PD=0.755U
* device instance $228 r0 *1 34.028,-125.105 nfet
M$228 \$249 \$231 \$237 GND|VGND|VSS nfet L=0.15U W=0.36U AS=0.0711P AD=0.0669P
+ PS=0.755U PD=0.75U
* device instance $229 r0 *1 30.183,-125.075 nfet
M$229 \$233 B|D|PH_B4|Q|S GND|VGND|VSS GND|VGND|VSS nfet L=0.15U W=0.42U
+ AS=0.2205P AD=0.066P PS=1.89U PD=0.745U
* device instance $230 r0 *1 31.968,-125.075 nfet
M$230 \$248 \$236 \$247 GND|VGND|VSS nfet L=0.15U W=0.42U AS=0.1401P AD=0.0441P
+ PS=1.1U PD=0.63U
* device instance $231 r0 *1 32.328,-125.075 nfet
M$231 GND|VGND|VSS RESET_B|RST_B \$248 GND|VGND|VSS nfet L=0.15U W=0.42U
+ AS=0.0441P AD=0.1346P PS=0.63U PD=1.15U
* device instance $232 r0 *1 34.508,-125.075 nfet
M$232 GND|VGND|VSS \$238 \$249 GND|VGND|VSS nfet L=0.15U W=0.42U AS=0.0669P
+ AD=0.12495P PS=0.75U PD=1.015U
* device instance $233 r0 *1 35.253,-125.075 nfet
M$233 \$251 RESET_B|RST_B GND|VGND|VSS GND|VGND|VSS nfet L=0.15U W=0.42U
+ AS=0.12495P AD=0.06405P PS=1.015U PD=0.725U
* device instance $234 r0 *1 35.708,-125.075 nfet
M$234 \$238 \$237 \$251 GND|VGND|VSS nfet L=0.15U W=0.42U AS=0.06405P
+ AD=0.1092P PS=0.725U PD=1.36U
* device instance $235 r0 *1 32.988,-124.965 nfet
M$235 \$236 \$234 GND|VGND|VSS GND|VGND|VSS nfet L=0.15U W=0.64U AS=0.1346P
+ AD=0.0999P PS=1.15U PD=0.985U
* device instance $236 r0 *1 36.748,-124.96 nfet
M$236 C|D|PH_B3|Q|S \$238 GND|VGND|VSS GND|VGND|VSS nfet L=0.15U W=0.65U
+ AS=0.2087P AD=0.169P PS=2.02U PD=1.82U
* device instance $237 r0 *1 49.188,-125.075 nfet
M$237 GND|VGND|VSS CLK|X \$239 GND|VGND|VSS nfet L=0.15U W=0.42U AS=0.1092P
+ AD=0.0567P PS=1.36U PD=0.69U
* device instance $238 r0 *1 49.608,-125.075 nfet
M$238 \$240 \$239 GND|VGND|VSS GND|VGND|VSS nfet L=0.15U W=0.42U AS=0.0567P
+ AD=0.1092P PS=0.69U PD=1.36U
* device instance $239 r0 *1 51.358,-125.105 nfet
M$239 \$242 \$239 \$241 GND|VGND|VSS nfet L=0.15U W=0.36U AS=0.066P AD=0.0594P
+ PS=0.745U PD=0.69U
* device instance $240 r0 *1 51.838,-125.105 nfet
M$240 \$252 \$240 \$242 GND|VGND|VSS nfet L=0.15U W=0.36U AS=0.0594P AD=0.1401P
+ PS=0.69U PD=1.1U
* device instance $241 r0 *1 54.183,-125.105 nfet
M$241 \$245 \$240 \$244 GND|VGND|VSS nfet L=0.15U W=0.36U AS=0.0999P AD=0.0711P
+ PS=0.985U PD=0.755U
* device instance $242 r0 *1 54.728,-125.105 nfet
M$242 \$255 \$239 \$245 GND|VGND|VSS nfet L=0.15U W=0.36U AS=0.0711P AD=0.0669P
+ PS=0.755U PD=0.75U
* device instance $243 r0 *1 50.883,-125.075 nfet
M$243 \$241 D|X$6 GND|VGND|VSS GND|VGND|VSS nfet L=0.15U W=0.42U AS=0.2205P
+ AD=0.066P PS=1.89U PD=0.745U
* device instance $244 r0 *1 52.668,-125.075 nfet
M$244 \$253 \$244 \$252 GND|VGND|VSS nfet L=0.15U W=0.42U AS=0.1401P AD=0.0441P
+ PS=1.1U PD=0.63U
* device instance $245 r0 *1 53.028,-125.075 nfet
M$245 GND|VGND|VSS RESET_B|RST_B \$253 GND|VGND|VSS nfet L=0.15U W=0.42U
+ AS=0.0441P AD=0.1346P PS=0.63U PD=1.15U
* device instance $246 r0 *1 55.208,-125.075 nfet
M$246 GND|VGND|VSS \$246 \$255 GND|VGND|VSS nfet L=0.15U W=0.42U AS=0.0669P
+ AD=0.12495P PS=0.75U PD=1.015U
* device instance $247 r0 *1 55.953,-125.075 nfet
M$247 \$256 RESET_B|RST_B GND|VGND|VSS GND|VGND|VSS nfet L=0.15U W=0.42U
+ AS=0.12495P AD=0.06405P PS=1.015U PD=0.725U
* device instance $248 r0 *1 56.408,-125.075 nfet
M$248 \$246 \$245 \$256 GND|VGND|VSS nfet L=0.15U W=0.42U AS=0.06405P
+ AD=0.1092P PS=0.725U PD=1.36U
* device instance $249 r0 *1 53.688,-124.965 nfet
M$249 \$244 \$242 GND|VGND|VSS GND|VGND|VSS nfet L=0.15U W=0.64U AS=0.1346P
+ AD=0.0999P PS=1.15U PD=0.985U
* device instance $250 r0 *1 57.448,-124.96 nfet
M$250 A|A0|B|DOUT9|Q \$246 GND|VGND|VSS GND|VGND|VSS nfet L=0.15U W=0.65U
+ AS=0.2087P AD=0.169P PS=2.02U PD=1.82U
* device instance $251 r0 *1 32.168,-120.64 nfet
M$251 GND|VGND|VSS \$258 D|X$7 GND|VGND|VSS nfet L=0.15U W=0.65U AS=0.169P
+ AD=0.11285P PS=1.82U PD=1.045U
* device instance $252 r0 *1 32.713,-120.525 nfet
M$252 \$289 B|D|PH_B4|Q|S GND|VGND|VSS GND|VGND|VSS nfet L=0.15U W=0.42U
+ AS=0.11285P AD=0.0693P PS=1.045U PD=0.75U
* device instance $253 r0 *1 33.193,-120.525 nfet
M$253 \$258 A1|COMP_OUT|OUTP \$289 GND|VGND|VSS nfet L=0.15U W=0.42U AS=0.0693P
+ AD=0.09975P PS=0.75U PD=0.895U
* device instance $254 r0 *1 33.818,-120.525 nfet
M$254 \$290 A|A0|B|DOUT4|Q \$258 GND|VGND|VSS nfet L=0.15U W=0.42U AS=0.09975P
+ AD=0.0693P PS=0.895U PD=0.75U
* device instance $255 r0 *1 34.298,-120.525 nfet
M$255 GND|VGND|VSS \$259 \$290 GND|VGND|VSS nfet L=0.15U W=0.42U AS=0.0693P
+ AD=0.1449P PS=0.75U PD=1.11U
* device instance $256 r0 *1 35.138,-120.525 nfet
M$256 \$259 B|D|PH_B4|Q|S GND|VGND|VSS GND|VGND|VSS nfet L=0.15U W=0.42U
+ AS=0.1449P AD=0.1092P PS=1.11U PD=1.36U
* device instance $257 r0 *1 36.308,-120.525 nfet
M$257 GND|VGND|VSS CLK|X \$260 GND|VGND|VSS nfet L=0.15U W=0.42U AS=0.1092P
+ AD=0.0567P PS=1.36U PD=0.69U
* device instance $258 r0 *1 36.728,-120.525 nfet
M$258 \$261 \$260 GND|VGND|VSS GND|VGND|VSS nfet L=0.15U W=0.42U AS=0.0567P
+ AD=0.1092P PS=0.69U PD=1.36U
* device instance $259 r0 *1 38.003,-120.525 nfet
M$259 \$262 D|PH_B2|Q|S GND|VGND|VSS GND|VGND|VSS nfet L=0.15U W=0.42U
+ AS=0.2205P AD=0.066P PS=1.89U PD=0.745U
* device instance $260 r0 *1 38.478,-120.495 nfet
M$260 \$263 \$260 \$262 GND|VGND|VSS nfet L=0.15U W=0.36U AS=0.066P AD=0.0594P
+ PS=0.745U PD=0.69U
* device instance $261 r0 *1 38.958,-120.495 nfet
M$261 \$263 \$261 \$294 GND|VGND|VSS nfet L=0.15U W=0.36U AS=0.1401P AD=0.0594P
+ PS=1.1U PD=0.69U
* device instance $262 r0 *1 39.788,-120.525 nfet
M$262 \$293 \$265 \$294 GND|VGND|VSS nfet L=0.15U W=0.42U AS=0.1401P AD=0.0441P
+ PS=1.1U PD=0.63U
* device instance $263 r0 *1 40.148,-120.525 nfet
M$263 \$293 RESET_B|RST_B GND|VGND|VSS GND|VGND|VSS nfet L=0.15U W=0.42U
+ AS=0.1346P AD=0.0441P PS=1.15U PD=0.63U
* device instance $264 r0 *1 40.808,-120.635 nfet
M$264 \$265 \$263 GND|VGND|VSS GND|VGND|VSS nfet L=0.15U W=0.64U AS=0.1346P
+ AD=0.0999P PS=1.15U PD=0.985U
* device instance $265 r0 *1 41.303,-120.495 nfet
M$265 \$266 \$261 \$265 GND|VGND|VSS nfet L=0.15U W=0.36U AS=0.0999P AD=0.0711P
+ PS=0.985U PD=0.755U
* device instance $266 r0 *1 41.848,-120.495 nfet
M$266 \$266 \$260 \$295 GND|VGND|VSS nfet L=0.15U W=0.36U AS=0.0669P AD=0.0711P
+ PS=0.75U PD=0.755U
* device instance $267 r0 *1 42.328,-120.525 nfet
M$267 GND|VGND|VSS \$267 \$295 GND|VGND|VSS nfet L=0.15U W=0.42U AS=0.0669P
+ AD=0.12495P PS=0.75U PD=1.015U
* device instance $268 r0 *1 43.073,-120.525 nfet
M$268 \$296 RESET_B|RST_B GND|VGND|VSS GND|VGND|VSS nfet L=0.15U W=0.42U
+ AS=0.12495P AD=0.06405P PS=1.015U PD=0.725U
* device instance $269 r0 *1 43.528,-120.525 nfet
M$269 \$267 \$266 \$296 GND|VGND|VSS nfet L=0.15U W=0.42U AS=0.06405P
+ AD=0.1092P PS=0.725U PD=1.36U
* device instance $270 r0 *1 44.568,-120.64 nfet
M$270 A|D|PH_B1|Q|S \$267 GND|VGND|VSS GND|VGND|VSS nfet L=0.15U W=0.65U
+ AS=0.2087P AD=0.169P PS=2.02U PD=1.82U
* device instance $271 r0 *1 47.348,-120.64 nfet
M$271 GND|VGND|VSS \$269 D|X$8 GND|VGND|VSS nfet L=0.15U W=0.65U AS=0.169P
+ AD=0.11285P PS=1.82U PD=1.045U
* device instance $272 r0 *1 47.893,-120.525 nfet
M$272 \$298 A|D|PH_B1|Q|S GND|VGND|VSS GND|VGND|VSS nfet L=0.15U W=0.42U
+ AS=0.11285P AD=0.0693P PS=1.045U PD=0.75U
* device instance $273 r0 *1 48.373,-120.525 nfet
M$273 \$269 A1|COMP_OUT|OUTP \$298 GND|VGND|VSS nfet L=0.15U W=0.42U AS=0.0693P
+ AD=0.09975P PS=0.75U PD=0.895U
* device instance $274 r0 *1 48.998,-120.525 nfet
M$274 \$297 A|A0|B|DOUT1|Q \$269 GND|VGND|VSS nfet L=0.15U W=0.42U AS=0.09975P
+ AD=0.0693P PS=0.895U PD=0.75U
* device instance $275 r0 *1 49.478,-120.525 nfet
M$275 GND|VGND|VSS \$272 \$297 GND|VGND|VSS nfet L=0.15U W=0.42U AS=0.0693P
+ AD=0.1449P PS=0.75U PD=1.11U
* device instance $276 r0 *1 50.318,-120.525 nfet
M$276 \$272 A|D|PH_B1|Q|S GND|VGND|VSS GND|VGND|VSS nfet L=0.15U W=0.42U
+ AS=0.1449P AD=0.1092P PS=1.11U PD=1.36U
* device instance $277 r0 *1 52.408,-120.64 nfet
M$277 GND|VGND|VSS \$274 D|X$9 GND|VGND|VSS nfet L=0.15U W=0.65U AS=0.169P
+ AD=0.11285P PS=1.82U PD=1.045U
* device instance $278 r0 *1 52.953,-120.525 nfet
M$278 \$292 B|D|PH_B0|Q|S GND|VGND|VSS GND|VGND|VSS nfet L=0.15U W=0.42U
+ AS=0.11285P AD=0.0693P PS=1.045U PD=0.75U
* device instance $279 r0 *1 53.433,-120.525 nfet
M$279 \$274 A1|COMP_OUT|OUTP \$292 GND|VGND|VSS nfet L=0.15U W=0.42U AS=0.0693P
+ AD=0.09975P PS=0.75U PD=0.895U
* device instance $280 r0 *1 54.058,-120.525 nfet
M$280 \$291 A|A0|B|DOUT0|Q \$274 GND|VGND|VSS nfet L=0.15U W=0.42U AS=0.09975P
+ AD=0.0693P PS=0.895U PD=0.75U
* device instance $281 r0 *1 54.538,-120.525 nfet
M$281 GND|VGND|VSS \$277 \$291 GND|VGND|VSS nfet L=0.15U W=0.42U AS=0.0693P
+ AD=0.1449P PS=0.75U PD=1.11U
* device instance $282 r0 *1 55.378,-120.525 nfet
M$282 \$277 B|D|PH_B0|Q|S GND|VGND|VSS GND|VGND|VSS nfet L=0.15U W=0.42U
+ AS=0.1449P AD=0.1092P PS=1.11U PD=1.36U
* device instance $283 r0 *1 56.558,-120.555 nfet
M$283 GND|VGND|VSS C|PH_EOC|Q \$279 GND|VGND|VSS nfet L=0.15U W=0.42U
+ AS=0.1092P AD=0.0567P PS=1.36U PD=0.69U
* device instance $284 r0 *1 56.978,-120.555 nfet
M$284 \$279 B|D|PH_B0|Q|S GND|VGND|VSS GND|VGND|VSS nfet L=0.15U W=0.42U
+ AS=0.0567P AD=0.0567P PS=0.69U PD=0.69U
* device instance $285 r0 *1 57.398,-120.555 nfet
M$285 \$279 A|D|PH_B1|Q|S GND|VGND|VSS GND|VGND|VSS nfet L=0.15U W=0.42U
+ AS=0.101875P AD=0.0567P PS=0.99U PD=0.69U
* device instance $286 r0 *1 57.888,-120.64 nfet
M$286 C|X \$279 GND|VGND|VSS GND|VGND|VSS nfet L=0.15U W=0.65U AS=0.101875P
+ AD=0.182P PS=0.99U PD=1.86U
* device instance $287 r0 *1 28.488,-119.635 nfet
M$287 GND|VGND|VSS CLK|X \$299 GND|VGND|VSS nfet L=0.15U W=0.42U AS=0.1092P
+ AD=0.0567P PS=1.36U PD=0.69U
* device instance $288 r0 *1 28.908,-119.635 nfet
M$288 \$300 \$299 GND|VGND|VSS GND|VGND|VSS nfet L=0.15U W=0.42U AS=0.0567P
+ AD=0.1092P PS=0.69U PD=1.36U
* device instance $289 r0 *1 30.658,-119.665 nfet
M$289 \$302 \$299 \$301 GND|VGND|VSS nfet L=0.15U W=0.36U AS=0.066P AD=0.0594P
+ PS=0.745U PD=0.69U
* device instance $290 r0 *1 31.138,-119.665 nfet
M$290 \$316 \$300 \$302 GND|VGND|VSS nfet L=0.15U W=0.36U AS=0.0594P AD=0.1401P
+ PS=0.69U PD=1.1U
* device instance $291 r0 *1 33.483,-119.665 nfet
M$291 \$305 \$300 \$304 GND|VGND|VSS nfet L=0.15U W=0.36U AS=0.0999P AD=0.0711P
+ PS=0.985U PD=0.755U
* device instance $292 r0 *1 34.028,-119.665 nfet
M$292 \$318 \$299 \$305 GND|VGND|VSS nfet L=0.15U W=0.36U AS=0.0711P AD=0.0669P
+ PS=0.755U PD=0.75U
* device instance $293 r0 *1 30.183,-119.635 nfet
M$293 \$301 D|X$4 GND|VGND|VSS GND|VGND|VSS nfet L=0.15U W=0.42U AS=0.2205P
+ AD=0.066P PS=1.89U PD=0.745U
* device instance $294 r0 *1 31.968,-119.635 nfet
M$294 \$315 \$304 \$316 GND|VGND|VSS nfet L=0.15U W=0.42U AS=0.1401P AD=0.0441P
+ PS=1.1U PD=0.63U
* device instance $295 r0 *1 32.328,-119.635 nfet
M$295 GND|VGND|VSS RESET_B|RST_B \$315 GND|VGND|VSS nfet L=0.15U W=0.42U
+ AS=0.0441P AD=0.1346P PS=0.63U PD=1.15U
* device instance $296 r0 *1 34.508,-119.635 nfet
M$296 GND|VGND|VSS \$306 \$318 GND|VGND|VSS nfet L=0.15U W=0.42U AS=0.0669P
+ AD=0.12495P PS=0.75U PD=1.015U
* device instance $297 r0 *1 35.253,-119.635 nfet
M$297 \$319 RESET_B|RST_B GND|VGND|VSS GND|VGND|VSS nfet L=0.15U W=0.42U
+ AS=0.12495P AD=0.06405P PS=1.015U PD=0.725U
* device instance $298 r0 *1 35.708,-119.635 nfet
M$298 \$306 \$305 \$319 GND|VGND|VSS nfet L=0.15U W=0.42U AS=0.06405P
+ AD=0.1092P PS=0.725U PD=1.36U
* device instance $299 r0 *1 32.988,-119.525 nfet
M$299 \$304 \$302 GND|VGND|VSS GND|VGND|VSS nfet L=0.15U W=0.64U AS=0.1346P
+ AD=0.0999P PS=1.15U PD=0.985U
* device instance $300 r0 *1 36.748,-119.52 nfet
M$300 A|A0|B|DOUT3|Q \$306 GND|VGND|VSS GND|VGND|VSS nfet L=0.15U W=0.65U
+ AS=0.2087P AD=0.169P PS=2.02U PD=1.82U
* device instance $301 r0 *1 37.668,-115.2 nfet
M$301 A|A0|B|DOUT4|Q \$332 GND|VGND|VSS GND|VGND|VSS nfet L=0.15U W=0.65U
+ AS=0.2087P AD=0.169P PS=2.02U PD=1.82U
* device instance $302 r0 *1 38.608,-115.2 nfet
M$302 GND|VGND|VSS A|X$1 \$333 GND|VGND|VSS nfet L=0.15U W=0.65U AS=0.169P
+ AD=0.08775P PS=1.82U PD=0.92U
* device instance $303 r0 *1 39.028,-115.2 nfet
M$303 CLK|X \$333 GND|VGND|VSS GND|VGND|VSS nfet L=0.15U W=0.65U AS=0.08775P
+ AD=0.08775P PS=0.92U PD=0.92U
* device instance $304 r0 *1 39.448,-115.2 nfet
M$304 GND|VGND|VSS \$333 CLK|X GND|VGND|VSS nfet L=0.15U W=0.65U AS=0.08775P
+ AD=0.08775P PS=0.92U PD=0.92U
* device instance $305 r0 *1 39.868,-115.2 nfet
M$305 CLK|X \$333 GND|VGND|VSS GND|VGND|VSS nfet L=0.15U W=0.65U AS=0.08775P
+ AD=0.08775P PS=0.92U PD=0.92U
* device instance $306 r0 *1 40.288,-115.2 nfet
M$306 GND|VGND|VSS \$333 CLK|X GND|VGND|VSS nfet L=0.15U W=0.65U AS=0.08775P
+ AD=0.169P PS=0.92U PD=1.82U
* device instance $307 r0 *1 49.648,-119.635 nfet
M$307 GND|VGND|VSS CLK|X \$307 GND|VGND|VSS nfet L=0.15U W=0.42U AS=0.1092P
+ AD=0.0567P PS=1.36U PD=0.69U
* device instance $308 r0 *1 50.068,-119.635 nfet
M$308 \$308 \$307 GND|VGND|VSS GND|VGND|VSS nfet L=0.15U W=0.42U AS=0.0567P
+ AD=0.1092P PS=0.69U PD=1.36U
* device instance $309 r0 *1 50.548,-115.2 nfet
M$309 B|D|PH_B0|Q|S \$341 GND|VGND|VSS GND|VGND|VSS nfet L=0.15U W=0.65U
+ AS=0.2087P AD=0.169P PS=2.02U PD=1.82U
* device instance $310 r0 *1 51.818,-119.665 nfet
M$310 \$310 \$307 \$309 GND|VGND|VSS nfet L=0.15U W=0.36U AS=0.066P AD=0.0594P
+ PS=0.745U PD=0.69U
* device instance $311 r0 *1 52.298,-119.665 nfet
M$311 \$320 \$308 \$310 GND|VGND|VSS nfet L=0.15U W=0.36U AS=0.0594P AD=0.1401P
+ PS=0.69U PD=1.1U
* device instance $312 r0 *1 54.643,-119.665 nfet
M$312 \$313 \$308 \$312 GND|VGND|VSS nfet L=0.15U W=0.36U AS=0.0999P AD=0.0711P
+ PS=0.985U PD=0.755U
* device instance $313 r0 *1 55.188,-119.665 nfet
M$313 \$323 \$307 \$313 GND|VGND|VSS nfet L=0.15U W=0.36U AS=0.0711P AD=0.0669P
+ PS=0.755U PD=0.75U
* device instance $314 r0 *1 51.343,-119.635 nfet
M$314 \$309 B|D|PH_B0|Q|S GND|VGND|VSS GND|VGND|VSS nfet L=0.15U W=0.42U
+ AS=0.2205P AD=0.066P PS=1.89U PD=0.745U
* device instance $315 r0 *1 53.128,-119.635 nfet
M$315 \$321 \$312 \$320 GND|VGND|VSS nfet L=0.15U W=0.42U AS=0.1401P AD=0.0441P
+ PS=1.1U PD=0.63U
* device instance $316 r0 *1 53.488,-119.635 nfet
M$316 GND|VGND|VSS RESET_B|RST_B \$321 GND|VGND|VSS nfet L=0.15U W=0.42U
+ AS=0.0441P AD=0.1346P PS=0.63U PD=1.15U
* device instance $317 r0 *1 55.668,-119.635 nfet
M$317 GND|VGND|VSS \$314 \$323 GND|VGND|VSS nfet L=0.15U W=0.42U AS=0.0669P
+ AD=0.12495P PS=0.75U PD=1.015U
* device instance $318 r0 *1 56.413,-119.635 nfet
M$318 \$324 RESET_B|RST_B GND|VGND|VSS GND|VGND|VSS nfet L=0.15U W=0.42U
+ AS=0.12495P AD=0.06405P PS=1.015U PD=0.725U
* device instance $319 r0 *1 56.868,-119.635 nfet
M$319 \$314 \$313 \$324 GND|VGND|VSS nfet L=0.15U W=0.42U AS=0.06405P
+ AD=0.1092P PS=0.725U PD=1.36U
* device instance $320 r0 *1 54.148,-119.525 nfet
M$320 \$312 \$310 GND|VGND|VSS GND|VGND|VSS nfet L=0.15U W=0.64U AS=0.1346P
+ AD=0.0999P PS=1.15U PD=0.985U
* device instance $321 r0 *1 57.908,-119.52 nfet
M$321 C|PH_EOC|Q \$314 GND|VGND|VSS GND|VGND|VSS nfet L=0.15U W=0.65U
+ AS=0.2087P AD=0.169P PS=2.02U PD=1.82U
* device instance $322 r0 *1 60.208,-115.2 nfet
M$322 A|A0|B|DOUT1|Q \$349 GND|VGND|VSS GND|VGND|VSS nfet L=0.15U W=0.65U
+ AS=0.2087P AD=0.169P PS=2.02U PD=1.82U
* device instance $323 r0 *1 29.408,-115.085 nfet
M$323 GND|VGND|VSS CLK|X \$325 GND|VGND|VSS nfet L=0.15U W=0.42U AS=0.1092P
+ AD=0.0567P PS=1.36U PD=0.69U
* device instance $324 r0 *1 29.828,-115.085 nfet
M$324 \$326 \$325 GND|VGND|VSS GND|VGND|VSS nfet L=0.15U W=0.42U AS=0.0567P
+ AD=0.1092P PS=0.69U PD=1.36U
* device instance $325 r0 *1 31.103,-115.085 nfet
M$325 \$327 D|X$7 GND|VGND|VSS GND|VGND|VSS nfet L=0.15U W=0.42U AS=0.2205P
+ AD=0.066P PS=1.89U PD=0.745U
* device instance $326 r0 *1 31.578,-115.055 nfet
M$326 \$328 \$325 \$327 GND|VGND|VSS nfet L=0.15U W=0.36U AS=0.066P AD=0.0594P
+ PS=0.745U PD=0.69U
* device instance $327 r0 *1 32.058,-115.055 nfet
M$327 \$328 \$326 \$358 GND|VGND|VSS nfet L=0.15U W=0.36U AS=0.1401P AD=0.0594P
+ PS=1.1U PD=0.69U
* device instance $328 r0 *1 32.888,-115.085 nfet
M$328 \$359 \$330 \$358 GND|VGND|VSS nfet L=0.15U W=0.42U AS=0.1401P AD=0.0441P
+ PS=1.1U PD=0.63U
* device instance $329 r0 *1 33.248,-115.085 nfet
M$329 \$359 RESET_B|RST_B GND|VGND|VSS GND|VGND|VSS nfet L=0.15U W=0.42U
+ AS=0.1346P AD=0.0441P PS=1.15U PD=0.63U
* device instance $330 r0 *1 33.908,-115.195 nfet
M$330 \$330 \$328 GND|VGND|VSS GND|VGND|VSS nfet L=0.15U W=0.64U AS=0.1346P
+ AD=0.0999P PS=1.15U PD=0.985U
* device instance $331 r0 *1 34.403,-115.055 nfet
M$331 \$331 \$326 \$330 GND|VGND|VSS nfet L=0.15U W=0.36U AS=0.0999P AD=0.0711P
+ PS=0.985U PD=0.755U
* device instance $332 r0 *1 34.948,-115.055 nfet
M$332 \$331 \$325 \$362 GND|VGND|VSS nfet L=0.15U W=0.36U AS=0.0669P AD=0.0711P
+ PS=0.75U PD=0.755U
* device instance $333 r0 *1 35.428,-115.085 nfet
M$333 GND|VGND|VSS \$332 \$362 GND|VGND|VSS nfet L=0.15U W=0.42U AS=0.0669P
+ AD=0.12495P PS=0.75U PD=1.015U
* device instance $334 r0 *1 36.173,-115.085 nfet
M$334 \$364 RESET_B|RST_B GND|VGND|VSS GND|VGND|VSS nfet L=0.15U W=0.42U
+ AS=0.12495P AD=0.06405P PS=1.015U PD=0.725U
* device instance $335 r0 *1 36.628,-115.085 nfet
M$335 \$332 \$331 \$364 GND|VGND|VSS nfet L=0.15U W=0.42U AS=0.06405P
+ AD=0.1092P PS=0.725U PD=1.36U
* device instance $336 r0 *1 42.288,-115.085 nfet
M$336 GND|VGND|VSS CLK|X \$334 GND|VGND|VSS nfet L=0.15U W=0.42U AS=0.1092P
+ AD=0.0567P PS=1.36U PD=0.69U
* device instance $337 r0 *1 42.708,-115.085 nfet
M$337 \$335 \$334 GND|VGND|VSS GND|VGND|VSS nfet L=0.15U W=0.42U AS=0.0567P
+ AD=0.1092P PS=0.69U PD=1.36U
* device instance $338 r0 *1 43.983,-115.085 nfet
M$338 \$336 A|D|PH_B1|Q|S GND|VGND|VSS GND|VGND|VSS nfet L=0.15U W=0.42U
+ AS=0.2205P AD=0.066P PS=1.89U PD=0.745U
* device instance $339 r0 *1 44.458,-115.055 nfet
M$339 \$337 \$334 \$336 GND|VGND|VSS nfet L=0.15U W=0.36U AS=0.066P AD=0.0594P
+ PS=0.745U PD=0.69U
* device instance $340 r0 *1 44.938,-115.055 nfet
M$340 \$337 \$335 \$363 GND|VGND|VSS nfet L=0.15U W=0.36U AS=0.1401P AD=0.0594P
+ PS=1.1U PD=0.69U
* device instance $341 r0 *1 45.768,-115.085 nfet
M$341 \$361 \$339 \$363 GND|VGND|VSS nfet L=0.15U W=0.42U AS=0.1401P AD=0.0441P
+ PS=1.1U PD=0.63U
* device instance $342 r0 *1 46.128,-115.085 nfet
M$342 \$361 RESET_B|RST_B GND|VGND|VSS GND|VGND|VSS nfet L=0.15U W=0.42U
+ AS=0.1346P AD=0.0441P PS=1.15U PD=0.63U
* device instance $343 r0 *1 46.788,-115.195 nfet
M$343 \$339 \$337 GND|VGND|VSS GND|VGND|VSS nfet L=0.15U W=0.64U AS=0.1346P
+ AD=0.0999P PS=1.15U PD=0.985U
* device instance $344 r0 *1 47.283,-115.055 nfet
M$344 \$340 \$335 \$339 GND|VGND|VSS nfet L=0.15U W=0.36U AS=0.0999P AD=0.0711P
+ PS=0.985U PD=0.755U
* device instance $345 r0 *1 47.828,-115.055 nfet
M$345 \$340 \$334 \$360 GND|VGND|VSS nfet L=0.15U W=0.36U AS=0.0669P AD=0.0711P
+ PS=0.75U PD=0.755U
* device instance $346 r0 *1 48.308,-115.085 nfet
M$346 GND|VGND|VSS \$341 \$360 GND|VGND|VSS nfet L=0.15U W=0.42U AS=0.0669P
+ AD=0.12495P PS=0.75U PD=1.015U
* device instance $347 r0 *1 49.053,-115.085 nfet
M$347 \$357 RESET_B|RST_B GND|VGND|VSS GND|VGND|VSS nfet L=0.15U W=0.42U
+ AS=0.12495P AD=0.06405P PS=1.015U PD=0.725U
* device instance $348 r0 *1 49.508,-115.085 nfet
M$348 \$341 \$340 \$357 GND|VGND|VSS nfet L=0.15U W=0.42U AS=0.06405P
+ AD=0.1092P PS=0.725U PD=1.36U
* device instance $349 r0 *1 51.948,-115.085 nfet
M$349 GND|VGND|VSS CLK|X \$342 GND|VGND|VSS nfet L=0.15U W=0.42U AS=0.1092P
+ AD=0.0567P PS=1.36U PD=0.69U
* device instance $350 r0 *1 52.368,-115.085 nfet
M$350 \$343 \$342 GND|VGND|VSS GND|VGND|VSS nfet L=0.15U W=0.42U AS=0.0567P
+ AD=0.1092P PS=0.69U PD=1.36U
* device instance $351 r0 *1 53.643,-115.085 nfet
M$351 \$344 D|X$8 GND|VGND|VSS GND|VGND|VSS nfet L=0.15U W=0.42U AS=0.2205P
+ AD=0.066P PS=1.89U PD=0.745U
* device instance $352 r0 *1 54.118,-115.055 nfet
M$352 \$345 \$342 \$344 GND|VGND|VSS nfet L=0.15U W=0.36U AS=0.066P AD=0.0594P
+ PS=0.745U PD=0.69U
* device instance $353 r0 *1 54.598,-115.055 nfet
M$353 \$345 \$343 \$356 GND|VGND|VSS nfet L=0.15U W=0.36U AS=0.1401P AD=0.0594P
+ PS=1.1U PD=0.69U
* device instance $354 r0 *1 55.428,-115.085 nfet
M$354 \$355 \$347 \$356 GND|VGND|VSS nfet L=0.15U W=0.42U AS=0.1401P AD=0.0441P
+ PS=1.1U PD=0.63U
* device instance $355 r0 *1 55.788,-115.085 nfet
M$355 \$355 RESET_B|RST_B GND|VGND|VSS GND|VGND|VSS nfet L=0.15U W=0.42U
+ AS=0.1346P AD=0.0441P PS=1.15U PD=0.63U
* device instance $356 r0 *1 56.448,-115.195 nfet
M$356 \$347 \$345 GND|VGND|VSS GND|VGND|VSS nfet L=0.15U W=0.64U AS=0.1346P
+ AD=0.0999P PS=1.15U PD=0.985U
* device instance $357 r0 *1 56.943,-115.055 nfet
M$357 \$348 \$343 \$347 GND|VGND|VSS nfet L=0.15U W=0.36U AS=0.0999P AD=0.0711P
+ PS=0.985U PD=0.755U
* device instance $358 r0 *1 57.488,-115.055 nfet
M$358 \$348 \$342 \$354 GND|VGND|VSS nfet L=0.15U W=0.36U AS=0.0669P AD=0.0711P
+ PS=0.75U PD=0.755U
* device instance $359 r0 *1 57.968,-115.085 nfet
M$359 GND|VGND|VSS \$349 \$354 GND|VGND|VSS nfet L=0.15U W=0.42U AS=0.0669P
+ AD=0.12495P PS=0.75U PD=1.015U
* device instance $360 r0 *1 58.713,-115.085 nfet
M$360 \$353 RESET_B|RST_B GND|VGND|VSS GND|VGND|VSS nfet L=0.15U W=0.42U
+ AS=0.12495P AD=0.06405P PS=1.015U PD=0.725U
* device instance $361 r0 *1 59.168,-115.085 nfet
M$361 \$349 \$348 \$353 GND|VGND|VSS nfet L=0.15U W=0.42U AS=0.06405P
+ AD=0.1092P PS=0.725U PD=1.36U
* device instance $362 r0 *1 28.488,-114.195 nfet
M$362 GND|VGND|VSS CLK|X \$365 GND|VGND|VSS nfet L=0.15U W=0.42U AS=0.1092P
+ AD=0.0567P PS=1.36U PD=0.69U
* device instance $363 r0 *1 28.908,-114.195 nfet
M$363 \$366 \$365 GND|VGND|VSS GND|VGND|VSS nfet L=0.15U W=0.42U AS=0.0567P
+ AD=0.1092P PS=0.69U PD=1.36U
* device instance $364 r0 *1 30.658,-114.225 nfet
M$364 \$368 \$365 \$367 GND|VGND|VSS nfet L=0.15U W=0.36U AS=0.066P AD=0.0594P
+ PS=0.745U PD=0.69U
* device instance $365 r0 *1 31.138,-114.225 nfet
M$365 \$381 \$366 \$368 GND|VGND|VSS nfet L=0.15U W=0.36U AS=0.0594P AD=0.1401P
+ PS=0.69U PD=1.1U
* device instance $366 r0 *1 33.483,-114.225 nfet
M$366 \$371 \$366 \$370 GND|VGND|VSS nfet L=0.15U W=0.36U AS=0.0999P AD=0.0711P
+ PS=0.985U PD=0.755U
* device instance $367 r0 *1 34.028,-114.225 nfet
M$367 \$383 \$365 \$371 GND|VGND|VSS nfet L=0.15U W=0.36U AS=0.0711P AD=0.0669P
+ PS=0.755U PD=0.75U
* device instance $368 r0 *1 30.183,-114.195 nfet
M$368 \$367 C|D|PH_B3|Q|S GND|VGND|VSS GND|VGND|VSS nfet L=0.15U W=0.42U
+ AS=0.2205P AD=0.066P PS=1.89U PD=0.745U
* device instance $369 r0 *1 31.968,-114.195 nfet
M$369 \$382 \$370 \$381 GND|VGND|VSS nfet L=0.15U W=0.42U AS=0.1401P AD=0.0441P
+ PS=1.1U PD=0.63U
* device instance $370 r0 *1 32.328,-114.195 nfet
M$370 GND|VGND|VSS RESET_B|RST_B \$382 GND|VGND|VSS nfet L=0.15U W=0.42U
+ AS=0.0441P AD=0.1346P PS=0.63U PD=1.15U
* device instance $371 r0 *1 34.508,-114.195 nfet
M$371 GND|VGND|VSS \$372 \$383 GND|VGND|VSS nfet L=0.15U W=0.42U AS=0.0669P
+ AD=0.12495P PS=0.75U PD=1.015U
* device instance $372 r0 *1 35.253,-114.195 nfet
M$372 \$385 RESET_B|RST_B GND|VGND|VSS GND|VGND|VSS nfet L=0.15U W=0.42U
+ AS=0.12495P AD=0.06405P PS=1.015U PD=0.725U
* device instance $373 r0 *1 35.708,-114.195 nfet
M$373 \$372 \$371 \$385 GND|VGND|VSS nfet L=0.15U W=0.42U AS=0.06405P
+ AD=0.1092P PS=0.725U PD=1.36U
* device instance $374 r0 *1 32.988,-114.085 nfet
M$374 \$370 \$368 GND|VGND|VSS GND|VGND|VSS nfet L=0.15U W=0.64U AS=0.1346P
+ AD=0.0999P PS=1.15U PD=0.985U
* device instance $375 r0 *1 36.748,-114.08 nfet
M$375 D|PH_B2|Q|S \$372 GND|VGND|VSS GND|VGND|VSS nfet L=0.15U W=0.65U
+ AS=0.2087P AD=0.169P PS=2.02U PD=1.82U
* device instance $376 r0 *1 51.948,-114.195 nfet
M$376 GND|VGND|VSS CLK|X \$373 GND|VGND|VSS nfet L=0.15U W=0.42U AS=0.1092P
+ AD=0.0567P PS=1.36U PD=0.69U
* device instance $377 r0 *1 52.368,-114.195 nfet
M$377 \$374 \$373 GND|VGND|VSS GND|VGND|VSS nfet L=0.15U W=0.42U AS=0.0567P
+ AD=0.1092P PS=0.69U PD=1.36U
* device instance $378 r0 *1 54.118,-114.225 nfet
M$378 \$376 \$373 \$375 GND|VGND|VSS nfet L=0.15U W=0.36U AS=0.066P AD=0.0594P
+ PS=0.745U PD=0.69U
* device instance $379 r0 *1 54.598,-114.225 nfet
M$379 \$386 \$374 \$376 GND|VGND|VSS nfet L=0.15U W=0.36U AS=0.0594P AD=0.1401P
+ PS=0.69U PD=1.1U
* device instance $380 r0 *1 56.943,-114.225 nfet
M$380 \$379 \$374 \$378 GND|VGND|VSS nfet L=0.15U W=0.36U AS=0.0999P AD=0.0711P
+ PS=0.985U PD=0.755U
* device instance $381 r0 *1 57.488,-114.225 nfet
M$381 \$388 \$373 \$379 GND|VGND|VSS nfet L=0.15U W=0.36U AS=0.0711P AD=0.0669P
+ PS=0.755U PD=0.75U
* device instance $382 r0 *1 53.643,-114.195 nfet
M$382 \$375 D|X$9 GND|VGND|VSS GND|VGND|VSS nfet L=0.15U W=0.42U AS=0.2205P
+ AD=0.066P PS=1.89U PD=0.745U
* device instance $383 r0 *1 55.428,-114.195 nfet
M$383 \$387 \$378 \$386 GND|VGND|VSS nfet L=0.15U W=0.42U AS=0.1401P AD=0.0441P
+ PS=1.1U PD=0.63U
* device instance $384 r0 *1 55.788,-114.195 nfet
M$384 GND|VGND|VSS RESET_B|RST_B \$387 GND|VGND|VSS nfet L=0.15U W=0.42U
+ AS=0.0441P AD=0.1346P PS=0.63U PD=1.15U
* device instance $385 r0 *1 57.968,-114.195 nfet
M$385 GND|VGND|VSS \$380 \$388 GND|VGND|VSS nfet L=0.15U W=0.42U AS=0.0669P
+ AD=0.12495P PS=0.75U PD=1.015U
* device instance $386 r0 *1 58.713,-114.195 nfet
M$386 \$390 RESET_B|RST_B GND|VGND|VSS GND|VGND|VSS nfet L=0.15U W=0.42U
+ AS=0.12495P AD=0.06405P PS=1.015U PD=0.725U
* device instance $387 r0 *1 59.168,-114.195 nfet
M$387 \$380 \$379 \$390 GND|VGND|VSS nfet L=0.15U W=0.42U AS=0.06405P
+ AD=0.1092P PS=0.725U PD=1.36U
* device instance $388 r0 *1 56.448,-114.085 nfet
M$388 \$378 \$376 GND|VGND|VSS GND|VGND|VSS nfet L=0.15U W=0.64U AS=0.1346P
+ AD=0.0999P PS=1.15U PD=0.985U
* device instance $389 r0 *1 60.208,-114.08 nfet
M$389 A|A0|B|DOUT0|Q \$380 GND|VGND|VSS GND|VGND|VSS nfet L=0.15U W=0.65U
+ AS=0.2087P AD=0.169P PS=2.02U PD=1.82U
* device instance $390 r0 *1 98.985,-93.44 nfet
M$390 \$391 B|Y GND|VGND|VSS GND|VGND|VSS nfet L=0.15U W=0.65U AS=0.169P
+ AD=0.08775P PS=1.82U PD=0.92U
* device instance $391 r0 *1 99.405,-93.44 nfet
M$391 GND|VGND|VSS A|A0|B|DOUT8|Q \$391 GND|VGND|VSS nfet L=0.15U W=0.65U
+ AS=0.08775P AD=0.08775P PS=0.92U PD=0.92U
* device instance $392 r0 *1 99.825,-93.44 nfet
M$392 \$399 A|A0|B|DOUT8|Q GND|VGND|VSS GND|VGND|VSS nfet L=0.15U W=0.65U
+ AS=0.08775P AD=0.08775P PS=0.92U PD=0.92U
* device instance $393 r0 *1 100.245,-93.44 nfet
M$393 ADCOUT8|X B|Y \$399 GND|VGND|VSS nfet L=0.15U W=0.65U AS=0.08775P
+ AD=0.25025P PS=0.92U PD=1.42U
* device instance $394 r0 *1 101.165,-93.44 nfet
M$394 GND|VGND|VSS \$391 ADCOUT8|X GND|VGND|VSS nfet L=0.15U W=0.65U
+ AS=0.25025P AD=0.208P PS=1.42U PD=1.94U
* device instance $395 r0 *1 115.13,-92.435 nfet
M$395 \$412 A|A_N|D|PH_B9|Q|S GND|VGND|VSS GND|VGND|VSS nfet L=0.15U W=0.42U
+ AS=0.11285P AD=0.0693P PS=1.045U PD=0.75U
* device instance $396 r0 *1 115.61,-92.435 nfet
M$396 \$405 A|A1|OUTN|OUTN_NC \$412 GND|VGND|VSS nfet L=0.15U W=0.42U
+ AS=0.0693P AD=0.09975P PS=0.75U PD=0.895U
* device instance $397 r0 *1 116.235,-92.435 nfet
M$397 \$414 A|A0|B|DOUT9|Q \$405 GND|VGND|VSS nfet L=0.15U W=0.42U AS=0.09975P
+ AD=0.0693P PS=0.895U PD=0.75U
* device instance $398 r0 *1 116.715,-92.435 nfet
M$398 GND|VGND|VSS \$407 \$414 GND|VGND|VSS nfet L=0.15U W=0.42U AS=0.0693P
+ AD=0.1449P PS=0.75U PD=1.11U
* device instance $399 r0 *1 117.555,-92.435 nfet
M$399 \$407 A|A_N|D|PH_B9|Q|S GND|VGND|VSS GND|VGND|VSS nfet L=0.15U W=0.42U
+ AS=0.1449P AD=0.1092P PS=1.11U PD=1.36U
* device instance $400 r0 *1 114.585,-92.32 nfet
M$400 GND|VGND|VSS \$405 DUMLOAD_MUX_NC|X GND|VGND|VSS nfet L=0.15U W=0.65U
+ AS=0.169P AD=0.11285P PS=1.82U PD=1.045U
* device instance $401 r0 *1 127.645,-93.465 nfet
M$401 \$400 A|A0|B|DOUT1|Q \$396 GND|VGND|VSS nfet L=0.15U W=0.42U AS=0.1176P
+ AD=0.0567P PS=1.4U PD=0.69U
* device instance $402 r0 *1 128.065,-93.465 nfet
M$402 \$400 B|Y GND|VGND|VSS GND|VGND|VSS nfet L=0.15U W=0.42U AS=0.1118P
+ AD=0.0567P PS=1.04U PD=0.69U
* device instance $403 r0 *1 128.605,-93.44 nfet
M$403 SELn1|X \$396 GND|VGND|VSS GND|VGND|VSS nfet L=0.15U W=0.65U AS=0.1118P
+ AD=0.182P PS=1.04U PD=1.86U
* device instance $404 r0 *1 98.065,-88 nfet
M$404 \$417 B|Y GND|VGND|VSS GND|VGND|VSS nfet L=0.15U W=0.65U AS=0.169P
+ AD=0.08775P PS=1.82U PD=0.92U
* device instance $405 r0 *1 98.485,-88 nfet
M$405 GND|VGND|VSS A|A0|B|DOUT2|Q \$417 GND|VGND|VSS nfet L=0.15U W=0.65U
+ AS=0.08775P AD=0.08775P PS=0.92U PD=0.92U
* device instance $406 r0 *1 98.905,-88 nfet
M$406 \$446 A|A0|B|DOUT2|Q GND|VGND|VSS GND|VGND|VSS nfet L=0.15U W=0.65U
+ AS=0.08775P AD=0.08775P PS=0.92U PD=0.92U
* device instance $407 r0 *1 99.325,-88 nfet
M$407 ADCOUT2|X B|Y \$446 GND|VGND|VSS nfet L=0.15U W=0.65U AS=0.08775P
+ AD=0.25025P PS=0.92U PD=1.42U
* device instance $408 r0 *1 100.245,-88 nfet
M$408 GND|VGND|VSS \$417 ADCOUT2|X GND|VGND|VSS nfet L=0.15U W=0.65U
+ AS=0.25025P AD=0.208P PS=1.42U PD=1.94U
* device instance $409 r0 *1 102.205,-88 nfet
M$409 \$421 B|Y GND|VGND|VSS GND|VGND|VSS nfet L=0.15U W=0.65U AS=0.169P
+ AD=0.08775P PS=1.82U PD=0.92U
* device instance $410 r0 *1 102.625,-88 nfet
M$410 GND|VGND|VSS A|A0|B|DOUT3|Q \$421 GND|VGND|VSS nfet L=0.15U W=0.65U
+ AS=0.08775P AD=0.08775P PS=0.92U PD=0.92U
* device instance $411 r0 *1 103.045,-88 nfet
M$411 \$449 A|A0|B|DOUT3|Q GND|VGND|VSS GND|VGND|VSS nfet L=0.15U W=0.65U
+ AS=0.08775P AD=0.08775P PS=0.92U PD=0.92U
* device instance $412 r0 *1 103.465,-88 nfet
M$412 ADCOUT3|X B|Y \$449 GND|VGND|VSS nfet L=0.15U W=0.65U AS=0.08775P
+ AD=0.25025P PS=0.92U PD=1.42U
* device instance $413 r0 *1 104.385,-88 nfet
M$413 GND|VGND|VSS \$421 ADCOUT3|X GND|VGND|VSS nfet L=0.15U W=0.65U
+ AS=0.25025P AD=0.208P PS=1.42U PD=1.94U
* device instance $414 r0 *1 107.265,-88 nfet
M$414 \$424 B|Y GND|VGND|VSS GND|VGND|VSS nfet L=0.15U W=0.65U AS=0.169P
+ AD=0.08775P PS=1.82U PD=0.92U
* device instance $415 r0 *1 107.685,-88 nfet
M$415 GND|VGND|VSS A|A0|B|DOUT7|Q \$424 GND|VGND|VSS nfet L=0.15U W=0.65U
+ AS=0.08775P AD=0.08775P PS=0.92U PD=0.92U
* device instance $416 r0 *1 108.105,-88 nfet
M$416 \$448 A|A0|B|DOUT7|Q GND|VGND|VSS GND|VGND|VSS nfet L=0.15U W=0.65U
+ AS=0.08775P AD=0.08775P PS=0.92U PD=0.92U
* device instance $417 r0 *1 108.525,-88 nfet
M$417 ADCOUT7|X B|Y \$448 GND|VGND|VSS nfet L=0.15U W=0.65U AS=0.08775P
+ AD=0.25025P PS=0.92U PD=1.42U
* device instance $418 r0 *1 109.445,-88 nfet
M$418 GND|VGND|VSS \$424 ADCOUT7|X GND|VGND|VSS nfet L=0.15U W=0.65U
+ AS=0.25025P AD=0.208P PS=1.42U PD=1.94U
* device instance $419 r0 *1 108.785,-92.295 nfet
M$419 \$411 A|A0|B|DOUT9|Q \$402 GND|VGND|VSS nfet L=0.15U W=0.42U AS=0.1176P
+ AD=0.0567P PS=1.4U PD=0.69U
* device instance $420 r0 *1 109.205,-92.295 nfet
M$420 \$411 A|A0|B|DOUT6|Q GND|VGND|VSS GND|VGND|VSS nfet L=0.15U W=0.42U
+ AS=0.1118P AD=0.0567P PS=1.04U PD=0.69U
* device instance $421 r0 *1 109.745,-92.32 nfet
M$421 SELp6|X \$402 GND|VGND|VSS GND|VGND|VSS nfet L=0.15U W=0.65U AS=0.1118P
+ AD=0.182P PS=1.04U PD=1.86U
* device instance $422 r0 *1 120.145,-88 nfet
M$422 \$431 B|Y GND|VGND|VSS GND|VGND|VSS nfet L=0.15U W=0.65U AS=0.169P
+ AD=0.08775P PS=1.82U PD=0.92U
* device instance $423 r0 *1 120.565,-88 nfet
M$423 GND|VGND|VSS A|A0|B|DOUT4|Q \$431 GND|VGND|VSS nfet L=0.15U W=0.65U
+ AS=0.08775P AD=0.08775P PS=0.92U PD=0.92U
* device instance $424 r0 *1 120.985,-88 nfet
M$424 \$444 A|A0|B|DOUT4|Q GND|VGND|VSS GND|VGND|VSS nfet L=0.15U W=0.65U
+ AS=0.08775P AD=0.08775P PS=0.92U PD=0.92U
* device instance $425 r0 *1 121.405,-88 nfet
M$425 ADCOUT4|X B|Y \$444 GND|VGND|VSS nfet L=0.15U W=0.65U AS=0.08775P
+ AD=0.25025P PS=0.92U PD=1.42U
* device instance $426 r0 *1 122.325,-88 nfet
M$426 GND|VGND|VSS \$431 ADCOUT4|X GND|VGND|VSS nfet L=0.15U W=0.65U
+ AS=0.25025P AD=0.208P PS=1.42U PD=1.94U
* device instance $427 r0 *1 135.03,-88 nfet
M$427 B|Y A|A0|B|DOUT9|Q GND|VGND|VSS GND|VGND|VSS nfet L=0.15U W=0.65U
+ AS=0.169P AD=0.169P PS=1.82U PD=1.82U
* device instance $428 r0 *1 136.845,-92.295 nfet
M$428 \$416 A|A0|B|DOUT9|Q \$409 GND|VGND|VSS nfet L=0.15U W=0.42U AS=0.1176P
+ AD=0.0567P PS=1.4U PD=0.69U
* device instance $429 r0 *1 137.265,-92.295 nfet
M$429 \$416 A|A0|B|DOUT4|Q GND|VGND|VSS GND|VGND|VSS nfet L=0.15U W=0.42U
+ AS=0.1118P AD=0.0567P PS=1.04U PD=0.69U
* device instance $430 r0 *1 137.805,-92.32 nfet
M$430 SELp4|X \$409 GND|VGND|VSS GND|VGND|VSS nfet L=0.15U W=0.65U AS=0.1118P
+ AD=0.182P PS=1.04U PD=1.86U
* device instance $431 r0 *1 97.145,-86.88 nfet
M$431 \$450 B|Y GND|VGND|VSS GND|VGND|VSS nfet L=0.15U W=0.65U AS=0.169P
+ AD=0.08775P PS=1.82U PD=0.92U
* device instance $432 r0 *1 97.565,-86.88 nfet
M$432 GND|VGND|VSS A|A0|B|DOUT0|Q \$450 GND|VGND|VSS nfet L=0.15U W=0.65U
+ AS=0.08775P AD=0.08775P PS=0.92U PD=0.92U
* device instance $433 r0 *1 97.985,-86.88 nfet
M$433 \$471 A|A0|B|DOUT0|Q GND|VGND|VSS GND|VGND|VSS nfet L=0.15U W=0.65U
+ AS=0.08775P AD=0.08775P PS=0.92U PD=0.92U
* device instance $434 r0 *1 98.405,-86.88 nfet
M$434 ADCOUT0|X B|Y \$471 GND|VGND|VSS nfet L=0.15U W=0.65U AS=0.08775P
+ AD=0.25025P PS=0.92U PD=1.42U
* device instance $435 r0 *1 99.325,-86.88 nfet
M$435 GND|VGND|VSS \$450 ADCOUT0|X GND|VGND|VSS nfet L=0.15U W=0.65U
+ AS=0.25025P AD=0.208P PS=1.42U PD=1.94U
* device instance $436 r0 *1 102.83,-86.88 nfet
M$436 HALF_LSB_ENN|Y A|HALF_LSB_EN|X GND|VGND|VSS GND|VGND|VSS nfet L=0.15U
+ W=0.65U AS=0.169P AD=0.169P PS=1.82U PD=1.82U
* device instance $437 r0 *1 110.625,-88.025 nfet
M$437 \$447 A|A0|B|DOUT7|Q \$427 GND|VGND|VSS nfet L=0.15U W=0.42U AS=0.1176P
+ AD=0.0567P PS=1.4U PD=0.69U
* device instance $438 r0 *1 111.045,-88.025 nfet
M$438 \$447 B|Y GND|VGND|VSS GND|VGND|VSS nfet L=0.15U W=0.42U AS=0.1118P
+ AD=0.0567P PS=1.04U PD=0.69U
* device instance $439 r0 *1 111.585,-88 nfet
M$439 SELn7|X \$427 GND|VGND|VSS GND|VGND|VSS nfet L=0.15U W=0.65U AS=0.1118P
+ AD=0.182P PS=1.04U PD=1.86U
* device instance $440 r0 *1 113.765,-86.88 nfet
M$440 \$474 A|A0|B|DOUT9|Q \$459 GND|VGND|VSS nfet L=0.15U W=0.65U AS=0.169P
+ AD=0.06825P PS=1.82U PD=0.86U
* device instance $441 r0 *1 114.125,-86.88 nfet
M$441 GND|VGND|VSS A|A1|OUTN|OUTN_NC \$474 GND|VGND|VSS nfet L=0.15U W=0.65U
+ AS=0.06825P AD=0.08775P PS=0.86U PD=0.92U
* device instance $442 r0 *1 114.545,-86.88 nfet
M$442 \$458 A|A1|OUTN|OUTN_NC GND|VGND|VSS GND|VGND|VSS nfet L=0.15U W=0.65U
+ AS=0.08775P AD=0.169P PS=0.92U PD=1.82U
* device instance $443 r0 *1 115.485,-86.88 nfet
M$443 \$458 A|A0|B|DOUT9|Q GND|VGND|VSS GND|VGND|VSS nfet L=0.15U W=0.65U
+ AS=0.169P AD=0.08775P PS=1.82U PD=0.92U
* device instance $444 r0 *1 115.905,-86.88 nfet
M$444 DUMLOAD_XNOR_NC|Y \$459 \$458 GND|VGND|VSS nfet L=0.15U W=0.65U
+ AS=0.08775P AD=0.195P PS=0.92U PD=1.9U
* device instance $445 r0 *1 117.525,-88.025 nfet
M$445 \$445 A|A0|B|DOUT9|Q \$429 GND|VGND|VSS nfet L=0.15U W=0.42U AS=0.1176P
+ AD=0.0567P PS=1.4U PD=0.69U
* device instance $446 r0 *1 117.945,-88.025 nfet
M$446 \$445 A|A0|B|DOUT1|Q GND|VGND|VSS GND|VGND|VSS nfet L=0.15U W=0.42U
+ AS=0.1118P AD=0.0567P PS=1.04U PD=0.69U
* device instance $447 r0 *1 118.485,-88 nfet
M$447 SELp1|X \$429 GND|VGND|VSS GND|VGND|VSS nfet L=0.15U W=0.65U AS=0.1118P
+ AD=0.182P PS=1.04U PD=1.86U
* device instance $448 r0 *1 121.525,-86.88 nfet
M$448 \$462 B|Y GND|VGND|VSS GND|VGND|VSS nfet L=0.15U W=0.65U AS=0.169P
+ AD=0.08775P PS=1.82U PD=0.92U
* device instance $449 r0 *1 121.945,-86.88 nfet
M$449 GND|VGND|VSS A|A0|B|DOUT5|Q \$462 GND|VGND|VSS nfet L=0.15U W=0.65U
+ AS=0.08775P AD=0.08775P PS=0.92U PD=0.92U
* device instance $450 r0 *1 122.365,-86.88 nfet
M$450 \$476 A|A0|B|DOUT5|Q GND|VGND|VSS GND|VGND|VSS nfet L=0.15U W=0.65U
+ AS=0.08775P AD=0.08775P PS=0.92U PD=0.92U
* device instance $451 r0 *1 122.785,-86.88 nfet
M$451 ADCOUT5|X B|Y \$476 GND|VGND|VSS nfet L=0.15U W=0.65U AS=0.08775P
+ AD=0.25025P PS=0.92U PD=1.42U
* device instance $452 r0 *1 123.705,-86.88 nfet
M$452 GND|VGND|VSS \$462 ADCOUT5|X GND|VGND|VSS nfet L=0.15U W=0.65U
+ AS=0.25025P AD=0.208P PS=1.42U PD=1.94U
* device instance $453 r0 *1 124.91,-86.88 nfet
M$453 CLK|CLKN|Y A|CLK GND|VGND|VSS GND|VGND|VSS nfet L=0.15U W=0.65U AS=0.169P
+ AD=0.169P PS=1.82U PD=1.82U
* device instance $454 r0 *1 127.185,-88.025 nfet
M$454 \$443 A|A0|B|DOUT9|Q \$434 GND|VGND|VSS nfet L=0.15U W=0.42U AS=0.1176P
+ AD=0.0567P PS=1.4U PD=0.69U
* device instance $455 r0 *1 127.605,-88.025 nfet
M$455 \$443 A|A0|B|DOUT7|Q GND|VGND|VSS GND|VGND|VSS nfet L=0.15U W=0.42U
+ AS=0.1118P AD=0.0567P PS=1.04U PD=0.69U
* device instance $456 r0 *1 128.145,-88 nfet
M$456 SELp7|X \$434 GND|VGND|VSS GND|VGND|VSS nfet L=0.15U W=0.65U AS=0.1118P
+ AD=0.182P PS=1.04U PD=1.86U
* device instance $457 r0 *1 136.845,-88.025 nfet
M$457 \$442 A|A0|B|DOUT6|Q \$436 GND|VGND|VSS nfet L=0.15U W=0.42U AS=0.1176P
+ AD=0.0567P PS=1.4U PD=0.69U
* device instance $458 r0 *1 137.265,-88.025 nfet
M$458 \$442 B|Y GND|VGND|VSS GND|VGND|VSS nfet L=0.15U W=0.42U AS=0.1118P
+ AD=0.0567P PS=1.04U PD=0.69U
* device instance $459 r0 *1 137.805,-88 nfet
M$459 SELn6|X \$436 GND|VGND|VSS GND|VGND|VSS nfet L=0.15U W=0.65U AS=0.1118P
+ AD=0.182P PS=1.04U PD=1.86U
* device instance $460 r0 *1 107.405,-86.855 nfet
M$460 \$472 A|A0|B|DOUT9|Q \$453 GND|VGND|VSS nfet L=0.15U W=0.42U AS=0.1176P
+ AD=0.0567P PS=1.4U PD=0.69U
* device instance $461 r0 *1 107.825,-86.855 nfet
M$461 \$472 A|A0|B|DOUT0|Q GND|VGND|VSS GND|VGND|VSS nfet L=0.15U W=0.42U
+ AS=0.1118P AD=0.0567P PS=1.04U PD=0.69U
* device instance $462 r0 *1 108.365,-86.88 nfet
M$462 SELp0|X \$453 GND|VGND|VSS GND|VGND|VSS nfet L=0.15U W=0.65U AS=0.1118P
+ AD=0.182P PS=1.04U PD=1.86U
* device instance $463 r0 *1 110.165,-86.855 nfet
M$463 \$473 A|A0|B|DOUT3|Q \$455 GND|VGND|VSS nfet L=0.15U W=0.42U AS=0.1176P
+ AD=0.0567P PS=1.4U PD=0.69U
* device instance $464 r0 *1 110.585,-86.855 nfet
M$464 \$473 B|Y GND|VGND|VSS GND|VGND|VSS nfet L=0.15U W=0.42U AS=0.1118P
+ AD=0.0567P PS=1.04U PD=0.69U
* device instance $465 r0 *1 111.125,-86.88 nfet
M$465 SELn3|X \$455 GND|VGND|VSS GND|VGND|VSS nfet L=0.15U W=0.65U AS=0.1118P
+ AD=0.182P PS=1.04U PD=1.86U
* device instance $466 r0 *1 118.305,-82.56 nfet
M$466 \$491 B|Y GND|VGND|VSS GND|VGND|VSS nfet L=0.15U W=0.65U AS=0.169P
+ AD=0.08775P PS=1.82U PD=0.92U
* device instance $467 r0 *1 118.725,-82.56 nfet
M$467 GND|VGND|VSS A|A0|B|DOUT1|Q \$491 GND|VGND|VSS nfet L=0.15U W=0.65U
+ AS=0.08775P AD=0.08775P PS=0.92U PD=0.92U
* device instance $468 r0 *1 119.145,-82.56 nfet
M$468 \$511 A|A0|B|DOUT1|Q GND|VGND|VSS GND|VGND|VSS nfet L=0.15U W=0.65U
+ AS=0.08775P AD=0.08775P PS=0.92U PD=0.92U
* device instance $469 r0 *1 119.565,-82.56 nfet
M$469 ADCOUT1|X B|Y \$511 GND|VGND|VSS nfet L=0.15U W=0.65U AS=0.08775P
+ AD=0.25025P PS=0.92U PD=1.42U
* device instance $470 r0 *1 120.485,-82.56 nfet
M$470 GND|VGND|VSS \$491 ADCOUT1|X GND|VGND|VSS nfet L=0.15U W=0.65U
+ AS=0.25025P AD=0.208P PS=1.42U PD=1.94U
* device instance $471 r0 *1 119.365,-86.855 nfet
M$471 \$475 A|A0|B|DOUT2|Q \$460 GND|VGND|VSS nfet L=0.15U W=0.42U AS=0.1176P
+ AD=0.0567P PS=1.4U PD=0.69U
* device instance $472 r0 *1 119.785,-86.855 nfet
M$472 \$475 B|Y GND|VGND|VSS GND|VGND|VSS nfet L=0.15U W=0.42U AS=0.1118P
+ AD=0.0567P PS=1.04U PD=0.69U
* device instance $473 r0 *1 120.325,-86.88 nfet
M$473 SELn2|X \$460 GND|VGND|VSS GND|VGND|VSS nfet L=0.15U W=0.65U AS=0.1118P
+ AD=0.182P PS=1.04U PD=1.86U
* device instance $474 r0 *1 122.445,-82.56 nfet
M$474 \$494 B|Y GND|VGND|VSS GND|VGND|VSS nfet L=0.15U W=0.65U AS=0.169P
+ AD=0.08775P PS=1.82U PD=0.92U
* device instance $475 r0 *1 122.865,-82.56 nfet
M$475 GND|VGND|VSS A|A0|B|DOUT6|Q \$494 GND|VGND|VSS nfet L=0.15U W=0.65U
+ AS=0.08775P AD=0.08775P PS=0.92U PD=0.92U
* device instance $476 r0 *1 123.285,-82.56 nfet
M$476 \$510 A|A0|B|DOUT6|Q GND|VGND|VSS GND|VGND|VSS nfet L=0.15U W=0.65U
+ AS=0.08775P AD=0.08775P PS=0.92U PD=0.92U
* device instance $477 r0 *1 123.705,-82.56 nfet
M$477 ADCOUT6|X B|Y \$510 GND|VGND|VSS nfet L=0.15U W=0.65U AS=0.08775P
+ AD=0.25025P PS=0.92U PD=1.42U
* device instance $478 r0 *1 124.625,-82.56 nfet
M$478 GND|VGND|VSS \$494 ADCOUT6|X GND|VGND|VSS nfet L=0.15U W=0.65U
+ AS=0.25025P AD=0.208P PS=1.42U PD=1.94U
* device instance $479 r0 *1 128.565,-86.855 nfet
M$479 \$477 A|A0|B|DOUT9|Q \$465 GND|VGND|VSS nfet L=0.15U W=0.42U AS=0.1176P
+ AD=0.0567P PS=1.4U PD=0.69U
* device instance $480 r0 *1 128.985,-86.855 nfet
M$480 \$477 A|A0|B|DOUT8|Q GND|VGND|VSS GND|VGND|VSS nfet L=0.15U W=0.42U
+ AS=0.1118P AD=0.0567P PS=1.04U PD=0.69U
* device instance $481 r0 *1 129.525,-86.88 nfet
M$481 SELp8|X \$465 GND|VGND|VSS GND|VGND|VSS nfet L=0.15U W=0.65U AS=0.1118P
+ AD=0.182P PS=1.04U PD=1.86U
* device instance $482 r0 *1 132.245,-86.855 nfet
M$482 \$479 A|A0|B|DOUT9|Q \$467 GND|VGND|VSS nfet L=0.15U W=0.42U AS=0.1176P
+ AD=0.0567P PS=1.4U PD=0.69U
* device instance $483 r0 *1 132.665,-86.855 nfet
M$483 \$479 A|A0|B|DOUT3|Q GND|VGND|VSS GND|VGND|VSS nfet L=0.15U W=0.42U
+ AS=0.1118P AD=0.0567P PS=1.04U PD=0.69U
* device instance $484 r0 *1 133.205,-86.88 nfet
M$484 SELp3|X \$467 GND|VGND|VSS GND|VGND|VSS nfet L=0.15U W=0.65U AS=0.1118P
+ AD=0.182P PS=1.04U PD=1.86U
* device instance $485 r0 *1 135.925,-86.855 nfet
M$485 \$478 A|A0|B|DOUT5|Q \$469 GND|VGND|VSS nfet L=0.15U W=0.42U AS=0.1176P
+ AD=0.0567P PS=1.4U PD=0.69U
* device instance $486 r0 *1 136.345,-86.855 nfet
M$486 \$478 B|Y GND|VGND|VSS GND|VGND|VSS nfet L=0.15U W=0.42U AS=0.1118P
+ AD=0.0567P PS=1.04U PD=0.69U
* device instance $487 r0 *1 136.885,-86.88 nfet
M$487 SELn5|X \$469 GND|VGND|VSS GND|VGND|VSS nfet L=0.15U W=0.65U AS=0.1118P
+ AD=0.182P PS=1.04U PD=1.86U
* device instance $488 r0 *1 4.545,-29.5 nfet
M$488 \$516 SELp0|X VREFN GND|VGND|VSS nfet L=0.15U W=1U AS=0.47P AD=0.47P
+ PS=2.94U PD=2.94U
* device instance $489 r0 *1 15.545,-29.5 nfet
M$489 \$517 SELp1|X VREFN GND|VGND|VSS nfet L=0.15U W=1U AS=0.47P AD=0.47P
+ PS=2.94U PD=2.94U
* device instance $490 r0 *1 26.545,-29.5 nfet
M$490 \$518 SELp2|X VREFN GND|VGND|VSS nfet L=0.15U W=1U AS=0.47P AD=0.47P
+ PS=2.94U PD=2.94U
* device instance $491 r0 *1 37.545,-29.5 nfet
M$491 \$519 SELp3|X VREFN GND|VGND|VSS nfet L=0.15U W=1U AS=0.47P AD=0.47P
+ PS=2.94U PD=2.94U
* device instance $492 r0 *1 48.545,-29.5 nfet
M$492 \$520 SELp4|X VREFN GND|VGND|VSS nfet L=0.15U W=1U AS=0.47P AD=0.47P
+ PS=2.94U PD=2.94U
* device instance $493 r0 *1 59.545,-29.5 nfet
M$493 \$521 SELp5|X VREFN GND|VGND|VSS nfet L=0.15U W=1U AS=0.47P AD=0.47P
+ PS=2.94U PD=2.94U
* device instance $494 r0 *1 70.545,-29.5 nfet
M$494 \$534 SELp6|X VREFN GND|VGND|VSS nfet L=0.15U W=1U AS=0.47P AD=0.47P
+ PS=2.94U PD=2.94U
* device instance $495 r0 *1 81.545,-29.5 nfet
M$495 \$533 SELp7|X VREFN GND|VGND|VSS nfet L=0.15U W=1U AS=0.47P AD=0.47P
+ PS=2.94U PD=2.94U
* device instance $496 r0 *1 92.545,-29.5 nfet
M$496 \$532 SELp8|X VREFN GND|VGND|VSS nfet L=0.15U W=1U AS=0.47P AD=0.47P
+ PS=2.94U PD=2.94U
* device instance $497 r0 *1 101.885,-82.585 nfet
M$497 \$506 A|A0|B|DOUT8|Q \$485 GND|VGND|VSS nfet L=0.15U W=0.42U AS=0.1176P
+ AD=0.0567P PS=1.4U PD=0.69U
* device instance $498 r0 *1 102.305,-82.585 nfet
M$498 \$506 B|Y GND|VGND|VSS GND|VGND|VSS nfet L=0.15U W=0.42U AS=0.1118P
+ AD=0.0567P PS=1.04U PD=0.69U
* device instance $499 r0 *1 102.845,-82.56 nfet
M$499 SELn8|X \$485 GND|VGND|VSS GND|VGND|VSS nfet L=0.15U W=0.65U AS=0.1118P
+ AD=0.182P PS=1.04U PD=1.86U
* device instance $500 r0 *1 103.545,-29.5 nfet
M$500 \$522 SELn0|X VREFN GND|VGND|VSS nfet L=0.15U W=1U AS=0.47P AD=0.47P
+ PS=2.94U PD=2.94U
* device instance $501 r0 *1 108.325,-82.585 nfet
M$501 \$508 A|A0|B|DOUT9|Q \$487 GND|VGND|VSS nfet L=0.15U W=0.42U AS=0.1176P
+ AD=0.0567P PS=1.4U PD=0.69U
* device instance $502 r0 *1 108.745,-82.585 nfet
M$502 \$508 A|A0|B|DOUT2|Q GND|VGND|VSS GND|VGND|VSS nfet L=0.15U W=0.42U
+ AS=0.1118P AD=0.0567P PS=1.04U PD=0.69U
* device instance $503 r0 *1 109.285,-82.56 nfet
M$503 SELp2|X \$487 GND|VGND|VSS GND|VGND|VSS nfet L=0.15U W=0.65U AS=0.1118P
+ AD=0.182P PS=1.04U PD=1.86U
* device instance $504 r0 *1 114.545,-29.5 nfet
M$504 \$523 SELn1|X VREFN GND|VGND|VSS nfet L=0.15U W=1U AS=0.47P AD=0.47P
+ PS=2.94U PD=2.94U
* device instance $505 r0 *1 114.585,-82.445 nfet
M$505 \$489 A|A_N|D|PH_B9|Q|S GND|VGND|VSS GND|VGND|VSS nfet L=0.15U W=0.42U
+ AS=0.1092P AD=0.1092P PS=1.36U PD=1.36U
* device instance $506 r0 *1 115.525,-82.445 nfet
M$506 \$512 \$489 \$490 GND|VGND|VSS nfet L=0.15U W=0.42U AS=0.1092P AD=0.0504P
+ PS=1.36U PD=0.66U
* device instance $507 r0 *1 115.915,-82.445 nfet
M$507 \$512 A|B|BUSY|X GND|VGND|VSS GND|VGND|VSS nfet L=0.15U W=0.42U
+ AS=0.1013P AD=0.0504P PS=0.99U PD=0.66U
* device instance $508 r0 *1 116.405,-82.56 nfet
M$508 A|HALF_LSB_EN|X \$490 GND|VGND|VSS GND|VGND|VSS nfet L=0.15U W=0.65U
+ AS=0.1013P AD=0.169P PS=0.99U PD=1.82U
* device instance $509 r0 *1 125.545,-29.5 nfet
M$509 \$524 SELn2|X VREFN GND|VGND|VSS nfet L=0.15U W=1U AS=0.47P AD=0.47P
+ PS=2.94U PD=2.94U
* device instance $510 r0 *1 128.565,-82.585 nfet
M$510 \$509 A|A0|B|DOUT9|Q \$497 GND|VGND|VSS nfet L=0.15U W=0.42U AS=0.1176P
+ AD=0.0567P PS=1.4U PD=0.69U
* device instance $511 r0 *1 128.985,-82.585 nfet
M$511 \$509 A|A0|B|DOUT5|Q GND|VGND|VSS GND|VGND|VSS nfet L=0.15U W=0.42U
+ AS=0.1118P AD=0.0567P PS=1.04U PD=0.69U
* device instance $512 r0 *1 129.525,-82.56 nfet
M$512 SELp5|X \$497 GND|VGND|VSS GND|VGND|VSS nfet L=0.15U W=0.65U AS=0.1118P
+ AD=0.182P PS=1.04U PD=1.86U
* device instance $513 r0 *1 132.245,-82.585 nfet
M$513 \$507 A|A0|B|DOUT0|Q \$499 GND|VGND|VSS nfet L=0.15U W=0.42U AS=0.1176P
+ AD=0.0567P PS=1.4U PD=0.69U
* device instance $514 r0 *1 132.665,-82.585 nfet
M$514 \$507 B|Y GND|VGND|VSS GND|VGND|VSS nfet L=0.15U W=0.42U AS=0.1118P
+ AD=0.0567P PS=1.04U PD=0.69U
* device instance $515 r0 *1 133.205,-82.56 nfet
M$515 SELn0|X \$499 GND|VGND|VSS GND|VGND|VSS nfet L=0.15U W=0.65U AS=0.1118P
+ AD=0.182P PS=1.04U PD=1.86U
* device instance $516 r0 *1 136.385,-82.585 nfet
M$516 \$505 A|A0|B|DOUT4|Q \$501 GND|VGND|VSS nfet L=0.15U W=0.42U AS=0.1176P
+ AD=0.0567P PS=1.4U PD=0.69U
* device instance $517 r0 *1 136.805,-82.585 nfet
M$517 \$505 B|Y GND|VGND|VSS GND|VGND|VSS nfet L=0.15U W=0.42U AS=0.1118P
+ AD=0.0567P PS=1.04U PD=0.69U
* device instance $518 r0 *1 137.345,-82.56 nfet
M$518 SELn4|X \$501 GND|VGND|VSS GND|VGND|VSS nfet L=0.15U W=0.65U AS=0.1118P
+ AD=0.182P PS=1.04U PD=1.86U
* device instance $519 r0 *1 136.545,-29.5 nfet
M$519 \$525 SELn3|X VREFN GND|VGND|VSS nfet L=0.15U W=1U AS=0.47P AD=0.47P
+ PS=2.94U PD=2.94U
* device instance $520 r0 *1 147.545,-29.5 nfet
M$520 \$526 SELn4|X VREFN GND|VGND|VSS nfet L=0.15U W=1U AS=0.47P AD=0.47P
+ PS=2.94U PD=2.94U
* device instance $521 r0 *1 158.545,-29.5 nfet
M$521 \$531 SELn5|X VREFN GND|VGND|VSS nfet L=0.15U W=1U AS=0.47P AD=0.47P
+ PS=2.94U PD=2.94U
* device instance $522 r0 *1 169.545,-29.5 nfet
M$522 \$530 SELn6|X VREFN GND|VGND|VSS nfet L=0.15U W=1U AS=0.47P AD=0.47P
+ PS=2.94U PD=2.94U
* device instance $523 r0 *1 180.545,-29.5 nfet
M$523 \$529 SELn7|X VREFN GND|VGND|VSS nfet L=0.15U W=1U AS=0.47P AD=0.47P
+ PS=2.94U PD=2.94U
* device instance $524 r0 *1 191.545,-29.5 nfet
M$524 \$528 SELn8|X VREFN GND|VGND|VSS nfet L=0.15U W=1U AS=0.47P AD=0.47P
+ PS=2.94U PD=2.94U
* device instance $525 r0 *1 102.87,193.8 nfet
M$525 \$553 CLK|CLKN|Y GND|VGND|VSS GND|VGND|VSS nfet L=0.5U W=8U AS=3.36P
+ AD=3.36P PS=16.84U PD=16.84U
* device instance $526 r0 *1 106.37,192.19 nfet
M$526 \$551 TOP_N|VINN \$553 GND|VGND|VSS nfet L=0.5U W=2U AS=0.84P AD=0.84P
+ PS=4.84U PD=4.84U
* device instance $527 r0 *1 106.37,195.41 nfet
M$527 \$552 TOP_P|VINP \$553 GND|VGND|VSS nfet L=0.5U W=2U AS=0.84P AD=0.84P
+ PS=4.84U PD=4.84U
* device instance $528 r0 *1 106.84,89.25 nfet
M$528 VINP \$542 TOP_P|VINP GND|VGND|VSS nfet L=0.15U W=2U AS=0.94P AD=0.94P
+ PS=4.94U PD=4.94U
* device instance $529 r0 *1 108.11,195.41 nfet
M$529 \$551 TOP_N|VINN \$553 GND|VGND|VSS nfet L=0.5U W=2U AS=0.84P AD=0.84P
+ PS=4.84U PD=4.84U
* device instance $530 r0 *1 108.11,192.19 nfet
M$530 \$552 TOP_P|VINP \$553 GND|VGND|VSS nfet L=0.5U W=2U AS=0.84P AD=0.84P
+ PS=4.84U PD=4.84U
* device instance $531 r0 *1 109.13,89.25 nfet
M$531 VINN \$548 TOP_N|VINN GND|VGND|VSS nfet L=0.15U W=2U AS=0.94P AD=0.94P
+ PS=4.94U PD=4.94U
* device instance $532 r0 *1 111.57,191.19 nfet
M$532 A1|COMP_OUT|OUTP A|A1|OUTN|OUTN_NC \$551 GND|VGND|VSS nfet L=0.5U W=4U
+ AS=1.68P AD=1.68P PS=8.84U PD=8.84U
* device instance $533 r0 *1 111.57,196.41 nfet
M$533 A|A1|OUTN|OUTN_NC A1|COMP_OUT|OUTP \$552 GND|VGND|VSS nfet L=0.5U W=4U
+ AS=1.68P AD=1.68P PS=8.84U PD=8.84U
* device instance $534 r0 *1 111.42,88.75 nfet
M$534 \$545 \$543 GND|VGND|VSS GND|VGND|VSS nfet L=0.15U W=1U AS=0.47P AD=0.47P
+ PS=2.94U PD=2.94U
* device instance $535 r0 *1 113.71,88.75 nfet
M$535 \$545 D|PH_SAMPLE|SAMPLE|Y VINP GND|VGND|VSS nfet L=0.15U W=1U AS=0.47P
+ AD=0.47P PS=2.94U PD=2.94U
* device instance $536 r0 *1 116.125,88.75 nfet
M$536 \$542 \$543 GND|VGND|VSS GND|VGND|VSS nfet L=0.5U W=1U AS=0.42P AD=0.42P
+ PS=2.84U PD=2.84U
* device instance $537 r0 *1 118.54,96.25 nfet
M$537 BPREF_P D|PH_SAMPLE|SAMPLE|Y VCM GND|VGND|VSS nfet L=0.15U W=16U AS=7.52P
+ AD=7.52P PS=32.94U PD=32.94U
* device instance $538 r0 *1 120.83,96.25 nfet
M$538 BPREF_N D|PH_SAMPLE|SAMPLE|Y VCM GND|VGND|VSS nfet L=0.15U W=16U AS=7.52P
+ AD=7.52P PS=32.94U PD=32.94U
* device instance $539 r0 *1 123.245,88.75 nfet
M$539 \$548 \$543 GND|VGND|VSS GND|VGND|VSS nfet L=0.5U W=1U AS=0.42P AD=0.42P
+ PS=2.84U PD=2.84U
* device instance $540 r0 *1 125.196,67.5 nfet
M$540 BOT_OFF_N A|HALF_LSB_EN|X VCM GND|VGND|VSS nfet L=0.15U W=1U AS=0.47P
+ AD=0.47P PS=2.94U PD=2.94U
* device instance $541 r0 *1 125.66,88.75 nfet
M$541 \$547 D|PH_SAMPLE|SAMPLE|Y VINN GND|VGND|VSS nfet L=0.15U W=1U AS=0.47P
+ AD=0.47P PS=2.94U PD=2.94U
* device instance $542 r0 *1 127.95,88.75 nfet
M$542 \$547 \$543 GND|VGND|VSS GND|VGND|VSS nfet L=0.15U W=1U AS=0.47P AD=0.47P
+ PS=2.94U PD=2.94U
* device instance $543 r0 *1 130.24,88.75 nfet
M$543 \$543 D|PH_SAMPLE|SAMPLE|Y GND|VGND|VSS GND|VGND|VSS nfet L=0.15U W=1U
+ AS=0.47P AD=0.47P PS=2.94U PD=2.94U
* device instance $544 r0 *1 141.196,67.5 nfet
M$544 BOT_OFF_P GND|VGND|VSS VCM GND|VGND|VSS nfet L=0.15U W=1U AS=0.47P
+ AD=0.47P PS=2.94U PD=2.94U
* device instance $545 r0 *1 60.208,-145.295 pfet
M$545 C|D|PH_B7|Q|S \$11 VPB|VPWR VPB|VPWR pfet L=0.15U W=1U AS=0.3012P
+ AD=0.26P PS=2.66U PD=2.52U
* device instance $546 r0 *1 56.828,-145.215 pfet
M$546 \$9 \$7 VPB|VPWR VPB|VPWR pfet L=0.15U W=0.84U AS=0.2184P AD=0.12915P
+ PS=2.2U PD=1.185U
* device instance $547 r0 *1 57.323,-145.005 pfet
M$547 \$10 \$3 \$9 VPB|VPWR pfet L=0.15U W=0.42U AS=0.12915P AD=0.0588P
+ PS=1.185U PD=0.7U
* device instance $548 r0 *1 57.753,-145.005 pfet
M$548 \$17 \$4 \$10 VPB|VPWR pfet L=0.15U W=0.42U AS=0.0588P AD=0.0567P PS=0.7U
+ PD=0.69U
* device instance $549 r0 *1 58.173,-145.005 pfet
M$549 VPB|VPWR \$11 \$17 VPB|VPWR pfet L=0.15U W=0.42U AS=0.0567P AD=0.0819P
+ PS=0.69U PD=0.81U
* device instance $550 r0 *1 58.713,-145.005 pfet
M$550 \$11 RESET_B|RST_B VPB|VPWR VPB|VPWR pfet L=0.15U W=0.42U AS=0.0819P
+ AD=0.0567P PS=0.81U PD=0.69U
* device instance $551 r0 *1 59.133,-145.005 pfet
M$551 VPB|VPWR \$10 \$11 VPB|VPWR pfet L=0.15U W=0.42U AS=0.0567P AD=0.1134P
+ PS=0.69U PD=1.38U
* device instance $552 r0 *1 51.948,-145.145 pfet
M$552 VPB|VPWR A|CLK|X \$3 VPB|VPWR pfet L=0.15U W=0.64U AS=0.1664P AD=0.0864P
+ PS=1.8U PD=0.91U
* device instance $553 r0 *1 52.368,-145.145 pfet
M$553 \$4 \$3 VPB|VPWR VPB|VPWR pfet L=0.15U W=0.64U AS=0.0864P AD=0.1664P
+ PS=0.91U PD=1.8U
* device instance $554 r0 *1 53.703,-145.005 pfet
M$554 \$6 B|D|PH_B8|Q|S VPB|VPWR VPB|VPWR pfet L=0.15U W=0.42U AS=0.1092P
+ AD=0.0651P PS=1.36U PD=0.73U
* device instance $555 r0 *1 54.163,-145.005 pfet
M$555 \$7 \$4 \$6 VPB|VPWR pfet L=0.15U W=0.42U AS=0.0651P AD=0.07245P PS=0.73U
+ PD=0.765U
* device instance $556 r0 *1 54.658,-145.005 pfet
M$556 \$8 \$3 \$7 VPB|VPWR pfet L=0.15U W=0.42U AS=0.07245P AD=0.1155P
+ PS=0.765U PD=0.97U
* device instance $557 r0 *1 55.358,-145.005 pfet
M$557 VPB|VPWR \$9 \$8 VPB|VPWR pfet L=0.15U W=0.42U AS=0.1155P AD=0.07035P
+ PS=0.97U PD=0.755U
* device instance $558 r0 *1 55.843,-145.005 pfet
M$558 \$8 RESET_B|RST_B VPB|VPWR VPB|VPWR pfet L=0.15U W=0.42U AS=0.07035P
+ AD=0.1092P PS=0.755U PD=1.36U
* device instance $559 r0 *1 37.143,-144.115 pfet
M$559 \$21 D|X VPB|VPWR VPB|VPWR pfet L=0.15U W=0.42U AS=0.1092P AD=0.0651P
+ PS=1.36U PD=0.73U
* device instance $560 r0 *1 37.603,-144.115 pfet
M$560 \$22 \$19 \$21 VPB|VPWR pfet L=0.15U W=0.42U AS=0.0651P AD=0.07245P
+ PS=0.73U PD=0.765U
* device instance $561 r0 *1 38.098,-144.115 pfet
M$561 \$23 \$18 \$22 VPB|VPWR pfet L=0.15U W=0.42U AS=0.07245P AD=0.1155P
+ PS=0.765U PD=0.97U
* device instance $562 r0 *1 38.798,-144.115 pfet
M$562 VPB|VPWR \$25 \$23 VPB|VPWR pfet L=0.15U W=0.42U AS=0.1155P AD=0.07035P
+ PS=0.97U PD=0.755U
* device instance $563 r0 *1 39.283,-144.115 pfet
M$563 \$23 RESET_B|RST_B VPB|VPWR VPB|VPWR pfet L=0.15U W=0.42U AS=0.07035P
+ AD=0.1092P PS=0.755U PD=1.36U
* device instance $564 r0 *1 40.763,-144.115 pfet
M$564 \$26 \$18 \$25 VPB|VPWR pfet L=0.15U W=0.42U AS=0.12915P AD=0.0588P
+ PS=1.185U PD=0.7U
* device instance $565 r0 *1 41.193,-144.115 pfet
M$565 \$41 \$19 \$26 VPB|VPWR pfet L=0.15U W=0.42U AS=0.0588P AD=0.0567P
+ PS=0.7U PD=0.69U
* device instance $566 r0 *1 41.613,-144.115 pfet
M$566 VPB|VPWR \$27 \$41 VPB|VPWR pfet L=0.15U W=0.42U AS=0.0567P AD=0.0819P
+ PS=0.69U PD=0.81U
* device instance $567 r0 *1 42.153,-144.115 pfet
M$567 \$27 RESET_B|RST_B VPB|VPWR VPB|VPWR pfet L=0.15U W=0.42U AS=0.0819P
+ AD=0.0567P PS=0.81U PD=0.69U
* device instance $568 r0 *1 42.573,-144.115 pfet
M$568 VPB|VPWR \$26 \$27 VPB|VPWR pfet L=0.15U W=0.42U AS=0.0567P AD=0.1134P
+ PS=0.69U PD=1.38U
* device instance $569 r0 *1 40.268,-143.905 pfet
M$569 \$25 \$22 VPB|VPWR VPB|VPWR pfet L=0.15U W=0.84U AS=0.2184P AD=0.12915P
+ PS=2.2U PD=1.185U
* device instance $570 r0 *1 43.648,-143.825 pfet
M$570 A|A0|B|DOUT6|Q \$27 VPB|VPWR VPB|VPWR pfet L=0.15U W=1U AS=0.3012P
+ AD=0.26P PS=2.66U PD=2.52U
* device instance $571 r0 *1 53.703,-144.115 pfet
M$571 \$32 D|X$1 VPB|VPWR VPB|VPWR pfet L=0.15U W=0.42U AS=0.1092P AD=0.0651P
+ PS=1.36U PD=0.73U
* device instance $572 r0 *1 54.163,-144.115 pfet
M$572 \$33 \$30 \$32 VPB|VPWR pfet L=0.15U W=0.42U AS=0.0651P AD=0.07245P
+ PS=0.73U PD=0.765U
* device instance $573 r0 *1 54.658,-144.115 pfet
M$573 \$34 \$29 \$33 VPB|VPWR pfet L=0.15U W=0.42U AS=0.07245P AD=0.1155P
+ PS=0.765U PD=0.97U
* device instance $574 r0 *1 55.358,-144.115 pfet
M$574 VPB|VPWR \$35 \$34 VPB|VPWR pfet L=0.15U W=0.42U AS=0.1155P AD=0.07035P
+ PS=0.97U PD=0.755U
* device instance $575 r0 *1 55.843,-144.115 pfet
M$575 \$34 RESET_B|RST_B VPB|VPWR VPB|VPWR pfet L=0.15U W=0.42U AS=0.07035P
+ AD=0.1092P PS=0.755U PD=1.36U
* device instance $576 r0 *1 57.323,-144.115 pfet
M$576 \$36 \$29 \$35 VPB|VPWR pfet L=0.15U W=0.42U AS=0.12915P AD=0.0588P
+ PS=1.185U PD=0.7U
* device instance $577 r0 *1 57.753,-144.115 pfet
M$577 \$45 \$30 \$36 VPB|VPWR pfet L=0.15U W=0.42U AS=0.0588P AD=0.0567P
+ PS=0.7U PD=0.69U
* device instance $578 r0 *1 58.173,-144.115 pfet
M$578 VPB|VPWR \$37 \$45 VPB|VPWR pfet L=0.15U W=0.42U AS=0.0567P AD=0.0819P
+ PS=0.69U PD=0.81U
* device instance $579 r0 *1 58.713,-144.115 pfet
M$579 \$37 RESET_B|RST_B VPB|VPWR VPB|VPWR pfet L=0.15U W=0.42U AS=0.0819P
+ AD=0.0567P PS=0.81U PD=0.69U
* device instance $580 r0 *1 59.133,-144.115 pfet
M$580 VPB|VPWR \$36 \$37 VPB|VPWR pfet L=0.15U W=0.42U AS=0.0567P AD=0.1134P
+ PS=0.69U PD=1.38U
* device instance $581 r0 *1 56.828,-143.905 pfet
M$581 \$35 \$33 VPB|VPWR VPB|VPWR pfet L=0.15U W=0.84U AS=0.2184P AD=0.12915P
+ PS=2.2U PD=1.185U
* device instance $582 r0 *1 60.208,-143.825 pfet
M$582 A|A0|B|DOUT8|Q \$37 VPB|VPWR VPB|VPWR pfet L=0.15U W=1U AS=0.3012P
+ AD=0.26P PS=2.66U PD=2.52U
* device instance $583 r0 *1 28.488,-139.705 pfet
M$583 VPB|VPWR A|CLK|X \$48 VPB|VPWR pfet L=0.15U W=0.64U AS=0.1664P AD=0.0864P
+ PS=1.8U PD=0.91U
* device instance $584 r0 *1 28.908,-139.705 pfet
M$584 \$49 \$48 VPB|VPWR VPB|VPWR pfet L=0.15U W=0.64U AS=0.0864P AD=0.1664P
+ PS=0.91U PD=1.8U
* device instance $585 r0 *1 30.243,-139.565 pfet
M$585 \$51 D|X$2 VPB|VPWR VPB|VPWR pfet L=0.15U W=0.42U AS=0.1092P AD=0.0651P
+ PS=1.36U PD=0.73U
* device instance $586 r0 *1 30.703,-139.565 pfet
M$586 \$52 \$49 \$51 VPB|VPWR pfet L=0.15U W=0.42U AS=0.0651P AD=0.07245P
+ PS=0.73U PD=0.765U
* device instance $587 r0 *1 31.198,-139.565 pfet
M$587 \$53 \$48 \$52 VPB|VPWR pfet L=0.15U W=0.42U AS=0.07245P AD=0.1155P
+ PS=0.765U PD=0.97U
* device instance $588 r0 *1 31.898,-139.565 pfet
M$588 VPB|VPWR \$54 \$53 VPB|VPWR pfet L=0.15U W=0.42U AS=0.1155P AD=0.07035P
+ PS=0.97U PD=0.755U
* device instance $589 r0 *1 32.383,-139.565 pfet
M$589 \$53 RESET_B|RST_B VPB|VPWR VPB|VPWR pfet L=0.15U W=0.42U AS=0.07035P
+ AD=0.1092P PS=0.755U PD=1.36U
* device instance $590 r0 *1 33.368,-139.775 pfet
M$590 \$54 \$52 VPB|VPWR VPB|VPWR pfet L=0.15U W=0.84U AS=0.2184P AD=0.12915P
+ PS=2.2U PD=1.185U
* device instance $591 r0 *1 33.863,-139.565 pfet
M$591 \$55 \$48 \$54 VPB|VPWR pfet L=0.15U W=0.42U AS=0.12915P AD=0.0588P
+ PS=1.185U PD=0.7U
* device instance $592 r0 *1 34.293,-139.565 pfet
M$592 \$76 \$49 \$55 VPB|VPWR pfet L=0.15U W=0.42U AS=0.0588P AD=0.0567P
+ PS=0.7U PD=0.69U
* device instance $593 r0 *1 34.713,-139.565 pfet
M$593 VPB|VPWR \$56 \$76 VPB|VPWR pfet L=0.15U W=0.42U AS=0.0567P AD=0.0819P
+ PS=0.69U PD=0.81U
* device instance $594 r0 *1 35.253,-139.565 pfet
M$594 \$56 RESET_B|RST_B VPB|VPWR VPB|VPWR pfet L=0.15U W=0.42U AS=0.0819P
+ AD=0.0567P PS=0.81U PD=0.69U
* device instance $595 r0 *1 35.673,-139.565 pfet
M$595 VPB|VPWR \$55 \$56 VPB|VPWR pfet L=0.15U W=0.42U AS=0.0567P AD=0.1134P
+ PS=0.69U PD=1.38U
* device instance $596 r0 *1 35.388,-143.975 pfet
M$596 VPB|VPWR A|CLK|X \$18 VPB|VPWR pfet L=0.15U W=0.64U AS=0.1664P AD=0.0864P
+ PS=1.8U PD=0.91U
* device instance $597 r0 *1 35.808,-143.975 pfet
M$597 \$19 \$18 VPB|VPWR VPB|VPWR pfet L=0.15U W=0.64U AS=0.0864P AD=0.1664P
+ PS=0.91U PD=1.8U
* device instance $598 r0 *1 36.748,-139.855 pfet
M$598 A|A0|B|DOUT5|Q \$56 VPB|VPWR VPB|VPWR pfet L=0.15U W=1U AS=0.3012P
+ AD=0.26P PS=2.66U PD=2.52U
* device instance $599 r0 *1 44.793,-139.855 pfet
M$599 Y A|CLK|X VPB|VPWR VPB|VPWR pfet L=0.15U W=1U AS=0.26P AD=0.26P PS=2.52U
+ PD=2.52U
* device instance $600 r0 *1 50.108,-139.705 pfet
M$600 VPB|VPWR A|CLK|X \$59 VPB|VPWR pfet L=0.15U W=0.64U AS=0.1664P AD=0.0864P
+ PS=1.8U PD=0.91U
* device instance $601 r0 *1 50.528,-139.705 pfet
M$601 \$60 \$59 VPB|VPWR VPB|VPWR pfet L=0.15U W=0.64U AS=0.0864P AD=0.1664P
+ PS=0.91U PD=1.8U
* device instance $602 r0 *1 51.863,-139.565 pfet
M$602 \$61 C|D|PH_B7|Q|S VPB|VPWR VPB|VPWR pfet L=0.15U W=0.42U AS=0.1092P
+ AD=0.0651P PS=1.36U PD=0.73U
* device instance $603 r0 *1 52.323,-139.565 pfet
M$603 \$62 \$60 \$61 VPB|VPWR pfet L=0.15U W=0.42U AS=0.0651P AD=0.07245P
+ PS=0.73U PD=0.765U
* device instance $604 r0 *1 52.818,-139.565 pfet
M$604 \$63 \$59 \$62 VPB|VPWR pfet L=0.15U W=0.42U AS=0.07245P AD=0.1155P
+ PS=0.765U PD=0.97U
* device instance $605 r0 *1 53.518,-139.565 pfet
M$605 VPB|VPWR \$64 \$63 VPB|VPWR pfet L=0.15U W=0.42U AS=0.1155P AD=0.07035P
+ PS=0.97U PD=0.755U
* device instance $606 r0 *1 54.003,-139.565 pfet
M$606 \$63 RESET_B|RST_B VPB|VPWR VPB|VPWR pfet L=0.15U W=0.42U AS=0.07035P
+ AD=0.1092P PS=0.755U PD=1.36U
* device instance $607 r0 *1 51.948,-143.975 pfet
M$607 VPB|VPWR A|CLK|X \$29 VPB|VPWR pfet L=0.15U W=0.64U AS=0.1664P AD=0.0864P
+ PS=1.8U PD=0.91U
* device instance $608 r0 *1 52.368,-143.975 pfet
M$608 \$30 \$29 VPB|VPWR VPB|VPWR pfet L=0.15U W=0.64U AS=0.0864P AD=0.1664P
+ PS=0.91U PD=1.8U
* device instance $609 r0 *1 54.988,-139.775 pfet
M$609 \$64 \$62 VPB|VPWR VPB|VPWR pfet L=0.15U W=0.84U AS=0.2184P AD=0.12915P
+ PS=2.2U PD=1.185U
* device instance $610 r0 *1 55.483,-139.565 pfet
M$610 \$65 \$59 \$64 VPB|VPWR pfet L=0.15U W=0.42U AS=0.12915P AD=0.0588P
+ PS=1.185U PD=0.7U
* device instance $611 r0 *1 55.913,-139.565 pfet
M$611 \$75 \$60 \$65 VPB|VPWR pfet L=0.15U W=0.42U AS=0.0588P AD=0.0567P
+ PS=0.7U PD=0.69U
* device instance $612 r0 *1 56.333,-139.565 pfet
M$612 VPB|VPWR \$66 \$75 VPB|VPWR pfet L=0.15U W=0.42U AS=0.0567P AD=0.0819P
+ PS=0.69U PD=0.81U
* device instance $613 r0 *1 56.873,-139.565 pfet
M$613 \$66 RESET_B|RST_B VPB|VPWR VPB|VPWR pfet L=0.15U W=0.42U AS=0.0819P
+ AD=0.0567P PS=0.81U PD=0.69U
* device instance $614 r0 *1 57.293,-139.565 pfet
M$614 VPB|VPWR \$65 \$66 VPB|VPWR pfet L=0.15U W=0.42U AS=0.0567P AD=0.1134P
+ PS=0.69U PD=1.38U
* device instance $615 r0 *1 58.368,-139.855 pfet
M$615 D|PH_B6|Q|S \$66 VPB|VPWR VPB|VPWR pfet L=0.15U W=1U AS=0.3012P AD=0.26P
+ PS=2.66U PD=2.52U
* device instance $616 r0 *1 33.173,-134.32 pfet
M$616 \$140 C|D|PH_B3|Q|S VPB|VPWR VPB|VPWR pfet L=0.15U W=0.42U AS=0.15835P
+ AD=0.07665P PS=1.395U PD=0.785U
* device instance $617 r0 *1 33.688,-134.32 pfet
M$617 \$108 A|A0|B|DOUT3|Q \$140 VPB|VPWR pfet L=0.15U W=0.42U AS=0.07665P
+ AD=0.1932P PS=0.785U PD=1.34U
* device instance $618 r0 *1 34.758,-134.32 pfet
M$618 \$141 A1|COMP_OUT|OUTP \$108 VPB|VPWR pfet L=0.15U W=0.42U AS=0.1932P
+ AD=0.0441P PS=1.34U PD=0.63U
* device instance $619 r0 *1 35.118,-134.32 pfet
M$619 VPB|VPWR \$111 \$141 VPB|VPWR pfet L=0.15U W=0.42U AS=0.0441P AD=0.0693P
+ PS=0.63U PD=0.75U
* device instance $620 r0 *1 35.598,-134.32 pfet
M$620 \$111 C|D|PH_B3|Q|S VPB|VPWR VPB|VPWR pfet L=0.15U W=0.42U AS=0.0693P
+ AD=0.1176P PS=0.75U PD=1.4U
* device instance $621 r0 *1 32.628,-134.415 pfet
M$621 VPB|VPWR \$108 D|X$4 VPB|VPWR pfet L=0.15U W=1U AS=0.26P AD=0.15835P
+ PS=2.52U PD=1.395U
* device instance $622 r0 *1 33.173,-138.48 pfet
M$622 \$92 A|D|PH_B5|Q|S VPB|VPWR VPB|VPWR pfet L=0.15U W=0.42U AS=0.15835P
+ AD=0.07665P PS=1.395U PD=0.785U
* device instance $623 r0 *1 33.688,-138.48 pfet
M$623 \$77 A|A0|B|DOUT5|Q \$92 VPB|VPWR pfet L=0.15U W=0.42U AS=0.07665P
+ AD=0.1932P PS=0.785U PD=1.34U
* device instance $624 r0 *1 34.758,-138.48 pfet
M$624 \$93 A1|COMP_OUT|OUTP \$77 VPB|VPWR pfet L=0.15U W=0.42U AS=0.1932P
+ AD=0.0441P PS=1.34U PD=0.63U
* device instance $625 r0 *1 35.118,-138.48 pfet
M$625 VPB|VPWR \$80 \$93 VPB|VPWR pfet L=0.15U W=0.42U AS=0.0441P AD=0.0693P
+ PS=0.63U PD=0.75U
* device instance $626 r0 *1 35.598,-138.48 pfet
M$626 \$80 A|D|PH_B5|Q|S VPB|VPWR VPB|VPWR pfet L=0.15U W=0.42U AS=0.0693P
+ AD=0.1176P PS=0.75U PD=1.4U
* device instance $627 r0 *1 32.628,-138.385 pfet
M$627 VPB|VPWR \$77 D|X$2 VPB|VPWR pfet L=0.15U W=1U AS=0.26P AD=0.15835P
+ PS=2.52U PD=1.395U
* device instance $628 r0 *1 39.613,-138.48 pfet
M$628 \$95 D|PH_B6|Q|S VPB|VPWR VPB|VPWR pfet L=0.15U W=0.42U AS=0.15835P
+ AD=0.07665P PS=1.395U PD=0.785U
* device instance $629 r0 *1 40.128,-138.48 pfet
M$629 \$81 A|A0|B|DOUT6|Q \$95 VPB|VPWR pfet L=0.15U W=0.42U AS=0.07665P
+ AD=0.1932P PS=0.785U PD=1.34U
* device instance $630 r0 *1 41.198,-138.48 pfet
M$630 \$98 A1|COMP_OUT|OUTP \$81 VPB|VPWR pfet L=0.15U W=0.42U AS=0.1932P
+ AD=0.0441P PS=1.34U PD=0.63U
* device instance $631 r0 *1 41.558,-138.48 pfet
M$631 VPB|VPWR \$83 \$98 VPB|VPWR pfet L=0.15U W=0.42U AS=0.0441P AD=0.0693P
+ PS=0.63U PD=0.75U
* device instance $632 r0 *1 42.038,-138.48 pfet
M$632 \$83 D|PH_B6|Q|S VPB|VPWR VPB|VPWR pfet L=0.15U W=0.42U AS=0.0693P
+ AD=0.1176P PS=0.75U PD=1.4U
* device instance $633 r0 *1 39.068,-138.385 pfet
M$633 VPB|VPWR \$81 D|X VPB|VPWR pfet L=0.15U W=1U AS=0.26P AD=0.15835P
+ PS=2.52U PD=1.395U
* device instance $634 r0 *1 44.588,-138.385 pfet
M$634 VPB|VPWR A|X$1 \$84 VPB|VPWR pfet L=0.15U W=1U AS=0.26P AD=0.135P
+ PS=2.52U PD=1.27U
* device instance $635 r0 *1 45.008,-138.385 pfet
M$635 A|CLK|X \$84 VPB|VPWR VPB|VPWR pfet L=0.15U W=1U AS=0.135P AD=0.135P
+ PS=1.27U PD=1.27U
* device instance $636 r0 *1 45.428,-138.385 pfet
M$636 VPB|VPWR \$84 A|CLK|X VPB|VPWR pfet L=0.15U W=1U AS=0.135P AD=0.135P
+ PS=1.27U PD=1.27U
* device instance $637 r0 *1 45.848,-138.385 pfet
M$637 A|CLK|X \$84 VPB|VPWR VPB|VPWR pfet L=0.15U W=1U AS=0.135P AD=0.135P
+ PS=1.27U PD=1.27U
* device instance $638 r0 *1 46.268,-138.385 pfet
M$638 VPB|VPWR \$84 A|CLK|X VPB|VPWR pfet L=0.15U W=1U AS=0.135P AD=0.26P
+ PS=1.27U PD=2.52U
* device instance $639 r0 *1 48.708,-134.415 pfet
M$639 A|D|PH_B5|Q|S \$119 VPB|VPWR VPB|VPWR pfet L=0.15U W=1U AS=0.3012P
+ AD=0.26P PS=2.66U PD=2.52U
* device instance $640 r0 *1 52.493,-138.48 pfet
M$640 \$100 C|D|PH_B7|Q|S VPB|VPWR VPB|VPWR pfet L=0.15U W=0.42U AS=0.15835P
+ AD=0.07665P PS=1.395U PD=0.785U
* device instance $641 r0 *1 53.008,-138.48 pfet
M$641 \$86 A|A0|B|DOUT7|Q \$100 VPB|VPWR pfet L=0.15U W=0.42U AS=0.07665P
+ AD=0.1932P PS=0.785U PD=1.34U
* device instance $642 r0 *1 54.078,-138.48 pfet
M$642 \$101 A1|COMP_OUT|OUTP \$86 VPB|VPWR pfet L=0.15U W=0.42U AS=0.1932P
+ AD=0.0441P PS=1.34U PD=0.63U
* device instance $643 r0 *1 54.438,-138.48 pfet
M$643 VPB|VPWR \$88 \$101 VPB|VPWR pfet L=0.15U W=0.42U AS=0.0441P AD=0.0693P
+ PS=0.63U PD=0.75U
* device instance $644 r0 *1 54.918,-138.48 pfet
M$644 \$88 C|D|PH_B7|Q|S VPB|VPWR VPB|VPWR pfet L=0.15U W=0.42U AS=0.0693P
+ AD=0.1176P PS=0.75U PD=1.4U
* device instance $645 r0 *1 51.948,-138.385 pfet
M$645 VPB|VPWR \$86 D|X$3 VPB|VPWR pfet L=0.15U W=1U AS=0.26P AD=0.15835P
+ PS=2.52U PD=1.395U
* device instance $646 r0 *1 56.633,-138.48 pfet
M$646 \$104 B|D|PH_B8|Q|S VPB|VPWR VPB|VPWR pfet L=0.15U W=0.42U AS=0.15835P
+ AD=0.07665P PS=1.395U PD=0.785U
* device instance $647 r0 *1 57.148,-138.48 pfet
M$647 \$89 A|A0|B|DOUT8|Q \$104 VPB|VPWR pfet L=0.15U W=0.42U AS=0.07665P
+ AD=0.1932P PS=0.785U PD=1.34U
* device instance $648 r0 *1 58.218,-138.48 pfet
M$648 \$105 A1|COMP_OUT|OUTP \$89 VPB|VPWR pfet L=0.15U W=0.42U AS=0.1932P
+ AD=0.0441P PS=1.34U PD=0.63U
* device instance $649 r0 *1 58.578,-138.48 pfet
M$649 VPB|VPWR \$90 \$105 VPB|VPWR pfet L=0.15U W=0.42U AS=0.0441P AD=0.0693P
+ PS=0.63U PD=0.75U
* device instance $650 r0 *1 59.058,-138.48 pfet
M$650 \$90 B|D|PH_B8|Q|S VPB|VPWR VPB|VPWR pfet L=0.15U W=0.42U AS=0.0693P
+ AD=0.1176P PS=0.75U PD=1.4U
* device instance $651 r0 *1 56.088,-138.385 pfet
M$651 VPB|VPWR \$89 D|X$1 VPB|VPWR pfet L=0.15U W=1U AS=0.26P AD=0.15835P
+ PS=2.52U PD=1.395U
* device instance $652 r0 *1 58.828,-134.415 pfet
M$652 B|D|PH_B8|Q|S \$128 VPB|VPWR VPB|VPWR pfet L=0.15U W=1U AS=0.3012P
+ AD=0.26P PS=2.66U PD=2.52U
* device instance $653 r0 *1 40.448,-134.265 pfet
M$653 VPB|VPWR A|CLK|X \$112 VPB|VPWR pfet L=0.15U W=0.64U AS=0.1664P
+ AD=0.0864P PS=1.8U PD=0.91U
* device instance $654 r0 *1 40.868,-134.265 pfet
M$654 \$113 \$112 VPB|VPWR VPB|VPWR pfet L=0.15U W=0.64U AS=0.0864P AD=0.1664P
+ PS=0.91U PD=1.8U
* device instance $655 r0 *1 45.328,-134.335 pfet
M$655 \$117 \$115 VPB|VPWR VPB|VPWR pfet L=0.15U W=0.84U AS=0.2184P AD=0.12915P
+ PS=2.2U PD=1.185U
* device instance $656 r0 *1 45.823,-134.125 pfet
M$656 \$118 \$112 \$117 VPB|VPWR pfet L=0.15U W=0.42U AS=0.12915P AD=0.0588P
+ PS=1.185U PD=0.7U
* device instance $657 r0 *1 46.253,-134.125 pfet
M$657 \$142 \$113 \$118 VPB|VPWR pfet L=0.15U W=0.42U AS=0.0588P AD=0.0567P
+ PS=0.7U PD=0.69U
* device instance $658 r0 *1 46.673,-134.125 pfet
M$658 VPB|VPWR \$119 \$142 VPB|VPWR pfet L=0.15U W=0.42U AS=0.0567P AD=0.0819P
+ PS=0.69U PD=0.81U
* device instance $659 r0 *1 47.213,-134.125 pfet
M$659 \$119 RESET_B|RST_B VPB|VPWR VPB|VPWR pfet L=0.15U W=0.42U AS=0.0819P
+ AD=0.0567P PS=0.81U PD=0.69U
* device instance $660 r0 *1 47.633,-134.125 pfet
M$660 VPB|VPWR \$118 \$119 VPB|VPWR pfet L=0.15U W=0.42U AS=0.0567P AD=0.1134P
+ PS=0.69U PD=1.38U
* device instance $661 r0 *1 50.568,-134.265 pfet
M$661 VPB|VPWR A|CLK|X \$121 VPB|VPWR pfet L=0.15U W=0.64U AS=0.1664P
+ AD=0.0864P PS=1.8U PD=0.91U
* device instance $662 r0 *1 50.988,-134.265 pfet
M$662 \$122 \$121 VPB|VPWR VPB|VPWR pfet L=0.15U W=0.64U AS=0.0864P AD=0.1664P
+ PS=0.91U PD=1.8U
* device instance $663 r0 *1 55.448,-134.335 pfet
M$663 \$126 \$124 VPB|VPWR VPB|VPWR pfet L=0.15U W=0.84U AS=0.2184P AD=0.12915P
+ PS=2.2U PD=1.185U
* device instance $664 r0 *1 55.943,-134.125 pfet
M$664 \$127 \$121 \$126 VPB|VPWR pfet L=0.15U W=0.42U AS=0.12915P AD=0.0588P
+ PS=1.185U PD=0.7U
* device instance $665 r0 *1 56.373,-134.125 pfet
M$665 \$139 \$122 \$127 VPB|VPWR pfet L=0.15U W=0.42U AS=0.0588P AD=0.0567P
+ PS=0.7U PD=0.69U
* device instance $666 r0 *1 56.793,-134.125 pfet
M$666 VPB|VPWR \$128 \$139 VPB|VPWR pfet L=0.15U W=0.42U AS=0.0567P AD=0.0819P
+ PS=0.69U PD=0.81U
* device instance $667 r0 *1 57.333,-134.125 pfet
M$667 \$128 RESET_B|RST_B VPB|VPWR VPB|VPWR pfet L=0.15U W=0.42U AS=0.0819P
+ AD=0.0567P PS=0.81U PD=0.69U
* device instance $668 r0 *1 57.753,-134.125 pfet
M$668 VPB|VPWR \$127 \$128 VPB|VPWR pfet L=0.15U W=0.42U AS=0.0567P AD=0.1134P
+ PS=0.69U PD=1.38U
* device instance $669 r0 *1 42.203,-134.125 pfet
M$669 \$114 D|PH_B6|Q|S VPB|VPWR VPB|VPWR pfet L=0.15U W=0.42U AS=0.1092P
+ AD=0.0651P PS=1.36U PD=0.73U
* device instance $670 r0 *1 42.663,-134.125 pfet
M$670 \$115 \$113 \$114 VPB|VPWR pfet L=0.15U W=0.42U AS=0.0651P AD=0.07245P
+ PS=0.73U PD=0.765U
* device instance $671 r0 *1 43.158,-134.125 pfet
M$671 \$116 \$112 \$115 VPB|VPWR pfet L=0.15U W=0.42U AS=0.07245P AD=0.1155P
+ PS=0.765U PD=0.97U
* device instance $672 r0 *1 43.858,-134.125 pfet
M$672 VPB|VPWR \$117 \$116 VPB|VPWR pfet L=0.15U W=0.42U AS=0.1155P AD=0.07035P
+ PS=0.97U PD=0.755U
* device instance $673 r0 *1 44.343,-134.125 pfet
M$673 \$116 RESET_B|RST_B VPB|VPWR VPB|VPWR pfet L=0.15U W=0.42U AS=0.07035P
+ AD=0.1092P PS=0.755U PD=1.36U
* device instance $674 r0 *1 52.323,-134.125 pfet
M$674 \$123 A|A_N|D|PH_B9|Q|S VPB|VPWR VPB|VPWR pfet L=0.15U W=0.42U AS=0.1092P
+ AD=0.0651P PS=1.36U PD=0.73U
* device instance $675 r0 *1 52.783,-134.125 pfet
M$675 \$124 \$122 \$123 VPB|VPWR pfet L=0.15U W=0.42U AS=0.0651P AD=0.07245P
+ PS=0.73U PD=0.765U
* device instance $676 r0 *1 53.278,-134.125 pfet
M$676 \$125 \$121 \$124 VPB|VPWR pfet L=0.15U W=0.42U AS=0.07245P AD=0.1155P
+ PS=0.765U PD=0.97U
* device instance $677 r0 *1 53.978,-134.125 pfet
M$677 VPB|VPWR \$126 \$125 VPB|VPWR pfet L=0.15U W=0.42U AS=0.1155P AD=0.07035P
+ PS=0.97U PD=0.755U
* device instance $678 r0 *1 54.463,-134.125 pfet
M$678 \$125 RESET_B|RST_B VPB|VPWR VPB|VPWR pfet L=0.15U W=0.42U AS=0.07035P
+ AD=0.1092P PS=0.755U PD=1.36U
* device instance $679 r0 *1 29.868,-133.095 pfet
M$679 VPB|VPWR A|CLK|X \$143 VPB|VPWR pfet L=0.15U W=0.64U AS=0.1664P
+ AD=0.0864P PS=1.8U PD=0.91U
* device instance $680 r0 *1 30.288,-133.095 pfet
M$680 \$144 \$143 VPB|VPWR VPB|VPWR pfet L=0.15U W=0.64U AS=0.0864P AD=0.1664P
+ PS=0.91U PD=1.8U
* device instance $681 r0 *1 31.623,-133.235 pfet
M$681 \$146 D|X$5 VPB|VPWR VPB|VPWR pfet L=0.15U W=0.42U AS=0.1092P AD=0.0651P
+ PS=1.36U PD=0.73U
* device instance $682 r0 *1 32.083,-133.235 pfet
M$682 \$147 \$144 \$146 VPB|VPWR pfet L=0.15U W=0.42U AS=0.0651P AD=0.07245P
+ PS=0.73U PD=0.765U
* device instance $683 r0 *1 32.578,-133.235 pfet
M$683 \$148 \$143 \$147 VPB|VPWR pfet L=0.15U W=0.42U AS=0.07245P AD=0.1155P
+ PS=0.765U PD=0.97U
* device instance $684 r0 *1 33.278,-133.235 pfet
M$684 VPB|VPWR \$149 \$148 VPB|VPWR pfet L=0.15U W=0.42U AS=0.1155P AD=0.07035P
+ PS=0.97U PD=0.755U
* device instance $685 r0 *1 33.763,-133.235 pfet
M$685 \$148 RESET_B|RST_B VPB|VPWR VPB|VPWR pfet L=0.15U W=0.42U AS=0.07035P
+ AD=0.1092P PS=0.755U PD=1.36U
* device instance $686 r0 *1 34.093,-128.88 pfet
M$686 \$191 D|PH_B2|Q|S VPB|VPWR VPB|VPWR pfet L=0.15U W=0.42U AS=0.15835P
+ AD=0.07665P PS=1.395U PD=0.785U
* device instance $687 r0 *1 34.608,-128.88 pfet
M$687 \$176 A|A0|B|DOUT2|Q \$191 VPB|VPWR pfet L=0.15U W=0.42U AS=0.07665P
+ AD=0.1932P PS=0.785U PD=1.34U
* device instance $688 r0 *1 35.678,-128.88 pfet
M$688 \$192 A1|COMP_OUT|OUTP \$176 VPB|VPWR pfet L=0.15U W=0.42U AS=0.1932P
+ AD=0.0441P PS=1.34U PD=0.63U
* device instance $689 r0 *1 36.038,-128.88 pfet
M$689 VPB|VPWR \$178 \$192 VPB|VPWR pfet L=0.15U W=0.42U AS=0.0441P AD=0.0693P
+ PS=0.63U PD=0.75U
* device instance $690 r0 *1 36.518,-128.88 pfet
M$690 \$178 D|PH_B2|Q|S VPB|VPWR VPB|VPWR pfet L=0.15U W=0.42U AS=0.0693P
+ AD=0.1176P PS=0.75U PD=1.4U
* device instance $691 r0 *1 33.548,-128.975 pfet
M$691 VPB|VPWR \$176 D|X$5 VPB|VPWR pfet L=0.15U W=1U AS=0.26P AD=0.15835P
+ PS=2.52U PD=1.395U
* device instance $692 r0 *1 35.243,-133.235 pfet
M$692 \$150 \$143 \$149 VPB|VPWR pfet L=0.15U W=0.42U AS=0.12915P AD=0.0588P
+ PS=1.185U PD=0.7U
* device instance $693 r0 *1 35.673,-133.235 pfet
M$693 \$163 \$144 \$150 VPB|VPWR pfet L=0.15U W=0.42U AS=0.0588P AD=0.0567P
+ PS=0.7U PD=0.69U
* device instance $694 r0 *1 36.093,-133.235 pfet
M$694 VPB|VPWR \$151 \$163 VPB|VPWR pfet L=0.15U W=0.42U AS=0.0567P AD=0.0819P
+ PS=0.69U PD=0.81U
* device instance $695 r0 *1 36.633,-133.235 pfet
M$695 \$151 RESET_B|RST_B VPB|VPWR VPB|VPWR pfet L=0.15U W=0.42U AS=0.0819P
+ AD=0.0567P PS=0.81U PD=0.69U
* device instance $696 r0 *1 37.053,-133.235 pfet
M$696 VPB|VPWR \$150 \$151 VPB|VPWR pfet L=0.15U W=0.42U AS=0.0567P AD=0.1134P
+ PS=0.69U PD=1.38U
* device instance $697 r0 *1 34.748,-133.025 pfet
M$697 \$149 \$147 VPB|VPWR VPB|VPWR pfet L=0.15U W=0.84U AS=0.2184P AD=0.12915P
+ PS=2.2U PD=1.185U
* device instance $698 r0 *1 38.128,-132.945 pfet
M$698 A|A0|B|DOUT2|Q \$151 VPB|VPWR VPB|VPWR pfet L=0.15U W=1U AS=0.3012P
+ AD=0.26P PS=2.66U PD=2.52U
* device instance $699 r0 *1 40.448,-128.975 pfet
M$699 VPB|VPWR A|CLK \$180 VPB|VPWR pfet L=0.15U W=1U AS=0.26P AD=0.135P
+ PS=2.52U PD=1.27U
* device instance $700 r0 *1 40.868,-128.975 pfet
M$700 A|X$1 \$180 VPB|VPWR VPB|VPWR pfet L=0.15U W=1U AS=0.135P AD=0.135P
+ PS=1.27U PD=1.27U
* device instance $701 r0 *1 41.288,-128.975 pfet
M$701 VPB|VPWR \$180 A|X$1 VPB|VPWR pfet L=0.15U W=1U AS=0.135P AD=0.135P
+ PS=1.27U PD=1.27U
* device instance $702 r0 *1 41.708,-128.975 pfet
M$702 A|X$1 \$180 VPB|VPWR VPB|VPWR pfet L=0.15U W=1U AS=0.135P AD=0.135P
+ PS=1.27U PD=1.27U
* device instance $703 r0 *1 42.128,-128.975 pfet
M$703 VPB|VPWR \$180 A|X$1 VPB|VPWR pfet L=0.15U W=1U AS=0.135P AD=0.26P
+ PS=1.27U PD=2.52U
* device instance $704 r0 *1 48.728,-132.655 pfet
M$704 \$165 D|PH_B6|Q|S \$152 VPB|VPWR pfet L=0.15U W=0.42U AS=0.1092P
+ AD=0.0693P PS=1.36U PD=0.75U
* device instance $705 r0 *1 49.208,-132.655 pfet
M$705 \$164 C|D|PH_B7|Q|S \$165 VPB|VPWR pfet L=0.15U W=0.42U AS=0.0693P
+ AD=0.0441P PS=0.75U PD=0.63U
* device instance $706 r0 *1 49.568,-132.655 pfet
M$706 \$166 B|D|PH_B8|Q|S \$164 VPB|VPWR pfet L=0.15U W=0.42U AS=0.0441P
+ AD=0.0693P PS=0.63U PD=0.75U
* device instance $707 r0 *1 50.048,-132.655 pfet
M$707 \$166 A|A_N|D|PH_B9|Q|S VPB|VPWR VPB|VPWR pfet L=0.15U W=0.42U
+ AS=0.14825P AD=0.0693P PS=1.34U PD=0.75U
* device instance $708 r0 *1 50.538,-132.945 pfet
M$708 A|X \$152 VPB|VPWR VPB|VPWR pfet L=0.15U W=1U AS=0.14825P AD=0.27P
+ PS=1.34U PD=2.54U
* device instance $709 r0 *1 51.948,-133.095 pfet
M$709 VPB|VPWR A|CLK|X \$154 VPB|VPWR pfet L=0.15U W=0.64U AS=0.1664P
+ AD=0.0864P PS=1.8U PD=0.91U
* device instance $710 r0 *1 52.368,-133.095 pfet
M$710 \$155 \$154 VPB|VPWR VPB|VPWR pfet L=0.15U W=0.64U AS=0.0864P AD=0.1664P
+ PS=0.91U PD=1.8U
* device instance $711 r0 *1 53.703,-133.235 pfet
M$711 \$157 D|PH_SAMPLE|SAMPLE|Y VPB|VPWR VPB|VPWR pfet L=0.15U W=0.42U
+ AS=0.1092P AD=0.0651P PS=1.36U PD=0.73U
* device instance $712 r0 *1 54.163,-133.235 pfet
M$712 \$158 \$155 \$157 VPB|VPWR pfet L=0.15U W=0.42U AS=0.0651P AD=0.07245P
+ PS=0.73U PD=0.765U
* device instance $713 r0 *1 54.658,-133.235 pfet
M$713 \$159 \$154 \$158 VPB|VPWR pfet L=0.15U W=0.42U AS=0.07245P AD=0.1155P
+ PS=0.765U PD=0.97U
* device instance $714 r0 *1 55.358,-133.235 pfet
M$714 VPB|VPWR \$160 \$159 VPB|VPWR pfet L=0.15U W=0.42U AS=0.1155P AD=0.07035P
+ PS=0.97U PD=0.755U
* device instance $715 r0 *1 55.843,-133.235 pfet
M$715 \$159 RESET_B|RST_B VPB|VPWR VPB|VPWR pfet L=0.15U W=0.42U AS=0.07035P
+ AD=0.1092P PS=0.755U PD=1.36U
* device instance $716 r0 *1 57.323,-133.235 pfet
M$716 \$161 \$154 \$160 VPB|VPWR pfet L=0.15U W=0.42U AS=0.12915P AD=0.0588P
+ PS=1.185U PD=0.7U
* device instance $717 r0 *1 57.753,-133.235 pfet
M$717 \$167 \$155 \$161 VPB|VPWR pfet L=0.15U W=0.42U AS=0.0588P AD=0.0567P
+ PS=0.7U PD=0.69U
* device instance $718 r0 *1 58.173,-133.235 pfet
M$718 VPB|VPWR \$162 \$167 VPB|VPWR pfet L=0.15U W=0.42U AS=0.0567P AD=0.0819P
+ PS=0.69U PD=0.81U
* device instance $719 r0 *1 58.713,-133.235 pfet
M$719 \$162 RESET_B|RST_B VPB|VPWR VPB|VPWR pfet L=0.15U W=0.42U AS=0.0819P
+ AD=0.0567P PS=0.81U PD=0.69U
* device instance $720 r0 *1 59.133,-133.235 pfet
M$720 VPB|VPWR \$161 \$162 VPB|VPWR pfet L=0.15U W=0.42U AS=0.0567P AD=0.1134P
+ PS=0.69U PD=1.38U
* device instance $721 r0 *1 56.828,-133.025 pfet
M$721 \$160 \$158 VPB|VPWR VPB|VPWR pfet L=0.15U W=0.84U AS=0.2184P AD=0.12915P
+ PS=2.2U PD=1.185U
* device instance $722 r0 *1 57.448,-128.975 pfet
M$722 A|A0|B|DOUT7|Q \$189 VPB|VPWR VPB|VPWR pfet L=0.15U W=1U AS=0.3012P
+ AD=0.26P PS=2.66U PD=2.52U
* device instance $723 r0 *1 60.208,-132.945 pfet
M$723 A|A_N|D|PH_B9|Q|S \$162 VPB|VPWR VPB|VPWR pfet L=0.15U W=1U AS=0.3012P
+ AD=0.26P PS=2.66U PD=2.52U
* device instance $724 r0 *1 49.188,-128.825 pfet
M$724 VPB|VPWR A|CLK|X \$182 VPB|VPWR pfet L=0.15U W=0.64U AS=0.1664P
+ AD=0.0864P PS=1.8U PD=0.91U
* device instance $725 r0 *1 49.608,-128.825 pfet
M$725 \$183 \$182 VPB|VPWR VPB|VPWR pfet L=0.15U W=0.64U AS=0.0864P AD=0.1664P
+ PS=0.91U PD=1.8U
* device instance $726 r0 *1 54.068,-128.895 pfet
M$726 \$187 \$185 VPB|VPWR VPB|VPWR pfet L=0.15U W=0.84U AS=0.2184P AD=0.12915P
+ PS=2.2U PD=1.185U
* device instance $727 r0 *1 54.563,-128.685 pfet
M$727 \$188 \$182 \$187 VPB|VPWR pfet L=0.15U W=0.42U AS=0.12915P AD=0.0588P
+ PS=1.185U PD=0.7U
* device instance $728 r0 *1 54.993,-128.685 pfet
M$728 \$196 \$183 \$188 VPB|VPWR pfet L=0.15U W=0.42U AS=0.0588P AD=0.0567P
+ PS=0.7U PD=0.69U
* device instance $729 r0 *1 55.413,-128.685 pfet
M$729 VPB|VPWR \$189 \$196 VPB|VPWR pfet L=0.15U W=0.42U AS=0.0567P AD=0.0819P
+ PS=0.69U PD=0.81U
* device instance $730 r0 *1 55.953,-128.685 pfet
M$730 \$189 RESET_B|RST_B VPB|VPWR VPB|VPWR pfet L=0.15U W=0.42U AS=0.0819P
+ AD=0.0567P PS=0.81U PD=0.69U
* device instance $731 r0 *1 56.373,-128.685 pfet
M$731 VPB|VPWR \$188 \$189 VPB|VPWR pfet L=0.15U W=0.42U AS=0.0567P AD=0.1134P
+ PS=0.69U PD=1.38U
* device instance $732 r0 *1 31.623,-127.795 pfet
M$732 \$202 A|D|PH_B5|Q|S VPB|VPWR VPB|VPWR pfet L=0.15U W=0.42U AS=0.1092P
+ AD=0.0651P PS=1.36U PD=0.73U
* device instance $733 r0 *1 32.083,-127.795 pfet
M$733 \$203 \$201 \$202 VPB|VPWR pfet L=0.15U W=0.42U AS=0.0651P AD=0.07245P
+ PS=0.73U PD=0.765U
* device instance $734 r0 *1 32.578,-127.795 pfet
M$734 \$204 \$200 \$203 VPB|VPWR pfet L=0.15U W=0.42U AS=0.07245P AD=0.1155P
+ PS=0.765U PD=0.97U
* device instance $735 r0 *1 33.278,-127.795 pfet
M$735 VPB|VPWR \$205 \$204 VPB|VPWR pfet L=0.15U W=0.42U AS=0.1155P AD=0.07035P
+ PS=0.97U PD=0.755U
* device instance $736 r0 *1 33.763,-127.795 pfet
M$736 \$204 RESET_B|RST_B VPB|VPWR VPB|VPWR pfet L=0.15U W=0.42U AS=0.07035P
+ AD=0.1092P PS=0.755U PD=1.36U
* device instance $737 r0 *1 35.243,-127.795 pfet
M$737 \$207 \$200 \$205 VPB|VPWR pfet L=0.15U W=0.42U AS=0.12915P AD=0.0588P
+ PS=1.185U PD=0.7U
* device instance $738 r0 *1 35.673,-127.795 pfet
M$738 \$217 \$201 \$207 VPB|VPWR pfet L=0.15U W=0.42U AS=0.0588P AD=0.0567P
+ PS=0.7U PD=0.69U
* device instance $739 r0 *1 36.093,-127.795 pfet
M$739 VPB|VPWR \$208 \$217 VPB|VPWR pfet L=0.15U W=0.42U AS=0.0567P AD=0.0819P
+ PS=0.69U PD=0.81U
* device instance $740 r0 *1 36.633,-127.795 pfet
M$740 \$208 RESET_B|RST_B VPB|VPWR VPB|VPWR pfet L=0.15U W=0.42U AS=0.0819P
+ AD=0.0567P PS=0.81U PD=0.69U
* device instance $741 r0 *1 37.053,-127.795 pfet
M$741 VPB|VPWR \$207 \$208 VPB|VPWR pfet L=0.15U W=0.42U AS=0.0567P AD=0.1134P
+ PS=0.69U PD=1.38U
* device instance $742 r0 *1 34.748,-127.585 pfet
M$742 \$205 \$203 VPB|VPWR VPB|VPWR pfet L=0.15U W=0.84U AS=0.2184P AD=0.12915P
+ PS=2.2U PD=1.185U
* device instance $743 r0 *1 38.128,-127.505 pfet
M$743 B|D|PH_B4|Q|S \$208 VPB|VPWR VPB|VPWR pfet L=0.15U W=1U AS=0.3012P
+ AD=0.26P PS=2.66U PD=2.52U
* device instance $744 r0 *1 50.943,-128.685 pfet
M$744 \$184 D|X$3 VPB|VPWR VPB|VPWR pfet L=0.15U W=0.42U AS=0.1092P AD=0.0651P
+ PS=1.36U PD=0.73U
* device instance $745 r0 *1 51.403,-128.685 pfet
M$745 \$185 \$183 \$184 VPB|VPWR pfet L=0.15U W=0.42U AS=0.0651P AD=0.07245P
+ PS=0.73U PD=0.765U
* device instance $746 r0 *1 51.898,-128.685 pfet
M$746 \$186 \$182 \$185 VPB|VPWR pfet L=0.15U W=0.42U AS=0.07245P AD=0.1155P
+ PS=0.765U PD=0.97U
* device instance $747 r0 *1 52.598,-128.685 pfet
M$747 VPB|VPWR \$187 \$186 VPB|VPWR pfet L=0.15U W=0.42U AS=0.1155P AD=0.07035P
+ PS=0.97U PD=0.755U
* device instance $748 r0 *1 53.083,-128.685 pfet
M$748 \$186 RESET_B|RST_B VPB|VPWR VPB|VPWR pfet L=0.15U W=0.42U AS=0.07035P
+ AD=0.1092P PS=0.755U PD=1.36U
* device instance $749 r0 *1 52.613,-127.505 pfet
M$749 D|PH_SAMPLE|SAMPLE|Y A|B|BUSY|X VPB|VPWR VPB|VPWR pfet L=0.15U W=1U
+ AS=0.26P AD=0.26P PS=2.52U PD=2.52U
* device instance $750 r0 *1 56.633,-127.6 pfet
M$750 \$223 A|A_N|D|PH_B9|Q|S VPB|VPWR VPB|VPWR pfet L=0.15U W=0.42U
+ AS=0.15835P AD=0.07665P PS=1.395U PD=0.785U
* device instance $751 r0 *1 57.148,-127.6 pfet
M$751 \$215 A|A0|B|DOUT9|Q \$223 VPB|VPWR pfet L=0.15U W=0.42U AS=0.07665P
+ AD=0.1932P PS=0.785U PD=1.34U
* device instance $752 r0 *1 58.218,-127.6 pfet
M$752 \$224 A1|COMP_OUT|OUTP \$215 VPB|VPWR pfet L=0.15U W=0.42U AS=0.1932P
+ AD=0.0441P PS=1.34U PD=0.63U
* device instance $753 r0 *1 58.578,-127.6 pfet
M$753 VPB|VPWR \$216 \$224 VPB|VPWR pfet L=0.15U W=0.42U AS=0.0441P AD=0.0693P
+ PS=0.63U PD=0.75U
* device instance $754 r0 *1 59.058,-127.6 pfet
M$754 \$216 A|A_N|D|PH_B9|Q|S VPB|VPWR VPB|VPWR pfet L=0.15U W=0.42U AS=0.0693P
+ AD=0.1176P PS=0.75U PD=1.4U
* device instance $755 r0 *1 56.088,-127.505 pfet
M$755 VPB|VPWR \$215 D|X$6 VPB|VPWR pfet L=0.15U W=1U AS=0.26P AD=0.15835P
+ PS=2.52U PD=1.395U
* device instance $756 r0 *1 29.868,-127.655 pfet
M$756 VPB|VPWR CLK|X \$200 VPB|VPWR pfet L=0.15U W=0.64U AS=0.1664P AD=0.0864P
+ PS=1.8U PD=0.91U
* device instance $757 r0 *1 30.288,-127.655 pfet
M$757 \$201 \$200 VPB|VPWR VPB|VPWR pfet L=0.15U W=0.64U AS=0.0864P AD=0.1664P
+ PS=0.91U PD=1.8U
* device instance $758 r0 *1 33.368,-123.455 pfet
M$758 \$236 \$234 VPB|VPWR VPB|VPWR pfet L=0.15U W=0.84U AS=0.2184P AD=0.12915P
+ PS=2.2U PD=1.185U
* device instance $759 r0 *1 33.863,-123.245 pfet
M$759 \$237 \$231 \$236 VPB|VPWR pfet L=0.15U W=0.42U AS=0.12915P AD=0.0588P
+ PS=1.185U PD=0.7U
* device instance $760 r0 *1 34.293,-123.245 pfet
M$760 \$250 \$232 \$237 VPB|VPWR pfet L=0.15U W=0.42U AS=0.0588P AD=0.0567P
+ PS=0.7U PD=0.69U
* device instance $761 r0 *1 34.713,-123.245 pfet
M$761 VPB|VPWR \$238 \$250 VPB|VPWR pfet L=0.15U W=0.42U AS=0.0567P AD=0.0819P
+ PS=0.69U PD=0.81U
* device instance $762 r0 *1 35.253,-123.245 pfet
M$762 \$238 RESET_B|RST_B VPB|VPWR VPB|VPWR pfet L=0.15U W=0.42U AS=0.0819P
+ AD=0.0567P PS=0.81U PD=0.69U
* device instance $763 r0 *1 35.673,-123.245 pfet
M$763 VPB|VPWR \$237 \$238 VPB|VPWR pfet L=0.15U W=0.42U AS=0.0567P AD=0.1134P
+ PS=0.69U PD=1.38U
* device instance $764 r0 *1 36.748,-123.535 pfet
M$764 C|D|PH_B3|Q|S \$238 VPB|VPWR VPB|VPWR pfet L=0.15U W=1U AS=0.3012P
+ AD=0.26P PS=2.66U PD=2.52U
* device instance $765 r0 *1 48.728,-127.215 pfet
M$765 \$218 D|PH_B2|Q|S \$209 VPB|VPWR pfet L=0.15U W=0.42U AS=0.1092P
+ AD=0.0693P PS=1.36U PD=0.75U
* device instance $766 r0 *1 49.208,-127.215 pfet
M$766 \$219 C|D|PH_B3|Q|S \$218 VPB|VPWR pfet L=0.15U W=0.42U AS=0.0693P
+ AD=0.0441P PS=0.75U PD=0.63U
* device instance $767 r0 *1 49.568,-127.215 pfet
M$767 \$220 B|D|PH_B4|Q|S \$219 VPB|VPWR pfet L=0.15U W=0.42U AS=0.0441P
+ AD=0.0693P PS=0.63U PD=0.75U
* device instance $768 r0 *1 50.048,-127.215 pfet
M$768 \$220 A|D|PH_B5|Q|S VPB|VPWR VPB|VPWR pfet L=0.15U W=0.42U AS=0.14825P
+ AD=0.0693P PS=1.34U PD=0.75U
* device instance $769 r0 *1 50.538,-127.505 pfet
M$769 B|X \$209 VPB|VPWR VPB|VPWR pfet L=0.15U W=1U AS=0.14825P AD=0.27P
+ PS=1.34U PD=2.54U
* device instance $770 r0 *1 53.798,-127.215 pfet
M$770 \$221 C|X \$213 VPB|VPWR pfet L=0.15U W=0.42U AS=0.1092P AD=0.0441P
+ PS=1.36U PD=0.63U
* device instance $771 r0 *1 54.158,-127.215 pfet
M$771 \$222 B|X \$221 VPB|VPWR pfet L=0.15U W=0.42U AS=0.0441P AD=0.0693P
+ PS=0.63U PD=0.75U
* device instance $772 r0 *1 54.638,-127.215 pfet
M$772 \$222 A|X VPB|VPWR VPB|VPWR pfet L=0.15U W=0.42U AS=0.14825P AD=0.0693P
+ PS=1.34U PD=0.75U
* device instance $773 r0 *1 55.128,-127.505 pfet
M$773 A|B|BUSY|X \$213 VPB|VPWR VPB|VPWR pfet L=0.15U W=1U AS=0.14825P AD=0.28P
+ PS=1.34U PD=2.56U
* device instance $774 r0 *1 54.068,-123.455 pfet
M$774 \$244 \$242 VPB|VPWR VPB|VPWR pfet L=0.15U W=0.84U AS=0.2184P AD=0.12915P
+ PS=2.2U PD=1.185U
* device instance $775 r0 *1 54.563,-123.245 pfet
M$775 \$245 \$239 \$244 VPB|VPWR pfet L=0.15U W=0.42U AS=0.12915P AD=0.0588P
+ PS=1.185U PD=0.7U
* device instance $776 r0 *1 54.993,-123.245 pfet
M$776 \$254 \$240 \$245 VPB|VPWR pfet L=0.15U W=0.42U AS=0.0588P AD=0.0567P
+ PS=0.7U PD=0.69U
* device instance $777 r0 *1 55.413,-123.245 pfet
M$777 VPB|VPWR \$246 \$254 VPB|VPWR pfet L=0.15U W=0.42U AS=0.0567P AD=0.0819P
+ PS=0.69U PD=0.81U
* device instance $778 r0 *1 55.953,-123.245 pfet
M$778 \$246 RESET_B|RST_B VPB|VPWR VPB|VPWR pfet L=0.15U W=0.42U AS=0.0819P
+ AD=0.0567P PS=0.81U PD=0.69U
* device instance $779 r0 *1 56.373,-123.245 pfet
M$779 VPB|VPWR \$245 \$246 VPB|VPWR pfet L=0.15U W=0.42U AS=0.0567P AD=0.1134P
+ PS=0.69U PD=1.38U
* device instance $780 r0 *1 57.448,-123.535 pfet
M$780 A|A0|B|DOUT9|Q \$246 VPB|VPWR VPB|VPWR pfet L=0.15U W=1U AS=0.3012P
+ AD=0.26P PS=2.66U PD=2.52U
* device instance $781 r0 *1 28.488,-123.385 pfet
M$781 VPB|VPWR CLK|X \$231 VPB|VPWR pfet L=0.15U W=0.64U AS=0.1664P AD=0.0864P
+ PS=1.8U PD=0.91U
* device instance $782 r0 *1 28.908,-123.385 pfet
M$782 \$232 \$231 VPB|VPWR VPB|VPWR pfet L=0.15U W=0.64U AS=0.0864P AD=0.1664P
+ PS=0.91U PD=1.8U
* device instance $783 r0 *1 30.243,-123.245 pfet
M$783 \$233 B|D|PH_B4|Q|S VPB|VPWR VPB|VPWR pfet L=0.15U W=0.42U AS=0.1092P
+ AD=0.0651P PS=1.36U PD=0.73U
* device instance $784 r0 *1 30.703,-123.245 pfet
M$784 \$234 \$232 \$233 VPB|VPWR pfet L=0.15U W=0.42U AS=0.0651P AD=0.07245P
+ PS=0.73U PD=0.765U
* device instance $785 r0 *1 31.198,-123.245 pfet
M$785 \$235 \$231 \$234 VPB|VPWR pfet L=0.15U W=0.42U AS=0.07245P AD=0.1155P
+ PS=0.765U PD=0.97U
* device instance $786 r0 *1 31.898,-123.245 pfet
M$786 VPB|VPWR \$236 \$235 VPB|VPWR pfet L=0.15U W=0.42U AS=0.1155P AD=0.07035P
+ PS=0.97U PD=0.755U
* device instance $787 r0 *1 32.383,-123.245 pfet
M$787 \$235 RESET_B|RST_B VPB|VPWR VPB|VPWR pfet L=0.15U W=0.42U AS=0.07035P
+ AD=0.1092P PS=0.755U PD=1.36U
* device instance $788 r0 *1 49.188,-123.385 pfet
M$788 VPB|VPWR CLK|X \$239 VPB|VPWR pfet L=0.15U W=0.64U AS=0.1664P AD=0.0864P
+ PS=1.8U PD=0.91U
* device instance $789 r0 *1 49.608,-123.385 pfet
M$789 \$240 \$239 VPB|VPWR VPB|VPWR pfet L=0.15U W=0.64U AS=0.0864P AD=0.1664P
+ PS=0.91U PD=1.8U
* device instance $790 r0 *1 50.943,-123.245 pfet
M$790 \$241 D|X$6 VPB|VPWR VPB|VPWR pfet L=0.15U W=0.42U AS=0.1092P AD=0.0651P
+ PS=1.36U PD=0.73U
* device instance $791 r0 *1 51.403,-123.245 pfet
M$791 \$242 \$240 \$241 VPB|VPWR pfet L=0.15U W=0.42U AS=0.0651P AD=0.07245P
+ PS=0.73U PD=0.765U
* device instance $792 r0 *1 51.898,-123.245 pfet
M$792 \$243 \$239 \$242 VPB|VPWR pfet L=0.15U W=0.42U AS=0.07245P AD=0.1155P
+ PS=0.765U PD=0.97U
* device instance $793 r0 *1 52.598,-123.245 pfet
M$793 VPB|VPWR \$244 \$243 VPB|VPWR pfet L=0.15U W=0.42U AS=0.1155P AD=0.07035P
+ PS=0.97U PD=0.755U
* device instance $794 r0 *1 53.083,-123.245 pfet
M$794 \$243 RESET_B|RST_B VPB|VPWR VPB|VPWR pfet L=0.15U W=0.42U AS=0.07035P
+ AD=0.1092P PS=0.755U PD=1.36U
* device instance $795 r0 *1 32.713,-122.16 pfet
M$795 \$280 B|D|PH_B4|Q|S VPB|VPWR VPB|VPWR pfet L=0.15U W=0.42U AS=0.15835P
+ AD=0.07665P PS=1.395U PD=0.785U
* device instance $796 r0 *1 33.228,-122.16 pfet
M$796 \$258 A|A0|B|DOUT4|Q \$280 VPB|VPWR pfet L=0.15U W=0.42U AS=0.07665P
+ AD=0.1932P PS=0.785U PD=1.34U
* device instance $797 r0 *1 34.298,-122.16 pfet
M$797 \$281 A1|COMP_OUT|OUTP \$258 VPB|VPWR pfet L=0.15U W=0.42U AS=0.1932P
+ AD=0.0441P PS=1.34U PD=0.63U
* device instance $798 r0 *1 34.658,-122.16 pfet
M$798 VPB|VPWR \$259 \$281 VPB|VPWR pfet L=0.15U W=0.42U AS=0.0441P AD=0.0693P
+ PS=0.63U PD=0.75U
* device instance $799 r0 *1 35.138,-122.16 pfet
M$799 \$259 B|D|PH_B4|Q|S VPB|VPWR VPB|VPWR pfet L=0.15U W=0.42U AS=0.0693P
+ AD=0.1176P PS=0.75U PD=1.4U
* device instance $800 r0 *1 32.168,-122.065 pfet
M$800 VPB|VPWR \$258 D|X$7 VPB|VPWR pfet L=0.15U W=1U AS=0.26P AD=0.15835P
+ PS=2.52U PD=1.395U
* device instance $801 r0 *1 36.308,-122.215 pfet
M$801 VPB|VPWR CLK|X \$260 VPB|VPWR pfet L=0.15U W=0.64U AS=0.1664P AD=0.0864P
+ PS=1.8U PD=0.91U
* device instance $802 r0 *1 36.728,-122.215 pfet
M$802 \$261 \$260 VPB|VPWR VPB|VPWR pfet L=0.15U W=0.64U AS=0.0864P AD=0.1664P
+ PS=0.91U PD=1.8U
* device instance $803 r0 *1 38.063,-122.355 pfet
M$803 \$262 D|PH_B2|Q|S VPB|VPWR VPB|VPWR pfet L=0.15U W=0.42U AS=0.1092P
+ AD=0.0651P PS=1.36U PD=0.73U
* device instance $804 r0 *1 38.523,-122.355 pfet
M$804 \$263 \$261 \$262 VPB|VPWR pfet L=0.15U W=0.42U AS=0.0651P AD=0.07245P
+ PS=0.73U PD=0.765U
* device instance $805 r0 *1 39.018,-122.355 pfet
M$805 \$264 \$260 \$263 VPB|VPWR pfet L=0.15U W=0.42U AS=0.07245P AD=0.1155P
+ PS=0.765U PD=0.97U
* device instance $806 r0 *1 39.718,-122.355 pfet
M$806 VPB|VPWR \$265 \$264 VPB|VPWR pfet L=0.15U W=0.42U AS=0.1155P AD=0.07035P
+ PS=0.97U PD=0.755U
* device instance $807 r0 *1 40.203,-122.355 pfet
M$807 \$264 RESET_B|RST_B VPB|VPWR VPB|VPWR pfet L=0.15U W=0.42U AS=0.07035P
+ AD=0.1092P PS=0.755U PD=1.36U
* device instance $808 r0 *1 41.683,-122.355 pfet
M$808 \$266 \$260 \$265 VPB|VPWR pfet L=0.15U W=0.42U AS=0.12915P AD=0.0588P
+ PS=1.185U PD=0.7U
* device instance $809 r0 *1 42.113,-122.355 pfet
M$809 \$282 \$261 \$266 VPB|VPWR pfet L=0.15U W=0.42U AS=0.0588P AD=0.0567P
+ PS=0.7U PD=0.69U
* device instance $810 r0 *1 42.533,-122.355 pfet
M$810 VPB|VPWR \$267 \$282 VPB|VPWR pfet L=0.15U W=0.42U AS=0.0567P AD=0.0819P
+ PS=0.69U PD=0.81U
* device instance $811 r0 *1 43.073,-122.355 pfet
M$811 \$267 RESET_B|RST_B VPB|VPWR VPB|VPWR pfet L=0.15U W=0.42U AS=0.0819P
+ AD=0.0567P PS=0.81U PD=0.69U
* device instance $812 r0 *1 43.493,-122.355 pfet
M$812 VPB|VPWR \$266 \$267 VPB|VPWR pfet L=0.15U W=0.42U AS=0.0567P AD=0.1134P
+ PS=0.69U PD=1.38U
* device instance $813 r0 *1 41.188,-122.145 pfet
M$813 \$265 \$263 VPB|VPWR VPB|VPWR pfet L=0.15U W=0.84U AS=0.2184P AD=0.12915P
+ PS=2.2U PD=1.185U
* device instance $814 r0 *1 44.568,-122.065 pfet
M$814 A|D|PH_B1|Q|S \$267 VPB|VPWR VPB|VPWR pfet L=0.15U W=1U AS=0.3012P
+ AD=0.26P PS=2.66U PD=2.52U
* device instance $815 r0 *1 47.893,-122.16 pfet
M$815 \$283 A|D|PH_B1|Q|S VPB|VPWR VPB|VPWR pfet L=0.15U W=0.42U AS=0.15835P
+ AD=0.07665P PS=1.395U PD=0.785U
* device instance $816 r0 *1 48.408,-122.16 pfet
M$816 \$269 A|A0|B|DOUT1|Q \$283 VPB|VPWR pfet L=0.15U W=0.42U AS=0.07665P
+ AD=0.1932P PS=0.785U PD=1.34U
* device instance $817 r0 *1 49.478,-122.16 pfet
M$817 \$284 A1|COMP_OUT|OUTP \$269 VPB|VPWR pfet L=0.15U W=0.42U AS=0.1932P
+ AD=0.0441P PS=1.34U PD=0.63U
* device instance $818 r0 *1 49.838,-122.16 pfet
M$818 VPB|VPWR \$272 \$284 VPB|VPWR pfet L=0.15U W=0.42U AS=0.0441P AD=0.0693P
+ PS=0.63U PD=0.75U
* device instance $819 r0 *1 50.318,-122.16 pfet
M$819 \$272 A|D|PH_B1|Q|S VPB|VPWR VPB|VPWR pfet L=0.15U W=0.42U AS=0.0693P
+ AD=0.1176P PS=0.75U PD=1.4U
* device instance $820 r0 *1 47.348,-122.065 pfet
M$820 VPB|VPWR \$269 D|X$8 VPB|VPWR pfet L=0.15U W=1U AS=0.26P AD=0.15835P
+ PS=2.52U PD=1.395U
* device instance $821 r0 *1 52.953,-122.16 pfet
M$821 \$285 B|D|PH_B0|Q|S VPB|VPWR VPB|VPWR pfet L=0.15U W=0.42U AS=0.15835P
+ AD=0.07665P PS=1.395U PD=0.785U
* device instance $822 r0 *1 53.468,-122.16 pfet
M$822 \$274 A|A0|B|DOUT0|Q \$285 VPB|VPWR pfet L=0.15U W=0.42U AS=0.07665P
+ AD=0.1932P PS=0.785U PD=1.34U
* device instance $823 r0 *1 54.538,-122.16 pfet
M$823 \$286 A1|COMP_OUT|OUTP \$274 VPB|VPWR pfet L=0.15U W=0.42U AS=0.1932P
+ AD=0.0441P PS=1.34U PD=0.63U
* device instance $824 r0 *1 54.898,-122.16 pfet
M$824 VPB|VPWR \$277 \$286 VPB|VPWR pfet L=0.15U W=0.42U AS=0.0441P AD=0.0693P
+ PS=0.63U PD=0.75U
* device instance $825 r0 *1 55.378,-122.16 pfet
M$825 \$277 B|D|PH_B0|Q|S VPB|VPWR VPB|VPWR pfet L=0.15U W=0.42U AS=0.0693P
+ AD=0.1176P PS=0.75U PD=1.4U
* device instance $826 r0 *1 52.408,-122.065 pfet
M$826 VPB|VPWR \$274 D|X$9 VPB|VPWR pfet L=0.15U W=1U AS=0.26P AD=0.15835P
+ PS=2.52U PD=1.395U
* device instance $827 r0 *1 28.488,-117.945 pfet
M$827 VPB|VPWR CLK|X \$299 VPB|VPWR pfet L=0.15U W=0.64U AS=0.1664P AD=0.0864P
+ PS=1.8U PD=0.91U
* device instance $828 r0 *1 28.908,-117.945 pfet
M$828 \$300 \$299 VPB|VPWR VPB|VPWR pfet L=0.15U W=0.64U AS=0.0864P AD=0.1664P
+ PS=0.91U PD=1.8U
* device instance $829 r0 *1 30.243,-117.805 pfet
M$829 \$301 D|X$4 VPB|VPWR VPB|VPWR pfet L=0.15U W=0.42U AS=0.1092P AD=0.0651P
+ PS=1.36U PD=0.73U
* device instance $830 r0 *1 30.703,-117.805 pfet
M$830 \$302 \$300 \$301 VPB|VPWR pfet L=0.15U W=0.42U AS=0.0651P AD=0.07245P
+ PS=0.73U PD=0.765U
* device instance $831 r0 *1 31.198,-117.805 pfet
M$831 \$303 \$299 \$302 VPB|VPWR pfet L=0.15U W=0.42U AS=0.07245P AD=0.1155P
+ PS=0.765U PD=0.97U
* device instance $832 r0 *1 31.898,-117.805 pfet
M$832 VPB|VPWR \$304 \$303 VPB|VPWR pfet L=0.15U W=0.42U AS=0.1155P AD=0.07035P
+ PS=0.97U PD=0.755U
* device instance $833 r0 *1 32.383,-117.805 pfet
M$833 \$303 RESET_B|RST_B VPB|VPWR VPB|VPWR pfet L=0.15U W=0.42U AS=0.07035P
+ AD=0.1092P PS=0.755U PD=1.36U
* device instance $834 r0 *1 31.163,-116.915 pfet
M$834 \$327 D|X$7 VPB|VPWR VPB|VPWR pfet L=0.15U W=0.42U AS=0.1092P AD=0.0651P
+ PS=1.36U PD=0.73U
* device instance $835 r0 *1 31.623,-116.915 pfet
M$835 \$328 \$326 \$327 VPB|VPWR pfet L=0.15U W=0.42U AS=0.0651P AD=0.07245P
+ PS=0.73U PD=0.765U
* device instance $836 r0 *1 32.118,-116.915 pfet
M$836 \$329 \$325 \$328 VPB|VPWR pfet L=0.15U W=0.42U AS=0.07245P AD=0.1155P
+ PS=0.765U PD=0.97U
* device instance $837 r0 *1 32.818,-116.915 pfet
M$837 VPB|VPWR \$330 \$329 VPB|VPWR pfet L=0.15U W=0.42U AS=0.1155P AD=0.07035P
+ PS=0.97U PD=0.755U
* device instance $838 r0 *1 33.303,-116.915 pfet
M$838 \$329 RESET_B|RST_B VPB|VPWR VPB|VPWR pfet L=0.15U W=0.42U AS=0.07035P
+ AD=0.1092P PS=0.755U PD=1.36U
* device instance $839 r0 *1 33.368,-118.015 pfet
M$839 \$304 \$302 VPB|VPWR VPB|VPWR pfet L=0.15U W=0.84U AS=0.2184P AD=0.12915P
+ PS=2.2U PD=1.185U
* device instance $840 r0 *1 33.863,-117.805 pfet
M$840 \$305 \$299 \$304 VPB|VPWR pfet L=0.15U W=0.42U AS=0.12915P AD=0.0588P
+ PS=1.185U PD=0.7U
* device instance $841 r0 *1 34.293,-117.805 pfet
M$841 \$317 \$300 \$305 VPB|VPWR pfet L=0.15U W=0.42U AS=0.0588P AD=0.0567P
+ PS=0.7U PD=0.69U
* device instance $842 r0 *1 34.713,-117.805 pfet
M$842 VPB|VPWR \$306 \$317 VPB|VPWR pfet L=0.15U W=0.42U AS=0.0567P AD=0.0819P
+ PS=0.69U PD=0.81U
* device instance $843 r0 *1 35.253,-117.805 pfet
M$843 \$306 RESET_B|RST_B VPB|VPWR VPB|VPWR pfet L=0.15U W=0.42U AS=0.0819P
+ AD=0.0567P PS=0.81U PD=0.69U
* device instance $844 r0 *1 35.673,-117.805 pfet
M$844 VPB|VPWR \$305 \$306 VPB|VPWR pfet L=0.15U W=0.42U AS=0.0567P AD=0.1134P
+ PS=0.69U PD=1.38U
* device instance $845 r0 *1 34.783,-116.915 pfet
M$845 \$331 \$325 \$330 VPB|VPWR pfet L=0.15U W=0.42U AS=0.12915P AD=0.0588P
+ PS=1.185U PD=0.7U
* device instance $846 r0 *1 35.213,-116.915 pfet
M$846 \$350 \$326 \$331 VPB|VPWR pfet L=0.15U W=0.42U AS=0.0588P AD=0.0567P
+ PS=0.7U PD=0.69U
* device instance $847 r0 *1 35.633,-116.915 pfet
M$847 VPB|VPWR \$332 \$350 VPB|VPWR pfet L=0.15U W=0.42U AS=0.0567P AD=0.0819P
+ PS=0.69U PD=0.81U
* device instance $848 r0 *1 36.173,-116.915 pfet
M$848 \$332 RESET_B|RST_B VPB|VPWR VPB|VPWR pfet L=0.15U W=0.42U AS=0.0819P
+ AD=0.0567P PS=0.81U PD=0.69U
* device instance $849 r0 *1 36.593,-116.915 pfet
M$849 VPB|VPWR \$331 \$332 VPB|VPWR pfet L=0.15U W=0.42U AS=0.0567P AD=0.1134P
+ PS=0.69U PD=1.38U
* device instance $850 r0 *1 34.288,-116.705 pfet
M$850 \$330 \$328 VPB|VPWR VPB|VPWR pfet L=0.15U W=0.84U AS=0.2184P AD=0.12915P
+ PS=2.2U PD=1.185U
* device instance $851 r0 *1 36.748,-118.095 pfet
M$851 A|A0|B|DOUT3|Q \$306 VPB|VPWR VPB|VPWR pfet L=0.15U W=1U AS=0.3012P
+ AD=0.26P PS=2.66U PD=2.52U
* device instance $852 r0 *1 37.668,-116.625 pfet
M$852 A|A0|B|DOUT4|Q \$332 VPB|VPWR VPB|VPWR pfet L=0.15U W=1U AS=0.3012P
+ AD=0.26P PS=2.66U PD=2.52U
* device instance $853 r0 *1 38.608,-116.625 pfet
M$853 VPB|VPWR A|X$1 \$333 VPB|VPWR pfet L=0.15U W=1U AS=0.26P AD=0.135P
+ PS=2.52U PD=1.27U
* device instance $854 r0 *1 39.028,-116.625 pfet
M$854 CLK|X \$333 VPB|VPWR VPB|VPWR pfet L=0.15U W=1U AS=0.135P AD=0.135P
+ PS=1.27U PD=1.27U
* device instance $855 r0 *1 39.448,-116.625 pfet
M$855 VPB|VPWR \$333 CLK|X VPB|VPWR pfet L=0.15U W=1U AS=0.135P AD=0.135P
+ PS=1.27U PD=1.27U
* device instance $856 r0 *1 39.868,-116.625 pfet
M$856 CLK|X \$333 VPB|VPWR VPB|VPWR pfet L=0.15U W=1U AS=0.135P AD=0.135P
+ PS=1.27U PD=1.27U
* device instance $857 r0 *1 40.288,-116.625 pfet
M$857 VPB|VPWR \$333 CLK|X VPB|VPWR pfet L=0.15U W=1U AS=0.135P AD=0.26P
+ PS=1.27U PD=2.52U
* device instance $858 r0 *1 44.043,-116.915 pfet
M$858 \$336 A|D|PH_B1|Q|S VPB|VPWR VPB|VPWR pfet L=0.15U W=0.42U AS=0.1092P
+ AD=0.0651P PS=1.36U PD=0.73U
* device instance $859 r0 *1 44.503,-116.915 pfet
M$859 \$337 \$335 \$336 VPB|VPWR pfet L=0.15U W=0.42U AS=0.0651P AD=0.07245P
+ PS=0.73U PD=0.765U
* device instance $860 r0 *1 44.998,-116.915 pfet
M$860 \$338 \$334 \$337 VPB|VPWR pfet L=0.15U W=0.42U AS=0.07245P AD=0.1155P
+ PS=0.765U PD=0.97U
* device instance $861 r0 *1 45.698,-116.915 pfet
M$861 VPB|VPWR \$339 \$338 VPB|VPWR pfet L=0.15U W=0.42U AS=0.1155P AD=0.07035P
+ PS=0.97U PD=0.755U
* device instance $862 r0 *1 46.183,-116.915 pfet
M$862 \$338 RESET_B|RST_B VPB|VPWR VPB|VPWR pfet L=0.15U W=0.42U AS=0.07035P
+ AD=0.1092P PS=0.755U PD=1.36U
* device instance $863 r0 *1 47.663,-116.915 pfet
M$863 \$340 \$334 \$339 VPB|VPWR pfet L=0.15U W=0.42U AS=0.12915P AD=0.0588P
+ PS=1.185U PD=0.7U
* device instance $864 r0 *1 48.093,-116.915 pfet
M$864 \$351 \$335 \$340 VPB|VPWR pfet L=0.15U W=0.42U AS=0.0588P AD=0.0567P
+ PS=0.7U PD=0.69U
* device instance $865 r0 *1 48.513,-116.915 pfet
M$865 VPB|VPWR \$341 \$351 VPB|VPWR pfet L=0.15U W=0.42U AS=0.0567P AD=0.0819P
+ PS=0.69U PD=0.81U
* device instance $866 r0 *1 49.053,-116.915 pfet
M$866 \$341 RESET_B|RST_B VPB|VPWR VPB|VPWR pfet L=0.15U W=0.42U AS=0.0819P
+ AD=0.0567P PS=0.81U PD=0.69U
* device instance $867 r0 *1 49.473,-116.915 pfet
M$867 VPB|VPWR \$340 \$341 VPB|VPWR pfet L=0.15U W=0.42U AS=0.0567P AD=0.1134P
+ PS=0.69U PD=1.38U
* device instance $868 r0 *1 47.168,-116.705 pfet
M$868 \$339 \$337 VPB|VPWR VPB|VPWR pfet L=0.15U W=0.84U AS=0.2184P AD=0.12915P
+ PS=2.2U PD=1.185U
* device instance $869 r0 *1 49.648,-117.945 pfet
M$869 VPB|VPWR CLK|X \$307 VPB|VPWR pfet L=0.15U W=0.64U AS=0.1664P AD=0.0864P
+ PS=1.8U PD=0.91U
* device instance $870 r0 *1 50.068,-117.945 pfet
M$870 \$308 \$307 VPB|VPWR VPB|VPWR pfet L=0.15U W=0.64U AS=0.0864P AD=0.1664P
+ PS=0.91U PD=1.8U
* device instance $871 r0 *1 50.548,-116.625 pfet
M$871 B|D|PH_B0|Q|S \$341 VPB|VPWR VPB|VPWR pfet L=0.15U W=1U AS=0.3012P
+ AD=0.26P PS=2.66U PD=2.52U
* device instance $872 r0 *1 51.403,-117.805 pfet
M$872 \$309 B|D|PH_B0|Q|S VPB|VPWR VPB|VPWR pfet L=0.15U W=0.42U AS=0.1092P
+ AD=0.0651P PS=1.36U PD=0.73U
* device instance $873 r0 *1 51.863,-117.805 pfet
M$873 \$310 \$308 \$309 VPB|VPWR pfet L=0.15U W=0.42U AS=0.0651P AD=0.07245P
+ PS=0.73U PD=0.765U
* device instance $874 r0 *1 52.358,-117.805 pfet
M$874 \$311 \$307 \$310 VPB|VPWR pfet L=0.15U W=0.42U AS=0.07245P AD=0.1155P
+ PS=0.765U PD=0.97U
* device instance $875 r0 *1 53.058,-117.805 pfet
M$875 VPB|VPWR \$312 \$311 VPB|VPWR pfet L=0.15U W=0.42U AS=0.1155P AD=0.07035P
+ PS=0.97U PD=0.755U
* device instance $876 r0 *1 53.543,-117.805 pfet
M$876 \$311 RESET_B|RST_B VPB|VPWR VPB|VPWR pfet L=0.15U W=0.42U AS=0.07035P
+ AD=0.1092P PS=0.755U PD=1.36U
* device instance $877 r0 *1 53.703,-116.915 pfet
M$877 \$344 D|X$8 VPB|VPWR VPB|VPWR pfet L=0.15U W=0.42U AS=0.1092P AD=0.0651P
+ PS=1.36U PD=0.73U
* device instance $878 r0 *1 54.163,-116.915 pfet
M$878 \$345 \$343 \$344 VPB|VPWR pfet L=0.15U W=0.42U AS=0.0651P AD=0.07245P
+ PS=0.73U PD=0.765U
* device instance $879 r0 *1 54.658,-116.915 pfet
M$879 \$346 \$342 \$345 VPB|VPWR pfet L=0.15U W=0.42U AS=0.07245P AD=0.1155P
+ PS=0.765U PD=0.97U
* device instance $880 r0 *1 55.358,-116.915 pfet
M$880 VPB|VPWR \$347 \$346 VPB|VPWR pfet L=0.15U W=0.42U AS=0.1155P AD=0.07035P
+ PS=0.97U PD=0.755U
* device instance $881 r0 *1 55.843,-116.915 pfet
M$881 \$346 RESET_B|RST_B VPB|VPWR VPB|VPWR pfet L=0.15U W=0.42U AS=0.07035P
+ AD=0.1092P PS=0.755U PD=1.36U
* device instance $882 r0 *1 54.528,-118.015 pfet
M$882 \$312 \$310 VPB|VPWR VPB|VPWR pfet L=0.15U W=0.84U AS=0.2184P AD=0.12915P
+ PS=2.2U PD=1.185U
* device instance $883 r0 *1 55.023,-117.805 pfet
M$883 \$313 \$307 \$312 VPB|VPWR pfet L=0.15U W=0.42U AS=0.12915P AD=0.0588P
+ PS=1.185U PD=0.7U
* device instance $884 r0 *1 55.453,-117.805 pfet
M$884 \$322 \$308 \$313 VPB|VPWR pfet L=0.15U W=0.42U AS=0.0588P AD=0.0567P
+ PS=0.7U PD=0.69U
* device instance $885 r0 *1 55.873,-117.805 pfet
M$885 VPB|VPWR \$314 \$322 VPB|VPWR pfet L=0.15U W=0.42U AS=0.0567P AD=0.0819P
+ PS=0.69U PD=0.81U
* device instance $886 r0 *1 56.413,-117.805 pfet
M$886 \$314 RESET_B|RST_B VPB|VPWR VPB|VPWR pfet L=0.15U W=0.42U AS=0.0819P
+ AD=0.0567P PS=0.81U PD=0.69U
* device instance $887 r0 *1 56.833,-117.805 pfet
M$887 VPB|VPWR \$313 \$314 VPB|VPWR pfet L=0.15U W=0.42U AS=0.0567P AD=0.1134P
+ PS=0.69U PD=1.38U
* device instance $888 r0 *1 56.558,-121.775 pfet
M$888 \$287 C|PH_EOC|Q \$279 VPB|VPWR pfet L=0.15U W=0.42U AS=0.1092P
+ AD=0.0441P PS=1.36U PD=0.63U
* device instance $889 r0 *1 56.918,-121.775 pfet
M$889 \$288 B|D|PH_B0|Q|S \$287 VPB|VPWR pfet L=0.15U W=0.42U AS=0.0441P
+ AD=0.0693P PS=0.63U PD=0.75U
* device instance $890 r0 *1 57.398,-121.775 pfet
M$890 \$288 A|D|PH_B1|Q|S VPB|VPWR VPB|VPWR pfet L=0.15U W=0.42U AS=0.14825P
+ AD=0.0693P PS=1.34U PD=0.75U
* device instance $891 r0 *1 57.888,-122.065 pfet
M$891 C|X \$279 VPB|VPWR VPB|VPWR pfet L=0.15U W=1U AS=0.14825P AD=0.28P
+ PS=1.34U PD=2.56U
* device instance $892 r0 *1 57.323,-116.915 pfet
M$892 \$348 \$342 \$347 VPB|VPWR pfet L=0.15U W=0.42U AS=0.12915P AD=0.0588P
+ PS=1.185U PD=0.7U
* device instance $893 r0 *1 57.753,-116.915 pfet
M$893 \$352 \$343 \$348 VPB|VPWR pfet L=0.15U W=0.42U AS=0.0588P AD=0.0567P
+ PS=0.7U PD=0.69U
* device instance $894 r0 *1 58.173,-116.915 pfet
M$894 VPB|VPWR \$349 \$352 VPB|VPWR pfet L=0.15U W=0.42U AS=0.0567P AD=0.0819P
+ PS=0.69U PD=0.81U
* device instance $895 r0 *1 58.713,-116.915 pfet
M$895 \$349 RESET_B|RST_B VPB|VPWR VPB|VPWR pfet L=0.15U W=0.42U AS=0.0819P
+ AD=0.0567P PS=0.81U PD=0.69U
* device instance $896 r0 *1 59.133,-116.915 pfet
M$896 VPB|VPWR \$348 \$349 VPB|VPWR pfet L=0.15U W=0.42U AS=0.0567P AD=0.1134P
+ PS=0.69U PD=1.38U
* device instance $897 r0 *1 56.828,-116.705 pfet
M$897 \$347 \$345 VPB|VPWR VPB|VPWR pfet L=0.15U W=0.84U AS=0.2184P AD=0.12915P
+ PS=2.2U PD=1.185U
* device instance $898 r0 *1 57.908,-118.095 pfet
M$898 C|PH_EOC|Q \$314 VPB|VPWR VPB|VPWR pfet L=0.15U W=1U AS=0.3012P AD=0.26P
+ PS=2.66U PD=2.52U
* device instance $899 r0 *1 60.208,-116.625 pfet
M$899 A|A0|B|DOUT1|Q \$349 VPB|VPWR VPB|VPWR pfet L=0.15U W=1U AS=0.3012P
+ AD=0.26P PS=2.66U PD=2.52U
* device instance $900 r0 *1 28.488,-112.505 pfet
M$900 VPB|VPWR CLK|X \$365 VPB|VPWR pfet L=0.15U W=0.64U AS=0.1664P AD=0.0864P
+ PS=1.8U PD=0.91U
* device instance $901 r0 *1 28.908,-112.505 pfet
M$901 \$366 \$365 VPB|VPWR VPB|VPWR pfet L=0.15U W=0.64U AS=0.0864P AD=0.1664P
+ PS=0.91U PD=1.8U
* device instance $902 r0 *1 29.408,-116.775 pfet
M$902 VPB|VPWR CLK|X \$325 VPB|VPWR pfet L=0.15U W=0.64U AS=0.1664P AD=0.0864P
+ PS=1.8U PD=0.91U
* device instance $903 r0 *1 29.828,-116.775 pfet
M$903 \$326 \$325 VPB|VPWR VPB|VPWR pfet L=0.15U W=0.64U AS=0.0864P AD=0.1664P
+ PS=0.91U PD=1.8U
* device instance $904 r0 *1 30.243,-112.365 pfet
M$904 \$367 C|D|PH_B3|Q|S VPB|VPWR VPB|VPWR pfet L=0.15U W=0.42U AS=0.1092P
+ AD=0.0651P PS=1.36U PD=0.73U
* device instance $905 r0 *1 30.703,-112.365 pfet
M$905 \$368 \$366 \$367 VPB|VPWR pfet L=0.15U W=0.42U AS=0.0651P AD=0.07245P
+ PS=0.73U PD=0.765U
* device instance $906 r0 *1 31.198,-112.365 pfet
M$906 \$369 \$365 \$368 VPB|VPWR pfet L=0.15U W=0.42U AS=0.07245P AD=0.1155P
+ PS=0.765U PD=0.97U
* device instance $907 r0 *1 31.898,-112.365 pfet
M$907 VPB|VPWR \$370 \$369 VPB|VPWR pfet L=0.15U W=0.42U AS=0.1155P AD=0.07035P
+ PS=0.97U PD=0.755U
* device instance $908 r0 *1 32.383,-112.365 pfet
M$908 \$369 RESET_B|RST_B VPB|VPWR VPB|VPWR pfet L=0.15U W=0.42U AS=0.07035P
+ AD=0.1092P PS=0.755U PD=1.36U
* device instance $909 r0 *1 33.368,-112.575 pfet
M$909 \$370 \$368 VPB|VPWR VPB|VPWR pfet L=0.15U W=0.84U AS=0.2184P AD=0.12915P
+ PS=2.2U PD=1.185U
* device instance $910 r0 *1 33.863,-112.365 pfet
M$910 \$371 \$365 \$370 VPB|VPWR pfet L=0.15U W=0.42U AS=0.12915P AD=0.0588P
+ PS=1.185U PD=0.7U
* device instance $911 r0 *1 34.293,-112.365 pfet
M$911 \$384 \$366 \$371 VPB|VPWR pfet L=0.15U W=0.42U AS=0.0588P AD=0.0567P
+ PS=0.7U PD=0.69U
* device instance $912 r0 *1 34.713,-112.365 pfet
M$912 VPB|VPWR \$372 \$384 VPB|VPWR pfet L=0.15U W=0.42U AS=0.0567P AD=0.0819P
+ PS=0.69U PD=0.81U
* device instance $913 r0 *1 35.253,-112.365 pfet
M$913 \$372 RESET_B|RST_B VPB|VPWR VPB|VPWR pfet L=0.15U W=0.42U AS=0.0819P
+ AD=0.0567P PS=0.81U PD=0.69U
* device instance $914 r0 *1 35.673,-112.365 pfet
M$914 VPB|VPWR \$371 \$372 VPB|VPWR pfet L=0.15U W=0.42U AS=0.0567P AD=0.1134P
+ PS=0.69U PD=1.38U
* device instance $915 r0 *1 36.748,-112.655 pfet
M$915 D|PH_B2|Q|S \$372 VPB|VPWR VPB|VPWR pfet L=0.15U W=1U AS=0.3012P AD=0.26P
+ PS=2.66U PD=2.52U
* device instance $916 r0 *1 42.288,-116.775 pfet
M$916 VPB|VPWR CLK|X \$334 VPB|VPWR pfet L=0.15U W=0.64U AS=0.1664P AD=0.0864P
+ PS=1.8U PD=0.91U
* device instance $917 r0 *1 42.708,-116.775 pfet
M$917 \$335 \$334 VPB|VPWR VPB|VPWR pfet L=0.15U W=0.64U AS=0.0864P AD=0.1664P
+ PS=0.91U PD=1.8U
* device instance $918 r0 *1 51.948,-116.775 pfet
M$918 VPB|VPWR CLK|X \$342 VPB|VPWR pfet L=0.15U W=0.64U AS=0.1664P AD=0.0864P
+ PS=1.8U PD=0.91U
* device instance $919 r0 *1 52.368,-116.775 pfet
M$919 \$343 \$342 VPB|VPWR VPB|VPWR pfet L=0.15U W=0.64U AS=0.0864P AD=0.1664P
+ PS=0.91U PD=1.8U
* device instance $920 r0 *1 51.948,-112.505 pfet
M$920 VPB|VPWR CLK|X \$373 VPB|VPWR pfet L=0.15U W=0.64U AS=0.1664P AD=0.0864P
+ PS=1.8U PD=0.91U
* device instance $921 r0 *1 52.368,-112.505 pfet
M$921 \$374 \$373 VPB|VPWR VPB|VPWR pfet L=0.15U W=0.64U AS=0.0864P AD=0.1664P
+ PS=0.91U PD=1.8U
* device instance $922 r0 *1 53.703,-112.365 pfet
M$922 \$375 D|X$9 VPB|VPWR VPB|VPWR pfet L=0.15U W=0.42U AS=0.1092P AD=0.0651P
+ PS=1.36U PD=0.73U
* device instance $923 r0 *1 54.163,-112.365 pfet
M$923 \$376 \$374 \$375 VPB|VPWR pfet L=0.15U W=0.42U AS=0.0651P AD=0.07245P
+ PS=0.73U PD=0.765U
* device instance $924 r0 *1 54.658,-112.365 pfet
M$924 \$377 \$373 \$376 VPB|VPWR pfet L=0.15U W=0.42U AS=0.07245P AD=0.1155P
+ PS=0.765U PD=0.97U
* device instance $925 r0 *1 55.358,-112.365 pfet
M$925 VPB|VPWR \$378 \$377 VPB|VPWR pfet L=0.15U W=0.42U AS=0.1155P AD=0.07035P
+ PS=0.97U PD=0.755U
* device instance $926 r0 *1 55.843,-112.365 pfet
M$926 \$377 RESET_B|RST_B VPB|VPWR VPB|VPWR pfet L=0.15U W=0.42U AS=0.07035P
+ AD=0.1092P PS=0.755U PD=1.36U
* device instance $927 r0 *1 56.828,-112.575 pfet
M$927 \$378 \$376 VPB|VPWR VPB|VPWR pfet L=0.15U W=0.84U AS=0.2184P AD=0.12915P
+ PS=2.2U PD=1.185U
* device instance $928 r0 *1 57.323,-112.365 pfet
M$928 \$379 \$373 \$378 VPB|VPWR pfet L=0.15U W=0.42U AS=0.12915P AD=0.0588P
+ PS=1.185U PD=0.7U
* device instance $929 r0 *1 57.753,-112.365 pfet
M$929 \$389 \$374 \$379 VPB|VPWR pfet L=0.15U W=0.42U AS=0.0588P AD=0.0567P
+ PS=0.7U PD=0.69U
* device instance $930 r0 *1 58.173,-112.365 pfet
M$930 VPB|VPWR \$380 \$389 VPB|VPWR pfet L=0.15U W=0.42U AS=0.0567P AD=0.0819P
+ PS=0.69U PD=0.81U
* device instance $931 r0 *1 58.713,-112.365 pfet
M$931 \$380 RESET_B|RST_B VPB|VPWR VPB|VPWR pfet L=0.15U W=0.42U AS=0.0819P
+ AD=0.0567P PS=0.81U PD=0.69U
* device instance $932 r0 *1 59.133,-112.365 pfet
M$932 VPB|VPWR \$379 \$380 VPB|VPWR pfet L=0.15U W=0.42U AS=0.0567P AD=0.1134P
+ PS=0.69U PD=1.38U
* device instance $933 r0 *1 60.208,-112.655 pfet
M$933 A|A0|B|DOUT0|Q \$380 VPB|VPWR VPB|VPWR pfet L=0.15U W=1U AS=0.3012P
+ AD=0.26P PS=2.66U PD=2.52U
* device instance $934 r0 *1 98.985,-94.865 pfet
M$934 \$398 B|Y \$391 VPB|VPWR pfet L=0.15U W=1U AS=0.26P AD=0.135P PS=2.52U
+ PD=1.27U
* device instance $935 r0 *1 99.405,-94.865 pfet
M$935 VPB|VPWR A|A0|B|DOUT8|Q \$398 VPB|VPWR pfet L=0.15U W=1U AS=0.135P
+ AD=0.135P PS=1.27U PD=1.27U
* device instance $936 r0 *1 99.825,-94.865 pfet
M$936 \$394 A|A0|B|DOUT8|Q VPB|VPWR VPB|VPWR pfet L=0.15U W=1U AS=0.135P
+ AD=0.135P PS=1.27U PD=1.27U
* device instance $937 r0 *1 100.245,-94.865 pfet
M$937 VPB|VPWR B|Y \$394 VPB|VPWR pfet L=0.15U W=1U AS=0.135P AD=0.26P PS=1.27U
+ PD=2.52U
* device instance $938 r0 *1 101.185,-94.865 pfet
M$938 ADCOUT8|X \$391 \$394 VPB|VPWR pfet L=0.15U W=1U AS=0.26P AD=0.3P
+ PS=2.52U PD=2.6U
* device instance $939 r0 *1 108.785,-90.815 pfet
M$939 \$402 A|A0|B|DOUT9|Q VPB|VPWR VPB|VPWR pfet L=0.15U W=0.42U AS=0.1176P
+ AD=0.0567P PS=1.4U PD=0.69U
* device instance $940 r0 *1 109.205,-90.815 pfet
M$940 \$402 A|A0|B|DOUT6|Q VPB|VPWR VPB|VPWR pfet L=0.15U W=0.42U AS=0.16655P
+ AD=0.0567P PS=1.39U PD=0.69U
* device instance $941 r0 *1 109.745,-90.895 pfet
M$941 SELp6|X \$402 VPB|VPWR VPB|VPWR pfet L=0.15U W=1U AS=0.16655P AD=0.475P
+ PS=1.39U PD=2.95U
* device instance $942 r0 *1 115.13,-90.8 pfet
M$942 \$413 A|A_N|D|PH_B9|Q|S VPB|VPWR VPB|VPWR pfet L=0.15U W=0.42U
+ AS=0.15835P AD=0.07665P PS=1.395U PD=0.785U
* device instance $943 r0 *1 115.645,-90.8 pfet
M$943 \$405 A|A0|B|DOUT9|Q \$413 VPB|VPWR pfet L=0.15U W=0.42U AS=0.07665P
+ AD=0.1932P PS=0.785U PD=1.34U
* device instance $944 r0 *1 116.715,-90.8 pfet
M$944 \$415 A|A1|OUTN|OUTN_NC \$405 VPB|VPWR pfet L=0.15U W=0.42U AS=0.1932P
+ AD=0.0441P PS=1.34U PD=0.63U
* device instance $945 r0 *1 117.075,-90.8 pfet
M$945 VPB|VPWR \$407 \$415 VPB|VPWR pfet L=0.15U W=0.42U AS=0.0441P AD=0.0693P
+ PS=0.63U PD=0.75U
* device instance $946 r0 *1 117.555,-90.8 pfet
M$946 \$407 A|A_N|D|PH_B9|Q|S VPB|VPWR VPB|VPWR pfet L=0.15U W=0.42U AS=0.0693P
+ AD=0.1176P PS=0.75U PD=1.4U
* device instance $947 r0 *1 114.585,-90.895 pfet
M$947 VPB|VPWR \$405 DUMLOAD_MUX_NC|X VPB|VPWR pfet L=0.15U W=1U AS=0.26P
+ AD=0.15835P PS=2.52U PD=1.395U
* device instance $948 r0 *1 127.645,-94.945 pfet
M$948 \$396 A|A0|B|DOUT1|Q VPB|VPWR VPB|VPWR pfet L=0.15U W=0.42U AS=0.1176P
+ AD=0.0567P PS=1.4U PD=0.69U
* device instance $949 r0 *1 128.065,-94.945 pfet
M$949 \$396 B|Y VPB|VPWR VPB|VPWR pfet L=0.15U W=0.42U AS=0.16655P AD=0.0567P
+ PS=1.39U PD=0.69U
* device instance $950 r0 *1 128.605,-94.865 pfet
M$950 SELn1|X \$396 VPB|VPWR VPB|VPWR pfet L=0.15U W=1U AS=0.16655P AD=0.475P
+ PS=1.39U PD=2.95U
* device instance $951 r0 *1 136.845,-90.815 pfet
M$951 \$409 A|A0|B|DOUT9|Q VPB|VPWR VPB|VPWR pfet L=0.15U W=0.42U AS=0.1176P
+ AD=0.0567P PS=1.4U PD=0.69U
* device instance $952 r0 *1 137.265,-90.815 pfet
M$952 \$409 A|A0|B|DOUT4|Q VPB|VPWR VPB|VPWR pfet L=0.15U W=0.42U AS=0.16655P
+ AD=0.0567P PS=1.39U PD=0.69U
* device instance $953 r0 *1 137.805,-90.895 pfet
M$953 SELp4|X \$409 VPB|VPWR VPB|VPWR pfet L=0.15U W=1U AS=0.16655P AD=0.475P
+ PS=1.39U PD=2.95U
* device instance $954 r0 *1 98.065,-89.425 pfet
M$954 \$438 B|Y \$417 VPB|VPWR pfet L=0.15U W=1U AS=0.26P AD=0.135P PS=2.52U
+ PD=1.27U
* device instance $955 r0 *1 98.485,-89.425 pfet
M$955 VPB|VPWR A|A0|B|DOUT2|Q \$438 VPB|VPWR pfet L=0.15U W=1U AS=0.135P
+ AD=0.135P PS=1.27U PD=1.27U
* device instance $956 r0 *1 98.905,-89.425 pfet
M$956 \$419 A|A0|B|DOUT2|Q VPB|VPWR VPB|VPWR pfet L=0.15U W=1U AS=0.135P
+ AD=0.135P PS=1.27U PD=1.27U
* device instance $957 r0 *1 99.325,-89.425 pfet
M$957 VPB|VPWR B|Y \$419 VPB|VPWR pfet L=0.15U W=1U AS=0.135P AD=0.26P PS=1.27U
+ PD=2.52U
* device instance $958 r0 *1 100.265,-89.425 pfet
M$958 ADCOUT2|X \$417 \$419 VPB|VPWR pfet L=0.15U W=1U AS=0.26P AD=0.3P
+ PS=2.52U PD=2.6U
* device instance $959 r0 *1 102.205,-89.425 pfet
M$959 \$439 B|Y \$421 VPB|VPWR pfet L=0.15U W=1U AS=0.26P AD=0.135P PS=2.52U
+ PD=1.27U
* device instance $960 r0 *1 102.625,-89.425 pfet
M$960 VPB|VPWR A|A0|B|DOUT3|Q \$439 VPB|VPWR pfet L=0.15U W=1U AS=0.135P
+ AD=0.135P PS=1.27U PD=1.27U
* device instance $961 r0 *1 103.045,-89.425 pfet
M$961 \$422 A|A0|B|DOUT3|Q VPB|VPWR VPB|VPWR pfet L=0.15U W=1U AS=0.135P
+ AD=0.135P PS=1.27U PD=1.27U
* device instance $962 r0 *1 103.465,-89.425 pfet
M$962 VPB|VPWR B|Y \$422 VPB|VPWR pfet L=0.15U W=1U AS=0.135P AD=0.26P PS=1.27U
+ PD=2.52U
* device instance $963 r0 *1 104.405,-89.425 pfet
M$963 ADCOUT3|X \$421 \$422 VPB|VPWR pfet L=0.15U W=1U AS=0.26P AD=0.3P
+ PS=2.52U PD=2.6U
* device instance $964 r0 *1 107.265,-89.425 pfet
M$964 \$440 B|Y \$424 VPB|VPWR pfet L=0.15U W=1U AS=0.26P AD=0.135P PS=2.52U
+ PD=1.27U
* device instance $965 r0 *1 107.685,-89.425 pfet
M$965 VPB|VPWR A|A0|B|DOUT7|Q \$440 VPB|VPWR pfet L=0.15U W=1U AS=0.135P
+ AD=0.135P PS=1.27U PD=1.27U
* device instance $966 r0 *1 108.105,-89.425 pfet
M$966 \$426 A|A0|B|DOUT7|Q VPB|VPWR VPB|VPWR pfet L=0.15U W=1U AS=0.135P
+ AD=0.135P PS=1.27U PD=1.27U
* device instance $967 r0 *1 108.525,-89.425 pfet
M$967 VPB|VPWR B|Y \$426 VPB|VPWR pfet L=0.15U W=1U AS=0.135P AD=0.26P PS=1.27U
+ PD=2.52U
* device instance $968 r0 *1 109.465,-89.425 pfet
M$968 ADCOUT7|X \$424 \$426 VPB|VPWR pfet L=0.15U W=1U AS=0.26P AD=0.3P
+ PS=2.52U PD=2.6U
* device instance $969 r0 *1 120.145,-89.425 pfet
M$969 \$441 B|Y \$431 VPB|VPWR pfet L=0.15U W=1U AS=0.26P AD=0.135P PS=2.52U
+ PD=1.27U
* device instance $970 r0 *1 120.565,-89.425 pfet
M$970 VPB|VPWR A|A0|B|DOUT4|Q \$441 VPB|VPWR pfet L=0.15U W=1U AS=0.135P
+ AD=0.135P PS=1.27U PD=1.27U
* device instance $971 r0 *1 120.985,-89.425 pfet
M$971 \$432 A|A0|B|DOUT4|Q VPB|VPWR VPB|VPWR pfet L=0.15U W=1U AS=0.135P
+ AD=0.135P PS=1.27U PD=1.27U
* device instance $972 r0 *1 121.405,-89.425 pfet
M$972 VPB|VPWR B|Y \$432 VPB|VPWR pfet L=0.15U W=1U AS=0.135P AD=0.26P PS=1.27U
+ PD=2.52U
* device instance $973 r0 *1 122.345,-89.425 pfet
M$973 ADCOUT4|X \$431 \$432 VPB|VPWR pfet L=0.15U W=1U AS=0.26P AD=0.3P
+ PS=2.52U PD=2.6U
* device instance $974 r0 *1 135.03,-89.425 pfet
M$974 B|Y A|A0|B|DOUT9|Q VPB|VPWR VPB|VPWR pfet L=0.15U W=1U AS=0.26P AD=0.26P
+ PS=2.52U PD=2.52U
* device instance $975 r0 *1 97.145,-85.455 pfet
M$975 \$482 B|Y \$450 VPB|VPWR pfet L=0.15U W=1U AS=0.26P AD=0.135P PS=2.52U
+ PD=1.27U
* device instance $976 r0 *1 97.565,-85.455 pfet
M$976 VPB|VPWR A|A0|B|DOUT0|Q \$482 VPB|VPWR pfet L=0.15U W=1U AS=0.135P
+ AD=0.135P PS=1.27U PD=1.27U
* device instance $977 r0 *1 97.985,-85.455 pfet
M$977 \$480 A|A0|B|DOUT0|Q VPB|VPWR VPB|VPWR pfet L=0.15U W=1U AS=0.135P
+ AD=0.135P PS=1.27U PD=1.27U
* device instance $978 r0 *1 98.405,-85.455 pfet
M$978 VPB|VPWR B|Y \$480 VPB|VPWR pfet L=0.15U W=1U AS=0.135P AD=0.26P PS=1.27U
+ PD=2.52U
* device instance $979 r0 *1 99.345,-85.455 pfet
M$979 ADCOUT0|X \$450 \$480 VPB|VPWR pfet L=0.15U W=1U AS=0.26P AD=0.3P
+ PS=2.52U PD=2.6U
* device instance $980 r0 *1 102.83,-85.455 pfet
M$980 HALF_LSB_ENN|Y A|HALF_LSB_EN|X VPB|VPWR VPB|VPWR pfet L=0.15U W=1U
+ AS=0.26P AD=0.26P PS=2.52U PD=2.52U
* device instance $981 r0 *1 110.625,-89.505 pfet
M$981 \$427 A|A0|B|DOUT7|Q VPB|VPWR VPB|VPWR pfet L=0.15U W=0.42U AS=0.1176P
+ AD=0.0567P PS=1.4U PD=0.69U
* device instance $982 r0 *1 111.045,-89.505 pfet
M$982 \$427 B|Y VPB|VPWR VPB|VPWR pfet L=0.15U W=0.42U AS=0.16655P AD=0.0567P
+ PS=1.39U PD=0.69U
* device instance $983 r0 *1 111.585,-89.425 pfet
M$983 SELn7|X \$427 VPB|VPWR VPB|VPWR pfet L=0.15U W=1U AS=0.16655P AD=0.475P
+ PS=1.39U PD=2.95U
* device instance $984 r0 *1 113.705,-85.455 pfet
M$984 \$459 A|A0|B|DOUT9|Q VPB|VPWR VPB|VPWR pfet L=0.15U W=1U AS=0.3P
+ AD=0.135P PS=2.6U PD=1.27U
* device instance $985 r0 *1 114.125,-85.455 pfet
M$985 VPB|VPWR A|A1|OUTN|OUTN_NC \$459 VPB|VPWR pfet L=0.15U W=1U AS=0.135P
+ AD=0.365P PS=1.27U PD=1.73U
* device instance $986 r0 *1 115.005,-85.455 pfet
M$986 \$483 A|A1|OUTN|OUTN_NC VPB|VPWR VPB|VPWR pfet L=0.15U W=1U AS=0.365P
+ AD=0.105P PS=1.73U PD=1.21U
* device instance $987 r0 *1 115.365,-85.455 pfet
M$987 DUMLOAD_XNOR_NC|Y A|A0|B|DOUT9|Q \$483 VPB|VPWR pfet L=0.15U W=1U
+ AS=0.105P AD=0.165P PS=1.21U PD=1.33U
* device instance $988 r0 *1 115.845,-85.455 pfet
M$988 VPB|VPWR \$459 DUMLOAD_XNOR_NC|Y VPB|VPWR pfet L=0.15U W=1U AS=0.165P
+ AD=0.36P PS=1.33U PD=2.72U
* device instance $989 r0 *1 117.525,-89.505 pfet
M$989 \$429 A|A0|B|DOUT9|Q VPB|VPWR VPB|VPWR pfet L=0.15U W=0.42U AS=0.1176P
+ AD=0.0567P PS=1.4U PD=0.69U
* device instance $990 r0 *1 117.945,-89.505 pfet
M$990 \$429 A|A0|B|DOUT1|Q VPB|VPWR VPB|VPWR pfet L=0.15U W=0.42U AS=0.16655P
+ AD=0.0567P PS=1.39U PD=0.69U
* device instance $991 r0 *1 118.485,-89.425 pfet
M$991 SELp1|X \$429 VPB|VPWR VPB|VPWR pfet L=0.15U W=1U AS=0.16655P AD=0.475P
+ PS=1.39U PD=2.95U
* device instance $992 r0 *1 121.525,-85.455 pfet
M$992 \$484 B|Y \$462 VPB|VPWR pfet L=0.15U W=1U AS=0.26P AD=0.135P PS=2.52U
+ PD=1.27U
* device instance $993 r0 *1 121.945,-85.455 pfet
M$993 VPB|VPWR A|A0|B|DOUT5|Q \$484 VPB|VPWR pfet L=0.15U W=1U AS=0.135P
+ AD=0.135P PS=1.27U PD=1.27U
* device instance $994 r0 *1 122.365,-85.455 pfet
M$994 \$481 A|A0|B|DOUT5|Q VPB|VPWR VPB|VPWR pfet L=0.15U W=1U AS=0.135P
+ AD=0.135P PS=1.27U PD=1.27U
* device instance $995 r0 *1 122.785,-85.455 pfet
M$995 VPB|VPWR B|Y \$481 VPB|VPWR pfet L=0.15U W=1U AS=0.135P AD=0.26P PS=1.27U
+ PD=2.52U
* device instance $996 r0 *1 123.725,-85.455 pfet
M$996 ADCOUT5|X \$462 \$481 VPB|VPWR pfet L=0.15U W=1U AS=0.26P AD=0.3P
+ PS=2.52U PD=2.6U
* device instance $997 r0 *1 124.91,-85.455 pfet
M$997 CLK|CLKN|Y A|CLK VPB|VPWR VPB|VPWR pfet L=0.15U W=1U AS=0.26P AD=0.26P
+ PS=2.52U PD=2.52U
* device instance $998 r0 *1 127.185,-89.505 pfet
M$998 \$434 A|A0|B|DOUT9|Q VPB|VPWR VPB|VPWR pfet L=0.15U W=0.42U AS=0.1176P
+ AD=0.0567P PS=1.4U PD=0.69U
* device instance $999 r0 *1 127.605,-89.505 pfet
M$999 \$434 A|A0|B|DOUT7|Q VPB|VPWR VPB|VPWR pfet L=0.15U W=0.42U AS=0.16655P
+ AD=0.0567P PS=1.39U PD=0.69U
* device instance $1000 r0 *1 128.145,-89.425 pfet
M$1000 SELp7|X \$434 VPB|VPWR VPB|VPWR pfet L=0.15U W=1U AS=0.16655P AD=0.475P
+ PS=1.39U PD=2.95U
* device instance $1001 r0 *1 136.845,-89.505 pfet
M$1001 \$436 A|A0|B|DOUT6|Q VPB|VPWR VPB|VPWR pfet L=0.15U W=0.42U AS=0.1176P
+ AD=0.0567P PS=1.4U PD=0.69U
* device instance $1002 r0 *1 137.265,-89.505 pfet
M$1002 \$436 B|Y VPB|VPWR VPB|VPWR pfet L=0.15U W=0.42U AS=0.16655P AD=0.0567P
+ PS=1.39U PD=0.69U
* device instance $1003 r0 *1 137.805,-89.425 pfet
M$1003 SELn6|X \$436 VPB|VPWR VPB|VPWR pfet L=0.15U W=1U AS=0.16655P AD=0.475P
+ PS=1.39U PD=2.95U
* device instance $1004 r0 *1 107.405,-85.375 pfet
M$1004 \$453 A|A0|B|DOUT9|Q VPB|VPWR VPB|VPWR pfet L=0.15U W=0.42U AS=0.1176P
+ AD=0.0567P PS=1.4U PD=0.69U
* device instance $1005 r0 *1 107.825,-85.375 pfet
M$1005 \$453 A|A0|B|DOUT0|Q VPB|VPWR VPB|VPWR pfet L=0.15U W=0.42U AS=0.16655P
+ AD=0.0567P PS=1.39U PD=0.69U
* device instance $1006 r0 *1 108.365,-85.455 pfet
M$1006 SELp0|X \$453 VPB|VPWR VPB|VPWR pfet L=0.15U W=1U AS=0.16655P AD=0.475P
+ PS=1.39U PD=2.95U
* device instance $1007 r0 *1 110.165,-85.375 pfet
M$1007 \$455 A|A0|B|DOUT3|Q VPB|VPWR VPB|VPWR pfet L=0.15U W=0.42U AS=0.1176P
+ AD=0.0567P PS=1.4U PD=0.69U
* device instance $1008 r0 *1 110.585,-85.375 pfet
M$1008 \$455 B|Y VPB|VPWR VPB|VPWR pfet L=0.15U W=0.42U AS=0.16655P AD=0.0567P
+ PS=1.39U PD=0.69U
* device instance $1009 r0 *1 111.125,-85.455 pfet
M$1009 SELn3|X \$455 VPB|VPWR VPB|VPWR pfet L=0.15U W=1U AS=0.16655P AD=0.475P
+ PS=1.39U PD=2.95U
* device instance $1010 r0 *1 114.585,-84.275 pfet
M$1010 VPB|VPWR A|A_N|D|PH_B9|Q|S \$489 VPB|VPWR pfet L=0.15U W=0.42U
+ AS=0.1092P AD=0.0714P PS=1.36U PD=0.76U
* device instance $1011 r0 *1 115.075,-84.275 pfet
M$1011 \$490 \$489 VPB|VPWR VPB|VPWR pfet L=0.15U W=0.42U AS=0.0714P AD=0.0609P
+ PS=0.76U PD=0.71U
* device instance $1012 r0 *1 115.515,-84.275 pfet
M$1012 VPB|VPWR A|B|BUSY|X \$490 VPB|VPWR pfet L=0.15U W=0.42U AS=0.0609P
+ AD=0.2279P PS=0.71U PD=1.74U
* device instance $1013 r0 *1 116.405,-83.985 pfet
M$1013 A|HALF_LSB_EN|X \$490 VPB|VPWR VPB|VPWR pfet L=0.15U W=1U AS=0.2279P
+ AD=0.26P PS=1.74U PD=2.52U
* device instance $1014 r0 *1 118.305,-83.985 pfet
M$1014 \$503 B|Y \$491 VPB|VPWR pfet L=0.15U W=1U AS=0.26P AD=0.135P PS=2.52U
+ PD=1.27U
* device instance $1015 r0 *1 118.725,-83.985 pfet
M$1015 VPB|VPWR A|A0|B|DOUT1|Q \$503 VPB|VPWR pfet L=0.15U W=1U AS=0.135P
+ AD=0.135P PS=1.27U PD=1.27U
* device instance $1016 r0 *1 119.145,-83.985 pfet
M$1016 \$492 A|A0|B|DOUT1|Q VPB|VPWR VPB|VPWR pfet L=0.15U W=1U AS=0.135P
+ AD=0.135P PS=1.27U PD=1.27U
* device instance $1017 r0 *1 119.565,-83.985 pfet
M$1017 VPB|VPWR B|Y \$492 VPB|VPWR pfet L=0.15U W=1U AS=0.135P AD=0.26P
+ PS=1.27U PD=2.52U
* device instance $1018 r0 *1 119.365,-85.375 pfet
M$1018 \$460 A|A0|B|DOUT2|Q VPB|VPWR VPB|VPWR pfet L=0.15U W=0.42U AS=0.1176P
+ AD=0.0567P PS=1.4U PD=0.69U
* device instance $1019 r0 *1 119.785,-85.375 pfet
M$1019 \$460 B|Y VPB|VPWR VPB|VPWR pfet L=0.15U W=0.42U AS=0.16655P AD=0.0567P
+ PS=1.39U PD=0.69U
* device instance $1020 r0 *1 120.325,-85.455 pfet
M$1020 SELn2|X \$460 VPB|VPWR VPB|VPWR pfet L=0.15U W=1U AS=0.16655P AD=0.475P
+ PS=1.39U PD=2.95U
* device instance $1021 r0 *1 120.505,-83.985 pfet
M$1021 ADCOUT1|X \$491 \$492 VPB|VPWR pfet L=0.15U W=1U AS=0.26P AD=0.3P
+ PS=2.52U PD=2.6U
* device instance $1022 r0 *1 122.445,-83.985 pfet
M$1022 \$504 B|Y \$494 VPB|VPWR pfet L=0.15U W=1U AS=0.26P AD=0.135P PS=2.52U
+ PD=1.27U
* device instance $1023 r0 *1 122.865,-83.985 pfet
M$1023 VPB|VPWR A|A0|B|DOUT6|Q \$504 VPB|VPWR pfet L=0.15U W=1U AS=0.135P
+ AD=0.135P PS=1.27U PD=1.27U
* device instance $1024 r0 *1 123.285,-83.985 pfet
M$1024 \$495 A|A0|B|DOUT6|Q VPB|VPWR VPB|VPWR pfet L=0.15U W=1U AS=0.135P
+ AD=0.135P PS=1.27U PD=1.27U
* device instance $1025 r0 *1 123.705,-83.985 pfet
M$1025 VPB|VPWR B|Y \$495 VPB|VPWR pfet L=0.15U W=1U AS=0.135P AD=0.26P
+ PS=1.27U PD=2.52U
* device instance $1026 r0 *1 124.645,-83.985 pfet
M$1026 ADCOUT6|X \$494 \$495 VPB|VPWR pfet L=0.15U W=1U AS=0.26P AD=0.3P
+ PS=2.52U PD=2.6U
* device instance $1027 r0 *1 128.565,-85.375 pfet
M$1027 \$465 A|A0|B|DOUT9|Q VPB|VPWR VPB|VPWR pfet L=0.15U W=0.42U AS=0.1176P
+ AD=0.0567P PS=1.4U PD=0.69U
* device instance $1028 r0 *1 128.985,-85.375 pfet
M$1028 \$465 A|A0|B|DOUT8|Q VPB|VPWR VPB|VPWR pfet L=0.15U W=0.42U AS=0.16655P
+ AD=0.0567P PS=1.39U PD=0.69U
* device instance $1029 r0 *1 129.525,-85.455 pfet
M$1029 SELp8|X \$465 VPB|VPWR VPB|VPWR pfet L=0.15U W=1U AS=0.16655P AD=0.475P
+ PS=1.39U PD=2.95U
* device instance $1030 r0 *1 132.245,-85.375 pfet
M$1030 \$467 A|A0|B|DOUT9|Q VPB|VPWR VPB|VPWR pfet L=0.15U W=0.42U AS=0.1176P
+ AD=0.0567P PS=1.4U PD=0.69U
* device instance $1031 r0 *1 132.665,-85.375 pfet
M$1031 \$467 A|A0|B|DOUT3|Q VPB|VPWR VPB|VPWR pfet L=0.15U W=0.42U AS=0.16655P
+ AD=0.0567P PS=1.39U PD=0.69U
* device instance $1032 r0 *1 133.205,-85.455 pfet
M$1032 SELp3|X \$467 VPB|VPWR VPB|VPWR pfet L=0.15U W=1U AS=0.16655P AD=0.475P
+ PS=1.39U PD=2.95U
* device instance $1033 r0 *1 135.925,-85.375 pfet
M$1033 \$469 A|A0|B|DOUT5|Q VPB|VPWR VPB|VPWR pfet L=0.15U W=0.42U AS=0.1176P
+ AD=0.0567P PS=1.4U PD=0.69U
* device instance $1034 r0 *1 136.345,-85.375 pfet
M$1034 \$469 B|Y VPB|VPWR VPB|VPWR pfet L=0.15U W=0.42U AS=0.16655P AD=0.0567P
+ PS=1.39U PD=0.69U
* device instance $1035 r0 *1 136.885,-85.455 pfet
M$1035 SELn5|X \$469 VPB|VPWR VPB|VPWR pfet L=0.15U W=1U AS=0.16655P AD=0.475P
+ PS=1.39U PD=2.95U
* device instance $1036 r0 *1 4.545,-26.58 pfet
M$1036 \$516 SELp0|X VREFP VDD pfet L=0.15U W=2U AS=0.94P AD=0.94P PS=4.94U
+ PD=4.94U
* device instance $1037 r0 *1 15.545,-26.58 pfet
M$1037 \$517 SELp1|X VREFP VDD pfet L=0.15U W=2U AS=0.94P AD=0.94P PS=4.94U
+ PD=4.94U
* device instance $1038 r0 *1 26.545,-26.58 pfet
M$1038 \$518 SELp2|X VREFP VDD pfet L=0.15U W=2U AS=0.94P AD=0.94P PS=4.94U
+ PD=4.94U
* device instance $1039 r0 *1 37.545,-26.58 pfet
M$1039 \$519 SELp3|X VREFP VDD pfet L=0.15U W=2U AS=0.94P AD=0.94P PS=4.94U
+ PD=4.94U
* device instance $1040 r0 *1 48.545,-26.58 pfet
M$1040 \$520 SELp4|X VREFP VDD pfet L=0.15U W=2U AS=0.94P AD=0.94P PS=4.94U
+ PD=4.94U
* device instance $1041 r0 *1 59.545,-26.58 pfet
M$1041 \$521 SELp5|X VREFP VDD pfet L=0.15U W=2U AS=0.94P AD=0.94P PS=4.94U
+ PD=4.94U
* device instance $1042 r0 *1 70.545,-26.58 pfet
M$1042 \$534 SELp6|X VREFP VDD pfet L=0.15U W=2U AS=0.94P AD=0.94P PS=4.94U
+ PD=4.94U
* device instance $1043 r0 *1 81.545,-26.58 pfet
M$1043 \$533 SELp7|X VREFP VDD pfet L=0.15U W=2U AS=0.94P AD=0.94P PS=4.94U
+ PD=4.94U
* device instance $1044 r0 *1 92.545,-26.58 pfet
M$1044 \$532 SELp8|X VREFP VDD pfet L=0.15U W=2U AS=0.94P AD=0.94P PS=4.94U
+ PD=4.94U
* device instance $1045 r0 *1 101.885,-84.065 pfet
M$1045 \$485 A|A0|B|DOUT8|Q VPB|VPWR VPB|VPWR pfet L=0.15U W=0.42U AS=0.1176P
+ AD=0.0567P PS=1.4U PD=0.69U
* device instance $1046 r0 *1 102.305,-84.065 pfet
M$1046 \$485 B|Y VPB|VPWR VPB|VPWR pfet L=0.15U W=0.42U AS=0.16655P AD=0.0567P
+ PS=1.39U PD=0.69U
* device instance $1047 r0 *1 102.845,-83.985 pfet
M$1047 SELn8|X \$485 VPB|VPWR VPB|VPWR pfet L=0.15U W=1U AS=0.16655P AD=0.475P
+ PS=1.39U PD=2.95U
* device instance $1048 r0 *1 103.545,-26.58 pfet
M$1048 \$522 SELn0|X VREFP VDD pfet L=0.15U W=2U AS=0.94P AD=0.94P PS=4.94U
+ PD=4.94U
* device instance $1049 r0 *1 108.325,-84.065 pfet
M$1049 \$487 A|A0|B|DOUT9|Q VPB|VPWR VPB|VPWR pfet L=0.15U W=0.42U AS=0.1176P
+ AD=0.0567P PS=1.4U PD=0.69U
* device instance $1050 r0 *1 108.745,-84.065 pfet
M$1050 \$487 A|A0|B|DOUT2|Q VPB|VPWR VPB|VPWR pfet L=0.15U W=0.42U AS=0.16655P
+ AD=0.0567P PS=1.39U PD=0.69U
* device instance $1051 r0 *1 109.285,-83.985 pfet
M$1051 SELp2|X \$487 VPB|VPWR VPB|VPWR pfet L=0.15U W=1U AS=0.16655P AD=0.475P
+ PS=1.39U PD=2.95U
* device instance $1052 r0 *1 114.545,-26.58 pfet
M$1052 \$523 SELn1|X VREFP VDD pfet L=0.15U W=2U AS=0.94P AD=0.94P PS=4.94U
+ PD=4.94U
* device instance $1053 r0 *1 125.545,-26.58 pfet
M$1053 \$524 SELn2|X VREFP VDD pfet L=0.15U W=2U AS=0.94P AD=0.94P PS=4.94U
+ PD=4.94U
* device instance $1054 r0 *1 128.565,-84.065 pfet
M$1054 \$497 A|A0|B|DOUT9|Q VPB|VPWR VPB|VPWR pfet L=0.15U W=0.42U AS=0.1176P
+ AD=0.0567P PS=1.4U PD=0.69U
* device instance $1055 r0 *1 128.985,-84.065 pfet
M$1055 \$497 A|A0|B|DOUT5|Q VPB|VPWR VPB|VPWR pfet L=0.15U W=0.42U AS=0.16655P
+ AD=0.0567P PS=1.39U PD=0.69U
* device instance $1056 r0 *1 129.525,-83.985 pfet
M$1056 SELp5|X \$497 VPB|VPWR VPB|VPWR pfet L=0.15U W=1U AS=0.16655P AD=0.475P
+ PS=1.39U PD=2.95U
* device instance $1057 r0 *1 132.245,-84.065 pfet
M$1057 \$499 A|A0|B|DOUT0|Q VPB|VPWR VPB|VPWR pfet L=0.15U W=0.42U AS=0.1176P
+ AD=0.0567P PS=1.4U PD=0.69U
* device instance $1058 r0 *1 132.665,-84.065 pfet
M$1058 \$499 B|Y VPB|VPWR VPB|VPWR pfet L=0.15U W=0.42U AS=0.16655P AD=0.0567P
+ PS=1.39U PD=0.69U
* device instance $1059 r0 *1 133.205,-83.985 pfet
M$1059 SELn0|X \$499 VPB|VPWR VPB|VPWR pfet L=0.15U W=1U AS=0.16655P AD=0.475P
+ PS=1.39U PD=2.95U
* device instance $1060 r0 *1 136.385,-84.065 pfet
M$1060 \$501 A|A0|B|DOUT4|Q VPB|VPWR VPB|VPWR pfet L=0.15U W=0.42U AS=0.1176P
+ AD=0.0567P PS=1.4U PD=0.69U
* device instance $1061 r0 *1 136.805,-84.065 pfet
M$1061 \$501 B|Y VPB|VPWR VPB|VPWR pfet L=0.15U W=0.42U AS=0.16655P AD=0.0567P
+ PS=1.39U PD=0.69U
* device instance $1062 r0 *1 137.345,-83.985 pfet
M$1062 SELn4|X \$501 VPB|VPWR VPB|VPWR pfet L=0.15U W=1U AS=0.16655P AD=0.475P
+ PS=1.39U PD=2.95U
* device instance $1063 r0 *1 136.545,-26.58 pfet
M$1063 \$525 SELn3|X VREFP VDD pfet L=0.15U W=2U AS=0.94P AD=0.94P PS=4.94U
+ PD=4.94U
* device instance $1064 r0 *1 147.545,-26.58 pfet
M$1064 \$526 SELn4|X VREFP VDD pfet L=0.15U W=2U AS=0.94P AD=0.94P PS=4.94U
+ PD=4.94U
* device instance $1065 r0 *1 158.545,-26.58 pfet
M$1065 \$531 SELn5|X VREFP VDD pfet L=0.15U W=2U AS=0.94P AD=0.94P PS=4.94U
+ PD=4.94U
* device instance $1066 r0 *1 169.545,-26.58 pfet
M$1066 \$530 SELn6|X VREFP VDD pfet L=0.15U W=2U AS=0.94P AD=0.94P PS=4.94U
+ PD=4.94U
* device instance $1067 r0 *1 180.545,-26.58 pfet
M$1067 \$529 SELn7|X VREFP VDD pfet L=0.15U W=2U AS=0.94P AD=0.94P PS=4.94U
+ PD=4.94U
* device instance $1068 r0 *1 191.545,-26.58 pfet
M$1068 \$528 SELn8|X VREFP VDD pfet L=0.15U W=2U AS=0.94P AD=0.94P PS=4.94U
+ PD=4.94U
* device instance $1069 r0 *1 66.495,88.75 pfet
M$1069 BOOST_P \$542 VDD BOOST_P pfet L=0.5U W=1U AS=0.42P AD=0.42P PS=2.84U
+ PD=2.84U
* device instance $1070 r0 *1 69.57,88.75 pfet
M$1070 \$542 \$543 BOOST_P BOOST_P pfet L=0.15U W=1U AS=0.47P AD=0.47P PS=2.94U
+ PD=2.94U
* device instance $1071 r0 *1 74.71,88.75 pfet
M$1071 \$545 \$543 VINP VDD pfet L=0.15U W=1U AS=0.47P AD=0.47P PS=2.94U
+ PD=2.94U
* device instance $1072 r0 *1 77.91,96.25 pfet
M$1072 BPREF_P \$543 VCM VDD pfet L=0.15U W=16U AS=7.52P AD=7.52P PS=32.94U
+ PD=32.94U
* device instance $1073 r0 *1 81.11,89.25 pfet
M$1073 \$543 D|PH_SAMPLE|SAMPLE|Y VDD VDD pfet L=0.15U W=2U AS=0.94P AD=0.94P
+ PS=4.94U PD=4.94U
* device instance $1074 r0 *1 84.31,96.25 pfet
M$1074 BPREF_N \$543 VCM VDD pfet L=0.15U W=16U AS=7.52P AD=7.52P PS=32.94U
+ PD=32.94U
* device instance $1075 r0 *1 87.51,88.75 pfet
M$1075 \$547 \$543 VINN VDD pfet L=0.15U W=1U AS=0.47P AD=0.47P PS=2.94U
+ PD=2.94U
* device instance $1076 r0 *1 92.65,88.75 pfet
M$1076 \$548 \$543 BOOST_N BOOST_N pfet L=0.15U W=1U AS=0.47P AD=0.47P PS=2.94U
+ PD=2.94U
* device instance $1077 r0 *1 95.975,88.75 pfet
M$1077 BOOST_N \$548 VDD BOOST_N pfet L=0.5U W=1U AS=0.42P AD=0.42P PS=2.84U
+ PD=2.84U
* device instance $1078 r0 *1 115.07,198.41 pfet
M$1078 A|A1|OUTN|OUTN_NC A1|COMP_OUT|OUTP VDD VDD pfet L=0.5U W=8U AS=3.36P
+ AD=3.36P PS=16.84U PD=16.84U
* device instance $1079 r0 *1 115.07,189.19 pfet
M$1079 A1|COMP_OUT|OUTP A|A1|OUTN|OUTN_NC VDD VDD pfet L=0.5U W=8U AS=3.36P
+ AD=3.36P PS=16.84U PD=16.84U
* device instance $1080 r0 *1 118.87,185.19 pfet
M$1080 A1|COMP_OUT|OUTP CLK|CLKN|Y VDD VDD pfet L=0.5U W=16U AS=6.72P AD=6.72P
+ PS=32.84U PD=32.84U
* device instance $1081 r0 *1 118.87,202.41 pfet
M$1081 A|A1|OUTN|OUTN_NC CLK|CLKN|Y VDD VDD pfet L=0.5U W=16U AS=6.72P AD=6.72P
+ PS=32.84U PD=32.84U
* device instance $1082 r0 *1 123.87,196.41 pfet
M$1082 \$552 CLK|CLKN|Y VDD VDD pfet L=0.5U W=4U AS=1.68P AD=1.68P PS=8.84U
+ PD=8.84U
* device instance $1083 r0 *1 123.87,191.19 pfet
M$1083 \$551 CLK|CLKN|Y VDD VDD pfet L=0.5U W=4U AS=1.68P AD=1.68P PS=8.84U
+ PD=8.84U
* device instance $1084 r0 *1 129.886,68 pfet
M$1084 BOT_OFF_N A|HALF_LSB_EN|X VREFP VDD pfet L=0.15U W=2U AS=0.94P AD=0.94P
+ PS=4.94U PD=4.94U
* device instance $1085 r0 *1 133.086,68 pfet
M$1085 BOT_OFF_N HALF_LSB_ENN|Y VCM VDD pfet L=0.15U W=2U AS=0.94P AD=0.94P
+ PS=4.94U PD=4.94U
* device instance $1086 r0 *1 145.886,68 pfet
M$1086 BOT_OFF_P GND|VGND|VSS VREFP VDD pfet L=0.15U W=2U AS=0.94P AD=0.94P
+ PS=4.94U PD=4.94U
* device instance $1087 r0 *1 149.086,68 pfet
M$1087 BOT_OFF_P VPB|VPWR VCM VDD pfet L=0.15U W=2U AS=0.94P AD=0.94P PS=4.94U
+ PD=4.94U
* device instance $1088 r0 *1 219.95,-126.05 sky130_fd_pr__model__cap_mim
C$1088 GND|VGND|VSS VPB|VPWR 4.434864e-12 sky130_fd_pr__model__cap_mim
* device instance $1089 r0 *1 219.95,-74.05 sky130_fd_pr__model__cap_mim
C$1089 GND|VGND|VSS VPB|VPWR 4.434864e-12 sky130_fd_pr__model__cap_mim
* device instance $1090 r0 *1 0,0.35 sky130_fd_pr__model__cap_mim
C$1090 \$532 TOP_P|VINP 8.664e-15 sky130_fd_pr__model__cap_mim
* device instance $1091 r0 *1 3.4,0.35 sky130_fd_pr__model__cap_mim
C$1091 \$533 TOP_P|VINP 8.664e-15 sky130_fd_pr__model__cap_mim
* device instance $1092 r0 *1 6.8,0.35 sky130_fd_pr__model__cap_mim
C$1092 \$532 TOP_P|VINP 8.664e-15 sky130_fd_pr__model__cap_mim
* device instance $1093 r0 *1 10.2,0.35 sky130_fd_pr__model__cap_mim
C$1093 \$534 TOP_P|VINP 8.664e-15 sky130_fd_pr__model__cap_mim
* device instance $1094 r0 *1 13.6,0.35 sky130_fd_pr__model__cap_mim
C$1094 \$532 TOP_P|VINP 8.664e-15 sky130_fd_pr__model__cap_mim
* device instance $1095 r0 *1 17,0.35 sky130_fd_pr__model__cap_mim
C$1095 \$533 TOP_P|VINP 8.664e-15 sky130_fd_pr__model__cap_mim
* device instance $1096 r0 *1 20.4,0.35 sky130_fd_pr__model__cap_mim
C$1096 \$532 TOP_P|VINP 8.664e-15 sky130_fd_pr__model__cap_mim
* device instance $1097 r0 *1 23.8,0.35 sky130_fd_pr__model__cap_mim
C$1097 \$521 TOP_P|VINP 8.664e-15 sky130_fd_pr__model__cap_mim
* device instance $1098 r0 *1 27.2,0.35 sky130_fd_pr__model__cap_mim
C$1098 \$532 TOP_P|VINP 8.664e-15 sky130_fd_pr__model__cap_mim
* device instance $1099 r0 *1 30.6,0.35 sky130_fd_pr__model__cap_mim
C$1099 \$533 TOP_P|VINP 8.664e-15 sky130_fd_pr__model__cap_mim
* device instance $1100 r0 *1 34,0.35 sky130_fd_pr__model__cap_mim
C$1100 \$532 TOP_P|VINP 8.664e-15 sky130_fd_pr__model__cap_mim
* device instance $1101 r0 *1 37.4,0.35 sky130_fd_pr__model__cap_mim
C$1101 \$534 TOP_P|VINP 8.664e-15 sky130_fd_pr__model__cap_mim
* device instance $1102 r0 *1 40.8,0.35 sky130_fd_pr__model__cap_mim
C$1102 \$532 TOP_P|VINP 8.664e-15 sky130_fd_pr__model__cap_mim
* device instance $1103 r0 *1 44.2,0.35 sky130_fd_pr__model__cap_mim
C$1103 \$533 TOP_P|VINP 8.664e-15 sky130_fd_pr__model__cap_mim
* device instance $1104 r0 *1 47.6,0.35 sky130_fd_pr__model__cap_mim
C$1104 \$532 TOP_P|VINP 8.664e-15 sky130_fd_pr__model__cap_mim
* device instance $1105 r0 *1 51,0.35 sky130_fd_pr__model__cap_mim
C$1105 \$520 TOP_P|VINP 8.664e-15 sky130_fd_pr__model__cap_mim
* device instance $1106 r0 *1 54.4,0.35 sky130_fd_pr__model__cap_mim
C$1106 \$532 TOP_P|VINP 8.664e-15 sky130_fd_pr__model__cap_mim
* device instance $1107 r0 *1 57.8,0.35 sky130_fd_pr__model__cap_mim
C$1107 \$533 TOP_P|VINP 8.664e-15 sky130_fd_pr__model__cap_mim
* device instance $1108 r0 *1 61.2,0.35 sky130_fd_pr__model__cap_mim
C$1108 \$532 TOP_P|VINP 8.664e-15 sky130_fd_pr__model__cap_mim
* device instance $1109 r0 *1 64.6,0.35 sky130_fd_pr__model__cap_mim
C$1109 \$534 TOP_P|VINP 8.664e-15 sky130_fd_pr__model__cap_mim
* device instance $1110 r0 *1 68,0.35 sky130_fd_pr__model__cap_mim
C$1110 \$532 TOP_P|VINP 8.664e-15 sky130_fd_pr__model__cap_mim
* device instance $1111 r0 *1 71.4,0.35 sky130_fd_pr__model__cap_mim
C$1111 \$533 TOP_P|VINP 8.664e-15 sky130_fd_pr__model__cap_mim
* device instance $1112 r0 *1 74.8,0.35 sky130_fd_pr__model__cap_mim
C$1112 \$532 TOP_P|VINP 8.664e-15 sky130_fd_pr__model__cap_mim
* device instance $1113 r0 *1 78.2,0.35 sky130_fd_pr__model__cap_mim
C$1113 \$521 TOP_P|VINP 8.664e-15 sky130_fd_pr__model__cap_mim
* device instance $1114 r0 *1 81.6,0.35 sky130_fd_pr__model__cap_mim
C$1114 \$532 TOP_P|VINP 8.664e-15 sky130_fd_pr__model__cap_mim
* device instance $1115 r0 *1 85,0.35 sky130_fd_pr__model__cap_mim
C$1115 \$533 TOP_P|VINP 8.664e-15 sky130_fd_pr__model__cap_mim
* device instance $1116 r0 *1 88.4,0.35 sky130_fd_pr__model__cap_mim
C$1116 \$532 TOP_P|VINP 8.664e-15 sky130_fd_pr__model__cap_mim
* device instance $1117 r0 *1 91.8,0.35 sky130_fd_pr__model__cap_mim
C$1117 \$534 TOP_P|VINP 8.664e-15 sky130_fd_pr__model__cap_mim
* device instance $1118 r0 *1 95.2,0.35 sky130_fd_pr__model__cap_mim
C$1118 \$532 TOP_P|VINP 8.664e-15 sky130_fd_pr__model__cap_mim
* device instance $1119 r0 *1 98.6,0.35 sky130_fd_pr__model__cap_mim
C$1119 \$533 TOP_P|VINP 8.664e-15 sky130_fd_pr__model__cap_mim
* device instance $1120 r0 *1 102,0.35 sky130_fd_pr__model__cap_mim
C$1120 \$532 TOP_P|VINP 8.664e-15 sky130_fd_pr__model__cap_mim
* device instance $1121 r0 *1 105.4,0.35 sky130_fd_pr__model__cap_mim
C$1121 \$519 TOP_P|VINP 8.664e-15 sky130_fd_pr__model__cap_mim
* device instance $1122 r0 *1 108.8,0.35 sky130_fd_pr__model__cap_mim
C$1122 \$516 TOP_P|VINP 8.664e-15 sky130_fd_pr__model__cap_mim
* device instance $1123 r0 *1 112.2,0.35 sky130_fd_pr__model__cap_mim
C$1123 \$532 TOP_P|VINP 8.664e-15 sky130_fd_pr__model__cap_mim
* device instance $1124 r0 *1 115.6,0.35 sky130_fd_pr__model__cap_mim
C$1124 \$533 TOP_P|VINP 8.664e-15 sky130_fd_pr__model__cap_mim
* device instance $1125 r0 *1 119,0.35 sky130_fd_pr__model__cap_mim
C$1125 \$532 TOP_P|VINP 8.664e-15 sky130_fd_pr__model__cap_mim
* device instance $1126 r0 *1 122.4,0.35 sky130_fd_pr__model__cap_mim
C$1126 \$534 TOP_P|VINP 8.664e-15 sky130_fd_pr__model__cap_mim
* device instance $1127 r0 *1 125.8,0.35 sky130_fd_pr__model__cap_mim
C$1127 \$532 TOP_P|VINP 8.664e-15 sky130_fd_pr__model__cap_mim
* device instance $1128 r0 *1 129.2,0.35 sky130_fd_pr__model__cap_mim
C$1128 \$533 TOP_P|VINP 8.664e-15 sky130_fd_pr__model__cap_mim
* device instance $1129 r0 *1 132.6,0.35 sky130_fd_pr__model__cap_mim
C$1129 \$532 TOP_P|VINP 8.664e-15 sky130_fd_pr__model__cap_mim
* device instance $1130 r0 *1 136,0.35 sky130_fd_pr__model__cap_mim
C$1130 \$521 TOP_P|VINP 8.664e-15 sky130_fd_pr__model__cap_mim
* device instance $1131 r0 *1 139.4,0.35 sky130_fd_pr__model__cap_mim
C$1131 \$532 TOP_P|VINP 8.664e-15 sky130_fd_pr__model__cap_mim
* device instance $1132 r0 *1 142.8,0.35 sky130_fd_pr__model__cap_mim
C$1132 \$533 TOP_P|VINP 8.664e-15 sky130_fd_pr__model__cap_mim
* device instance $1133 r0 *1 146.2,0.35 sky130_fd_pr__model__cap_mim
C$1133 \$532 TOP_P|VINP 8.664e-15 sky130_fd_pr__model__cap_mim
* device instance $1134 r0 *1 149.6,0.35 sky130_fd_pr__model__cap_mim
C$1134 \$534 TOP_P|VINP 8.664e-15 sky130_fd_pr__model__cap_mim
* device instance $1135 r0 *1 153,0.35 sky130_fd_pr__model__cap_mim
C$1135 \$532 TOP_P|VINP 8.664e-15 sky130_fd_pr__model__cap_mim
* device instance $1136 r0 *1 156.4,0.35 sky130_fd_pr__model__cap_mim
C$1136 \$533 TOP_P|VINP 8.664e-15 sky130_fd_pr__model__cap_mim
* device instance $1137 r0 *1 159.8,0.35 sky130_fd_pr__model__cap_mim
C$1137 \$532 TOP_P|VINP 8.664e-15 sky130_fd_pr__model__cap_mim
* device instance $1138 r0 *1 163.2,0.35 sky130_fd_pr__model__cap_mim
C$1138 \$520 TOP_P|VINP 8.664e-15 sky130_fd_pr__model__cap_mim
* device instance $1139 r0 *1 166.6,0.35 sky130_fd_pr__model__cap_mim
C$1139 \$532 TOP_P|VINP 8.664e-15 sky130_fd_pr__model__cap_mim
* device instance $1140 r0 *1 170,0.35 sky130_fd_pr__model__cap_mim
C$1140 \$533 TOP_P|VINP 8.664e-15 sky130_fd_pr__model__cap_mim
* device instance $1141 r0 *1 173.4,0.35 sky130_fd_pr__model__cap_mim
C$1141 \$532 TOP_P|VINP 8.664e-15 sky130_fd_pr__model__cap_mim
* device instance $1142 r0 *1 176.8,0.35 sky130_fd_pr__model__cap_mim
C$1142 \$534 TOP_P|VINP 8.664e-15 sky130_fd_pr__model__cap_mim
* device instance $1143 r0 *1 180.2,0.35 sky130_fd_pr__model__cap_mim
C$1143 \$532 TOP_P|VINP 8.664e-15 sky130_fd_pr__model__cap_mim
* device instance $1144 r0 *1 183.6,0.35 sky130_fd_pr__model__cap_mim
C$1144 \$533 TOP_P|VINP 8.664e-15 sky130_fd_pr__model__cap_mim
* device instance $1145 r0 *1 187,0.35 sky130_fd_pr__model__cap_mim
C$1145 \$532 TOP_P|VINP 8.664e-15 sky130_fd_pr__model__cap_mim
* device instance $1146 r0 *1 190.4,0.35 sky130_fd_pr__model__cap_mim
C$1146 \$521 TOP_P|VINP 8.664e-15 sky130_fd_pr__model__cap_mim
* device instance $1147 r0 *1 193.8,0.35 sky130_fd_pr__model__cap_mim
C$1147 \$532 TOP_P|VINP 8.664e-15 sky130_fd_pr__model__cap_mim
* device instance $1148 r0 *1 197.2,0.35 sky130_fd_pr__model__cap_mim
C$1148 \$533 TOP_P|VINP 8.664e-15 sky130_fd_pr__model__cap_mim
* device instance $1149 r0 *1 200.6,0.35 sky130_fd_pr__model__cap_mim
C$1149 \$532 TOP_P|VINP 8.664e-15 sky130_fd_pr__model__cap_mim
* device instance $1150 r0 *1 204,0.35 sky130_fd_pr__model__cap_mim
C$1150 \$534 TOP_P|VINP 8.664e-15 sky130_fd_pr__model__cap_mim
* device instance $1151 r0 *1 207.4,0.35 sky130_fd_pr__model__cap_mim
C$1151 \$532 TOP_P|VINP 8.664e-15 sky130_fd_pr__model__cap_mim
* device instance $1152 r0 *1 210.8,0.35 sky130_fd_pr__model__cap_mim
C$1152 \$533 TOP_P|VINP 8.664e-15 sky130_fd_pr__model__cap_mim
* device instance $1153 r0 *1 214.2,0.35 sky130_fd_pr__model__cap_mim
C$1153 \$532 TOP_P|VINP 8.664e-15 sky130_fd_pr__model__cap_mim
* device instance $1154 r0 *1 0,3.75 sky130_fd_pr__model__cap_mim
C$1154 \$528 TOP_N|VINN 8.664e-15 sky130_fd_pr__model__cap_mim
* device instance $1155 r0 *1 3.4,3.75 sky130_fd_pr__model__cap_mim
C$1155 \$529 TOP_N|VINN 8.664e-15 sky130_fd_pr__model__cap_mim
* device instance $1156 r0 *1 6.8,3.75 sky130_fd_pr__model__cap_mim
C$1156 \$528 TOP_N|VINN 8.664e-15 sky130_fd_pr__model__cap_mim
* device instance $1157 r0 *1 10.2,3.75 sky130_fd_pr__model__cap_mim
C$1157 \$530 TOP_N|VINN 8.664e-15 sky130_fd_pr__model__cap_mim
* device instance $1158 r0 *1 13.6,3.75 sky130_fd_pr__model__cap_mim
C$1158 \$528 TOP_N|VINN 8.664e-15 sky130_fd_pr__model__cap_mim
* device instance $1159 r0 *1 17,3.75 sky130_fd_pr__model__cap_mim
C$1159 \$529 TOP_N|VINN 8.664e-15 sky130_fd_pr__model__cap_mim
* device instance $1160 r0 *1 20.4,3.75 sky130_fd_pr__model__cap_mim
C$1160 \$528 TOP_N|VINN 8.664e-15 sky130_fd_pr__model__cap_mim
* device instance $1161 r0 *1 23.8,3.75 sky130_fd_pr__model__cap_mim
C$1161 \$531 TOP_N|VINN 8.664e-15 sky130_fd_pr__model__cap_mim
* device instance $1162 r0 *1 27.2,3.75 sky130_fd_pr__model__cap_mim
C$1162 \$528 TOP_N|VINN 8.664e-15 sky130_fd_pr__model__cap_mim
* device instance $1163 r0 *1 30.6,3.75 sky130_fd_pr__model__cap_mim
C$1163 \$529 TOP_N|VINN 8.664e-15 sky130_fd_pr__model__cap_mim
* device instance $1164 r0 *1 34,3.75 sky130_fd_pr__model__cap_mim
C$1164 \$528 TOP_N|VINN 8.664e-15 sky130_fd_pr__model__cap_mim
* device instance $1165 r0 *1 37.4,3.75 sky130_fd_pr__model__cap_mim
C$1165 \$530 TOP_N|VINN 8.664e-15 sky130_fd_pr__model__cap_mim
* device instance $1166 r0 *1 40.8,3.75 sky130_fd_pr__model__cap_mim
C$1166 \$528 TOP_N|VINN 8.664e-15 sky130_fd_pr__model__cap_mim
* device instance $1167 r0 *1 44.2,3.75 sky130_fd_pr__model__cap_mim
C$1167 \$529 TOP_N|VINN 8.664e-15 sky130_fd_pr__model__cap_mim
* device instance $1168 r0 *1 47.6,3.75 sky130_fd_pr__model__cap_mim
C$1168 \$528 TOP_N|VINN 8.664e-15 sky130_fd_pr__model__cap_mim
* device instance $1169 r0 *1 51,3.75 sky130_fd_pr__model__cap_mim
C$1169 \$526 TOP_N|VINN 8.664e-15 sky130_fd_pr__model__cap_mim
* device instance $1170 r0 *1 54.4,3.75 sky130_fd_pr__model__cap_mim
C$1170 \$528 TOP_N|VINN 8.664e-15 sky130_fd_pr__model__cap_mim
* device instance $1171 r0 *1 57.8,3.75 sky130_fd_pr__model__cap_mim
C$1171 \$529 TOP_N|VINN 8.664e-15 sky130_fd_pr__model__cap_mim
* device instance $1172 r0 *1 61.2,3.75 sky130_fd_pr__model__cap_mim
C$1172 \$528 TOP_N|VINN 8.664e-15 sky130_fd_pr__model__cap_mim
* device instance $1173 r0 *1 64.6,3.75 sky130_fd_pr__model__cap_mim
C$1173 \$530 TOP_N|VINN 8.664e-15 sky130_fd_pr__model__cap_mim
* device instance $1174 r0 *1 68,3.75 sky130_fd_pr__model__cap_mim
C$1174 \$528 TOP_N|VINN 8.664e-15 sky130_fd_pr__model__cap_mim
* device instance $1175 r0 *1 71.4,3.75 sky130_fd_pr__model__cap_mim
C$1175 \$529 TOP_N|VINN 8.664e-15 sky130_fd_pr__model__cap_mim
* device instance $1176 r0 *1 74.8,3.75 sky130_fd_pr__model__cap_mim
C$1176 \$528 TOP_N|VINN 8.664e-15 sky130_fd_pr__model__cap_mim
* device instance $1177 r0 *1 78.2,3.75 sky130_fd_pr__model__cap_mim
C$1177 \$531 TOP_N|VINN 8.664e-15 sky130_fd_pr__model__cap_mim
* device instance $1178 r0 *1 81.6,3.75 sky130_fd_pr__model__cap_mim
C$1178 \$528 TOP_N|VINN 8.664e-15 sky130_fd_pr__model__cap_mim
* device instance $1179 r0 *1 85,3.75 sky130_fd_pr__model__cap_mim
C$1179 \$529 TOP_N|VINN 8.664e-15 sky130_fd_pr__model__cap_mim
* device instance $1180 r0 *1 88.4,3.75 sky130_fd_pr__model__cap_mim
C$1180 \$528 TOP_N|VINN 8.664e-15 sky130_fd_pr__model__cap_mim
* device instance $1181 r0 *1 91.8,3.75 sky130_fd_pr__model__cap_mim
C$1181 \$530 TOP_N|VINN 8.664e-15 sky130_fd_pr__model__cap_mim
* device instance $1182 r0 *1 95.2,3.75 sky130_fd_pr__model__cap_mim
C$1182 \$528 TOP_N|VINN 8.664e-15 sky130_fd_pr__model__cap_mim
* device instance $1183 r0 *1 98.6,3.75 sky130_fd_pr__model__cap_mim
C$1183 \$529 TOP_N|VINN 8.664e-15 sky130_fd_pr__model__cap_mim
* device instance $1184 r0 *1 102,3.75 sky130_fd_pr__model__cap_mim
C$1184 \$528 TOP_N|VINN 8.664e-15 sky130_fd_pr__model__cap_mim
* device instance $1185 r0 *1 105.4,3.75 sky130_fd_pr__model__cap_mim
C$1185 \$525 TOP_N|VINN 8.664e-15 sky130_fd_pr__model__cap_mim
* device instance $1186 r0 *1 108.8,3.75 sky130_fd_pr__model__cap_mim
C$1186 \$522 TOP_N|VINN 8.664e-15 sky130_fd_pr__model__cap_mim
* device instance $1187 r0 *1 112.2,3.75 sky130_fd_pr__model__cap_mim
C$1187 \$528 TOP_N|VINN 8.664e-15 sky130_fd_pr__model__cap_mim
* device instance $1188 r0 *1 115.6,3.75 sky130_fd_pr__model__cap_mim
C$1188 \$529 TOP_N|VINN 8.664e-15 sky130_fd_pr__model__cap_mim
* device instance $1189 r0 *1 119,3.75 sky130_fd_pr__model__cap_mim
C$1189 \$528 TOP_N|VINN 8.664e-15 sky130_fd_pr__model__cap_mim
* device instance $1190 r0 *1 122.4,3.75 sky130_fd_pr__model__cap_mim
C$1190 \$530 TOP_N|VINN 8.664e-15 sky130_fd_pr__model__cap_mim
* device instance $1191 r0 *1 125.8,3.75 sky130_fd_pr__model__cap_mim
C$1191 \$528 TOP_N|VINN 8.664e-15 sky130_fd_pr__model__cap_mim
* device instance $1192 r0 *1 129.2,3.75 sky130_fd_pr__model__cap_mim
C$1192 \$529 TOP_N|VINN 8.664e-15 sky130_fd_pr__model__cap_mim
* device instance $1193 r0 *1 132.6,3.75 sky130_fd_pr__model__cap_mim
C$1193 \$528 TOP_N|VINN 8.664e-15 sky130_fd_pr__model__cap_mim
* device instance $1194 r0 *1 136,3.75 sky130_fd_pr__model__cap_mim
C$1194 \$531 TOP_N|VINN 8.664e-15 sky130_fd_pr__model__cap_mim
* device instance $1195 r0 *1 139.4,3.75 sky130_fd_pr__model__cap_mim
C$1195 \$528 TOP_N|VINN 8.664e-15 sky130_fd_pr__model__cap_mim
* device instance $1196 r0 *1 142.8,3.75 sky130_fd_pr__model__cap_mim
C$1196 \$529 TOP_N|VINN 8.664e-15 sky130_fd_pr__model__cap_mim
* device instance $1197 r0 *1 146.2,3.75 sky130_fd_pr__model__cap_mim
C$1197 \$528 TOP_N|VINN 8.664e-15 sky130_fd_pr__model__cap_mim
* device instance $1198 r0 *1 149.6,3.75 sky130_fd_pr__model__cap_mim
C$1198 \$530 TOP_N|VINN 8.664e-15 sky130_fd_pr__model__cap_mim
* device instance $1199 r0 *1 153,3.75 sky130_fd_pr__model__cap_mim
C$1199 \$528 TOP_N|VINN 8.664e-15 sky130_fd_pr__model__cap_mim
* device instance $1200 r0 *1 156.4,3.75 sky130_fd_pr__model__cap_mim
C$1200 \$529 TOP_N|VINN 8.664e-15 sky130_fd_pr__model__cap_mim
* device instance $1201 r0 *1 159.8,3.75 sky130_fd_pr__model__cap_mim
C$1201 \$528 TOP_N|VINN 8.664e-15 sky130_fd_pr__model__cap_mim
* device instance $1202 r0 *1 163.2,3.75 sky130_fd_pr__model__cap_mim
C$1202 \$526 TOP_N|VINN 8.664e-15 sky130_fd_pr__model__cap_mim
* device instance $1203 r0 *1 166.6,3.75 sky130_fd_pr__model__cap_mim
C$1203 \$528 TOP_N|VINN 8.664e-15 sky130_fd_pr__model__cap_mim
* device instance $1204 r0 *1 170,3.75 sky130_fd_pr__model__cap_mim
C$1204 \$529 TOP_N|VINN 8.664e-15 sky130_fd_pr__model__cap_mim
* device instance $1205 r0 *1 173.4,3.75 sky130_fd_pr__model__cap_mim
C$1205 \$528 TOP_N|VINN 8.664e-15 sky130_fd_pr__model__cap_mim
* device instance $1206 r0 *1 176.8,3.75 sky130_fd_pr__model__cap_mim
C$1206 \$530 TOP_N|VINN 8.664e-15 sky130_fd_pr__model__cap_mim
* device instance $1207 r0 *1 180.2,3.75 sky130_fd_pr__model__cap_mim
C$1207 \$528 TOP_N|VINN 8.664e-15 sky130_fd_pr__model__cap_mim
* device instance $1208 r0 *1 183.6,3.75 sky130_fd_pr__model__cap_mim
C$1208 \$529 TOP_N|VINN 8.664e-15 sky130_fd_pr__model__cap_mim
* device instance $1209 r0 *1 187,3.75 sky130_fd_pr__model__cap_mim
C$1209 \$528 TOP_N|VINN 8.664e-15 sky130_fd_pr__model__cap_mim
* device instance $1210 r0 *1 190.4,3.75 sky130_fd_pr__model__cap_mim
C$1210 \$531 TOP_N|VINN 8.664e-15 sky130_fd_pr__model__cap_mim
* device instance $1211 r0 *1 193.8,3.75 sky130_fd_pr__model__cap_mim
C$1211 \$528 TOP_N|VINN 8.664e-15 sky130_fd_pr__model__cap_mim
* device instance $1212 r0 *1 197.2,3.75 sky130_fd_pr__model__cap_mim
C$1212 \$529 TOP_N|VINN 8.664e-15 sky130_fd_pr__model__cap_mim
* device instance $1213 r0 *1 200.6,3.75 sky130_fd_pr__model__cap_mim
C$1213 \$528 TOP_N|VINN 8.664e-15 sky130_fd_pr__model__cap_mim
* device instance $1214 r0 *1 204,3.75 sky130_fd_pr__model__cap_mim
C$1214 \$530 TOP_N|VINN 8.664e-15 sky130_fd_pr__model__cap_mim
* device instance $1215 r0 *1 207.4,3.75 sky130_fd_pr__model__cap_mim
C$1215 \$528 TOP_N|VINN 8.664e-15 sky130_fd_pr__model__cap_mim
* device instance $1216 r0 *1 210.8,3.75 sky130_fd_pr__model__cap_mim
C$1216 \$529 TOP_N|VINN 8.664e-15 sky130_fd_pr__model__cap_mim
* device instance $1217 r0 *1 214.2,3.75 sky130_fd_pr__model__cap_mim
C$1217 \$528 TOP_N|VINN 8.664e-15 sky130_fd_pr__model__cap_mim
* device instance $1218 r0 *1 0,7.15 sky130_fd_pr__model__cap_mim
C$1218 \$532 TOP_P|VINP 8.664e-15 sky130_fd_pr__model__cap_mim
* device instance $1219 r0 *1 3.4,7.15 sky130_fd_pr__model__cap_mim
C$1219 \$533 TOP_P|VINP 8.664e-15 sky130_fd_pr__model__cap_mim
* device instance $1220 r0 *1 6.8,7.15 sky130_fd_pr__model__cap_mim
C$1220 \$532 TOP_P|VINP 8.664e-15 sky130_fd_pr__model__cap_mim
* device instance $1221 r0 *1 10.2,7.15 sky130_fd_pr__model__cap_mim
C$1221 \$534 TOP_P|VINP 8.664e-15 sky130_fd_pr__model__cap_mim
* device instance $1222 r0 *1 13.6,7.15 sky130_fd_pr__model__cap_mim
C$1222 \$532 TOP_P|VINP 8.664e-15 sky130_fd_pr__model__cap_mim
* device instance $1223 r0 *1 17,7.15 sky130_fd_pr__model__cap_mim
C$1223 \$533 TOP_P|VINP 8.664e-15 sky130_fd_pr__model__cap_mim
* device instance $1224 r0 *1 20.4,7.15 sky130_fd_pr__model__cap_mim
C$1224 \$532 TOP_P|VINP 8.664e-15 sky130_fd_pr__model__cap_mim
* device instance $1225 r0 *1 23.8,7.15 sky130_fd_pr__model__cap_mim
C$1225 \$521 TOP_P|VINP 8.664e-15 sky130_fd_pr__model__cap_mim
* device instance $1226 r0 *1 27.2,7.15 sky130_fd_pr__model__cap_mim
C$1226 \$532 TOP_P|VINP 8.664e-15 sky130_fd_pr__model__cap_mim
* device instance $1227 r0 *1 30.6,7.15 sky130_fd_pr__model__cap_mim
C$1227 \$533 TOP_P|VINP 8.664e-15 sky130_fd_pr__model__cap_mim
* device instance $1228 r0 *1 34,7.15 sky130_fd_pr__model__cap_mim
C$1228 \$532 TOP_P|VINP 8.664e-15 sky130_fd_pr__model__cap_mim
* device instance $1229 r0 *1 37.4,7.15 sky130_fd_pr__model__cap_mim
C$1229 \$534 TOP_P|VINP 8.664e-15 sky130_fd_pr__model__cap_mim
* device instance $1230 r0 *1 40.8,7.15 sky130_fd_pr__model__cap_mim
C$1230 \$532 TOP_P|VINP 8.664e-15 sky130_fd_pr__model__cap_mim
* device instance $1231 r0 *1 44.2,7.15 sky130_fd_pr__model__cap_mim
C$1231 \$533 TOP_P|VINP 8.664e-15 sky130_fd_pr__model__cap_mim
* device instance $1232 r0 *1 47.6,7.15 sky130_fd_pr__model__cap_mim
C$1232 \$532 TOP_P|VINP 8.664e-15 sky130_fd_pr__model__cap_mim
* device instance $1233 r0 *1 51,7.15 sky130_fd_pr__model__cap_mim
C$1233 \$520 TOP_P|VINP 8.664e-15 sky130_fd_pr__model__cap_mim
* device instance $1234 r0 *1 54.4,7.15 sky130_fd_pr__model__cap_mim
C$1234 \$532 TOP_P|VINP 8.664e-15 sky130_fd_pr__model__cap_mim
* device instance $1235 r0 *1 57.8,7.15 sky130_fd_pr__model__cap_mim
C$1235 \$533 TOP_P|VINP 8.664e-15 sky130_fd_pr__model__cap_mim
* device instance $1236 r0 *1 61.2,7.15 sky130_fd_pr__model__cap_mim
C$1236 \$532 TOP_P|VINP 8.664e-15 sky130_fd_pr__model__cap_mim
* device instance $1237 r0 *1 64.6,7.15 sky130_fd_pr__model__cap_mim
C$1237 \$534 TOP_P|VINP 8.664e-15 sky130_fd_pr__model__cap_mim
* device instance $1238 r0 *1 68,7.15 sky130_fd_pr__model__cap_mim
C$1238 \$532 TOP_P|VINP 8.664e-15 sky130_fd_pr__model__cap_mim
* device instance $1239 r0 *1 71.4,7.15 sky130_fd_pr__model__cap_mim
C$1239 \$533 TOP_P|VINP 8.664e-15 sky130_fd_pr__model__cap_mim
* device instance $1240 r0 *1 74.8,7.15 sky130_fd_pr__model__cap_mim
C$1240 \$532 TOP_P|VINP 8.664e-15 sky130_fd_pr__model__cap_mim
* device instance $1241 r0 *1 78.2,7.15 sky130_fd_pr__model__cap_mim
C$1241 \$521 TOP_P|VINP 8.664e-15 sky130_fd_pr__model__cap_mim
* device instance $1242 r0 *1 81.6,7.15 sky130_fd_pr__model__cap_mim
C$1242 \$532 TOP_P|VINP 8.664e-15 sky130_fd_pr__model__cap_mim
* device instance $1243 r0 *1 85,7.15 sky130_fd_pr__model__cap_mim
C$1243 \$533 TOP_P|VINP 8.664e-15 sky130_fd_pr__model__cap_mim
* device instance $1244 r0 *1 88.4,7.15 sky130_fd_pr__model__cap_mim
C$1244 \$532 TOP_P|VINP 8.664e-15 sky130_fd_pr__model__cap_mim
* device instance $1245 r0 *1 91.8,7.15 sky130_fd_pr__model__cap_mim
C$1245 \$534 TOP_P|VINP 8.664e-15 sky130_fd_pr__model__cap_mim
* device instance $1246 r0 *1 95.2,7.15 sky130_fd_pr__model__cap_mim
C$1246 \$532 TOP_P|VINP 8.664e-15 sky130_fd_pr__model__cap_mim
* device instance $1247 r0 *1 98.6,7.15 sky130_fd_pr__model__cap_mim
C$1247 \$533 TOP_P|VINP 8.664e-15 sky130_fd_pr__model__cap_mim
* device instance $1248 r0 *1 102,7.15 sky130_fd_pr__model__cap_mim
C$1248 \$532 TOP_P|VINP 8.664e-15 sky130_fd_pr__model__cap_mim
* device instance $1249 r0 *1 105.4,7.15 sky130_fd_pr__model__cap_mim
C$1249 \$519 TOP_P|VINP 8.664e-15 sky130_fd_pr__model__cap_mim
* device instance $1250 r0 *1 108.8,7.15 sky130_fd_pr__model__cap_mim
C$1250 \$518 TOP_P|VINP 8.664e-15 sky130_fd_pr__model__cap_mim
* device instance $1251 r0 *1 112.2,7.15 sky130_fd_pr__model__cap_mim
C$1251 \$532 TOP_P|VINP 8.664e-15 sky130_fd_pr__model__cap_mim
* device instance $1252 r0 *1 115.6,7.15 sky130_fd_pr__model__cap_mim
C$1252 \$533 TOP_P|VINP 8.664e-15 sky130_fd_pr__model__cap_mim
* device instance $1253 r0 *1 119,7.15 sky130_fd_pr__model__cap_mim
C$1253 \$532 TOP_P|VINP 8.664e-15 sky130_fd_pr__model__cap_mim
* device instance $1254 r0 *1 122.4,7.15 sky130_fd_pr__model__cap_mim
C$1254 \$534 TOP_P|VINP 8.664e-15 sky130_fd_pr__model__cap_mim
* device instance $1255 r0 *1 125.8,7.15 sky130_fd_pr__model__cap_mim
C$1255 \$532 TOP_P|VINP 8.664e-15 sky130_fd_pr__model__cap_mim
* device instance $1256 r0 *1 129.2,7.15 sky130_fd_pr__model__cap_mim
C$1256 \$533 TOP_P|VINP 8.664e-15 sky130_fd_pr__model__cap_mim
* device instance $1257 r0 *1 132.6,7.15 sky130_fd_pr__model__cap_mim
C$1257 \$532 TOP_P|VINP 8.664e-15 sky130_fd_pr__model__cap_mim
* device instance $1258 r0 *1 136,7.15 sky130_fd_pr__model__cap_mim
C$1258 \$521 TOP_P|VINP 8.664e-15 sky130_fd_pr__model__cap_mim
* device instance $1259 r0 *1 139.4,7.15 sky130_fd_pr__model__cap_mim
C$1259 \$532 TOP_P|VINP 8.664e-15 sky130_fd_pr__model__cap_mim
* device instance $1260 r0 *1 142.8,7.15 sky130_fd_pr__model__cap_mim
C$1260 \$533 TOP_P|VINP 8.664e-15 sky130_fd_pr__model__cap_mim
* device instance $1261 r0 *1 146.2,7.15 sky130_fd_pr__model__cap_mim
C$1261 \$532 TOP_P|VINP 8.664e-15 sky130_fd_pr__model__cap_mim
* device instance $1262 r0 *1 149.6,7.15 sky130_fd_pr__model__cap_mim
C$1262 \$534 TOP_P|VINP 8.664e-15 sky130_fd_pr__model__cap_mim
* device instance $1263 r0 *1 153,7.15 sky130_fd_pr__model__cap_mim
C$1263 \$532 TOP_P|VINP 8.664e-15 sky130_fd_pr__model__cap_mim
* device instance $1264 r0 *1 156.4,7.15 sky130_fd_pr__model__cap_mim
C$1264 \$533 TOP_P|VINP 8.664e-15 sky130_fd_pr__model__cap_mim
* device instance $1265 r0 *1 159.8,7.15 sky130_fd_pr__model__cap_mim
C$1265 \$532 TOP_P|VINP 8.664e-15 sky130_fd_pr__model__cap_mim
* device instance $1266 r0 *1 163.2,7.15 sky130_fd_pr__model__cap_mim
C$1266 \$520 TOP_P|VINP 8.664e-15 sky130_fd_pr__model__cap_mim
* device instance $1267 r0 *1 166.6,7.15 sky130_fd_pr__model__cap_mim
C$1267 \$532 TOP_P|VINP 8.664e-15 sky130_fd_pr__model__cap_mim
* device instance $1268 r0 *1 170,7.15 sky130_fd_pr__model__cap_mim
C$1268 \$533 TOP_P|VINP 8.664e-15 sky130_fd_pr__model__cap_mim
* device instance $1269 r0 *1 173.4,7.15 sky130_fd_pr__model__cap_mim
C$1269 \$532 TOP_P|VINP 8.664e-15 sky130_fd_pr__model__cap_mim
* device instance $1270 r0 *1 176.8,7.15 sky130_fd_pr__model__cap_mim
C$1270 \$534 TOP_P|VINP 8.664e-15 sky130_fd_pr__model__cap_mim
* device instance $1271 r0 *1 180.2,7.15 sky130_fd_pr__model__cap_mim
C$1271 \$532 TOP_P|VINP 8.664e-15 sky130_fd_pr__model__cap_mim
* device instance $1272 r0 *1 183.6,7.15 sky130_fd_pr__model__cap_mim
C$1272 \$533 TOP_P|VINP 8.664e-15 sky130_fd_pr__model__cap_mim
* device instance $1273 r0 *1 187,7.15 sky130_fd_pr__model__cap_mim
C$1273 \$532 TOP_P|VINP 8.664e-15 sky130_fd_pr__model__cap_mim
* device instance $1274 r0 *1 190.4,7.15 sky130_fd_pr__model__cap_mim
C$1274 \$521 TOP_P|VINP 8.664e-15 sky130_fd_pr__model__cap_mim
* device instance $1275 r0 *1 193.8,7.15 sky130_fd_pr__model__cap_mim
C$1275 \$532 TOP_P|VINP 8.664e-15 sky130_fd_pr__model__cap_mim
* device instance $1276 r0 *1 197.2,7.15 sky130_fd_pr__model__cap_mim
C$1276 \$533 TOP_P|VINP 8.664e-15 sky130_fd_pr__model__cap_mim
* device instance $1277 r0 *1 200.6,7.15 sky130_fd_pr__model__cap_mim
C$1277 \$532 TOP_P|VINP 8.664e-15 sky130_fd_pr__model__cap_mim
* device instance $1278 r0 *1 204,7.15 sky130_fd_pr__model__cap_mim
C$1278 \$534 TOP_P|VINP 8.664e-15 sky130_fd_pr__model__cap_mim
* device instance $1279 r0 *1 207.4,7.15 sky130_fd_pr__model__cap_mim
C$1279 \$532 TOP_P|VINP 8.664e-15 sky130_fd_pr__model__cap_mim
* device instance $1280 r0 *1 210.8,7.15 sky130_fd_pr__model__cap_mim
C$1280 \$533 TOP_P|VINP 8.664e-15 sky130_fd_pr__model__cap_mim
* device instance $1281 r0 *1 214.2,7.15 sky130_fd_pr__model__cap_mim
C$1281 \$532 TOP_P|VINP 8.664e-15 sky130_fd_pr__model__cap_mim
* device instance $1282 r0 *1 0,10.55 sky130_fd_pr__model__cap_mim
C$1282 \$528 TOP_N|VINN 8.664e-15 sky130_fd_pr__model__cap_mim
* device instance $1283 r0 *1 3.4,10.55 sky130_fd_pr__model__cap_mim
C$1283 \$529 TOP_N|VINN 8.664e-15 sky130_fd_pr__model__cap_mim
* device instance $1284 r0 *1 6.8,10.55 sky130_fd_pr__model__cap_mim
C$1284 \$528 TOP_N|VINN 8.664e-15 sky130_fd_pr__model__cap_mim
* device instance $1285 r0 *1 10.2,10.55 sky130_fd_pr__model__cap_mim
C$1285 \$530 TOP_N|VINN 8.664e-15 sky130_fd_pr__model__cap_mim
* device instance $1286 r0 *1 13.6,10.55 sky130_fd_pr__model__cap_mim
C$1286 \$528 TOP_N|VINN 8.664e-15 sky130_fd_pr__model__cap_mim
* device instance $1287 r0 *1 17,10.55 sky130_fd_pr__model__cap_mim
C$1287 \$529 TOP_N|VINN 8.664e-15 sky130_fd_pr__model__cap_mim
* device instance $1288 r0 *1 20.4,10.55 sky130_fd_pr__model__cap_mim
C$1288 \$528 TOP_N|VINN 8.664e-15 sky130_fd_pr__model__cap_mim
* device instance $1289 r0 *1 23.8,10.55 sky130_fd_pr__model__cap_mim
C$1289 \$531 TOP_N|VINN 8.664e-15 sky130_fd_pr__model__cap_mim
* device instance $1290 r0 *1 27.2,10.55 sky130_fd_pr__model__cap_mim
C$1290 \$528 TOP_N|VINN 8.664e-15 sky130_fd_pr__model__cap_mim
* device instance $1291 r0 *1 30.6,10.55 sky130_fd_pr__model__cap_mim
C$1291 \$529 TOP_N|VINN 8.664e-15 sky130_fd_pr__model__cap_mim
* device instance $1292 r0 *1 34,10.55 sky130_fd_pr__model__cap_mim
C$1292 \$528 TOP_N|VINN 8.664e-15 sky130_fd_pr__model__cap_mim
* device instance $1293 r0 *1 37.4,10.55 sky130_fd_pr__model__cap_mim
C$1293 \$530 TOP_N|VINN 8.664e-15 sky130_fd_pr__model__cap_mim
* device instance $1294 r0 *1 40.8,10.55 sky130_fd_pr__model__cap_mim
C$1294 \$528 TOP_N|VINN 8.664e-15 sky130_fd_pr__model__cap_mim
* device instance $1295 r0 *1 44.2,10.55 sky130_fd_pr__model__cap_mim
C$1295 \$529 TOP_N|VINN 8.664e-15 sky130_fd_pr__model__cap_mim
* device instance $1296 r0 *1 47.6,10.55 sky130_fd_pr__model__cap_mim
C$1296 \$528 TOP_N|VINN 8.664e-15 sky130_fd_pr__model__cap_mim
* device instance $1297 r0 *1 51,10.55 sky130_fd_pr__model__cap_mim
C$1297 \$526 TOP_N|VINN 8.664e-15 sky130_fd_pr__model__cap_mim
* device instance $1298 r0 *1 54.4,10.55 sky130_fd_pr__model__cap_mim
C$1298 \$528 TOP_N|VINN 8.664e-15 sky130_fd_pr__model__cap_mim
* device instance $1299 r0 *1 57.8,10.55 sky130_fd_pr__model__cap_mim
C$1299 \$529 TOP_N|VINN 8.664e-15 sky130_fd_pr__model__cap_mim
* device instance $1300 r0 *1 61.2,10.55 sky130_fd_pr__model__cap_mim
C$1300 \$528 TOP_N|VINN 8.664e-15 sky130_fd_pr__model__cap_mim
* device instance $1301 r0 *1 64.6,10.55 sky130_fd_pr__model__cap_mim
C$1301 \$530 TOP_N|VINN 8.664e-15 sky130_fd_pr__model__cap_mim
* device instance $1302 r0 *1 68,10.55 sky130_fd_pr__model__cap_mim
C$1302 \$528 TOP_N|VINN 8.664e-15 sky130_fd_pr__model__cap_mim
* device instance $1303 r0 *1 71.4,10.55 sky130_fd_pr__model__cap_mim
C$1303 \$529 TOP_N|VINN 8.664e-15 sky130_fd_pr__model__cap_mim
* device instance $1304 r0 *1 74.8,10.55 sky130_fd_pr__model__cap_mim
C$1304 \$528 TOP_N|VINN 8.664e-15 sky130_fd_pr__model__cap_mim
* device instance $1305 r0 *1 78.2,10.55 sky130_fd_pr__model__cap_mim
C$1305 \$531 TOP_N|VINN 8.664e-15 sky130_fd_pr__model__cap_mim
* device instance $1306 r0 *1 81.6,10.55 sky130_fd_pr__model__cap_mim
C$1306 \$528 TOP_N|VINN 8.664e-15 sky130_fd_pr__model__cap_mim
* device instance $1307 r0 *1 85,10.55 sky130_fd_pr__model__cap_mim
C$1307 \$529 TOP_N|VINN 8.664e-15 sky130_fd_pr__model__cap_mim
* device instance $1308 r0 *1 88.4,10.55 sky130_fd_pr__model__cap_mim
C$1308 \$528 TOP_N|VINN 8.664e-15 sky130_fd_pr__model__cap_mim
* device instance $1309 r0 *1 91.8,10.55 sky130_fd_pr__model__cap_mim
C$1309 \$530 TOP_N|VINN 8.664e-15 sky130_fd_pr__model__cap_mim
* device instance $1310 r0 *1 95.2,10.55 sky130_fd_pr__model__cap_mim
C$1310 \$528 TOP_N|VINN 8.664e-15 sky130_fd_pr__model__cap_mim
* device instance $1311 r0 *1 98.6,10.55 sky130_fd_pr__model__cap_mim
C$1311 \$529 TOP_N|VINN 8.664e-15 sky130_fd_pr__model__cap_mim
* device instance $1312 r0 *1 102,10.55 sky130_fd_pr__model__cap_mim
C$1312 \$528 TOP_N|VINN 8.664e-15 sky130_fd_pr__model__cap_mim
* device instance $1313 r0 *1 105.4,10.55 sky130_fd_pr__model__cap_mim
C$1313 \$525 TOP_N|VINN 8.664e-15 sky130_fd_pr__model__cap_mim
* device instance $1314 r0 *1 108.8,10.55 sky130_fd_pr__model__cap_mim
C$1314 \$524 TOP_N|VINN 8.664e-15 sky130_fd_pr__model__cap_mim
* device instance $1315 r0 *1 112.2,10.55 sky130_fd_pr__model__cap_mim
C$1315 \$528 TOP_N|VINN 8.664e-15 sky130_fd_pr__model__cap_mim
* device instance $1316 r0 *1 115.6,10.55 sky130_fd_pr__model__cap_mim
C$1316 \$529 TOP_N|VINN 8.664e-15 sky130_fd_pr__model__cap_mim
* device instance $1317 r0 *1 119,10.55 sky130_fd_pr__model__cap_mim
C$1317 \$528 TOP_N|VINN 8.664e-15 sky130_fd_pr__model__cap_mim
* device instance $1318 r0 *1 122.4,10.55 sky130_fd_pr__model__cap_mim
C$1318 \$530 TOP_N|VINN 8.664e-15 sky130_fd_pr__model__cap_mim
* device instance $1319 r0 *1 125.8,10.55 sky130_fd_pr__model__cap_mim
C$1319 \$528 TOP_N|VINN 8.664e-15 sky130_fd_pr__model__cap_mim
* device instance $1320 r0 *1 129.2,10.55 sky130_fd_pr__model__cap_mim
C$1320 \$529 TOP_N|VINN 8.664e-15 sky130_fd_pr__model__cap_mim
* device instance $1321 r0 *1 132.6,10.55 sky130_fd_pr__model__cap_mim
C$1321 \$528 TOP_N|VINN 8.664e-15 sky130_fd_pr__model__cap_mim
* device instance $1322 r0 *1 136,10.55 sky130_fd_pr__model__cap_mim
C$1322 \$531 TOP_N|VINN 8.664e-15 sky130_fd_pr__model__cap_mim
* device instance $1323 r0 *1 139.4,10.55 sky130_fd_pr__model__cap_mim
C$1323 \$528 TOP_N|VINN 8.664e-15 sky130_fd_pr__model__cap_mim
* device instance $1324 r0 *1 142.8,10.55 sky130_fd_pr__model__cap_mim
C$1324 \$529 TOP_N|VINN 8.664e-15 sky130_fd_pr__model__cap_mim
* device instance $1325 r0 *1 146.2,10.55 sky130_fd_pr__model__cap_mim
C$1325 \$528 TOP_N|VINN 8.664e-15 sky130_fd_pr__model__cap_mim
* device instance $1326 r0 *1 149.6,10.55 sky130_fd_pr__model__cap_mim
C$1326 \$530 TOP_N|VINN 8.664e-15 sky130_fd_pr__model__cap_mim
* device instance $1327 r0 *1 153,10.55 sky130_fd_pr__model__cap_mim
C$1327 \$528 TOP_N|VINN 8.664e-15 sky130_fd_pr__model__cap_mim
* device instance $1328 r0 *1 156.4,10.55 sky130_fd_pr__model__cap_mim
C$1328 \$529 TOP_N|VINN 8.664e-15 sky130_fd_pr__model__cap_mim
* device instance $1329 r0 *1 159.8,10.55 sky130_fd_pr__model__cap_mim
C$1329 \$528 TOP_N|VINN 8.664e-15 sky130_fd_pr__model__cap_mim
* device instance $1330 r0 *1 163.2,10.55 sky130_fd_pr__model__cap_mim
C$1330 \$526 TOP_N|VINN 8.664e-15 sky130_fd_pr__model__cap_mim
* device instance $1331 r0 *1 166.6,10.55 sky130_fd_pr__model__cap_mim
C$1331 \$528 TOP_N|VINN 8.664e-15 sky130_fd_pr__model__cap_mim
* device instance $1332 r0 *1 170,10.55 sky130_fd_pr__model__cap_mim
C$1332 \$529 TOP_N|VINN 8.664e-15 sky130_fd_pr__model__cap_mim
* device instance $1333 r0 *1 173.4,10.55 sky130_fd_pr__model__cap_mim
C$1333 \$528 TOP_N|VINN 8.664e-15 sky130_fd_pr__model__cap_mim
* device instance $1334 r0 *1 176.8,10.55 sky130_fd_pr__model__cap_mim
C$1334 \$530 TOP_N|VINN 8.664e-15 sky130_fd_pr__model__cap_mim
* device instance $1335 r0 *1 180.2,10.55 sky130_fd_pr__model__cap_mim
C$1335 \$528 TOP_N|VINN 8.664e-15 sky130_fd_pr__model__cap_mim
* device instance $1336 r0 *1 183.6,10.55 sky130_fd_pr__model__cap_mim
C$1336 \$529 TOP_N|VINN 8.664e-15 sky130_fd_pr__model__cap_mim
* device instance $1337 r0 *1 187,10.55 sky130_fd_pr__model__cap_mim
C$1337 \$528 TOP_N|VINN 8.664e-15 sky130_fd_pr__model__cap_mim
* device instance $1338 r0 *1 190.4,10.55 sky130_fd_pr__model__cap_mim
C$1338 \$531 TOP_N|VINN 8.664e-15 sky130_fd_pr__model__cap_mim
* device instance $1339 r0 *1 193.8,10.55 sky130_fd_pr__model__cap_mim
C$1339 \$528 TOP_N|VINN 8.664e-15 sky130_fd_pr__model__cap_mim
* device instance $1340 r0 *1 197.2,10.55 sky130_fd_pr__model__cap_mim
C$1340 \$529 TOP_N|VINN 8.664e-15 sky130_fd_pr__model__cap_mim
* device instance $1341 r0 *1 200.6,10.55 sky130_fd_pr__model__cap_mim
C$1341 \$528 TOP_N|VINN 8.664e-15 sky130_fd_pr__model__cap_mim
* device instance $1342 r0 *1 204,10.55 sky130_fd_pr__model__cap_mim
C$1342 \$530 TOP_N|VINN 8.664e-15 sky130_fd_pr__model__cap_mim
* device instance $1343 r0 *1 207.4,10.55 sky130_fd_pr__model__cap_mim
C$1343 \$528 TOP_N|VINN 8.664e-15 sky130_fd_pr__model__cap_mim
* device instance $1344 r0 *1 210.8,10.55 sky130_fd_pr__model__cap_mim
C$1344 \$529 TOP_N|VINN 8.664e-15 sky130_fd_pr__model__cap_mim
* device instance $1345 r0 *1 214.2,10.55 sky130_fd_pr__model__cap_mim
C$1345 \$528 TOP_N|VINN 8.664e-15 sky130_fd_pr__model__cap_mim
* device instance $1346 r0 *1 0,13.95 sky130_fd_pr__model__cap_mim
C$1346 \$532 TOP_P|VINP 8.664e-15 sky130_fd_pr__model__cap_mim
* device instance $1347 r0 *1 3.4,13.95 sky130_fd_pr__model__cap_mim
C$1347 \$533 TOP_P|VINP 8.664e-15 sky130_fd_pr__model__cap_mim
* device instance $1348 r0 *1 6.8,13.95 sky130_fd_pr__model__cap_mim
C$1348 \$532 TOP_P|VINP 8.664e-15 sky130_fd_pr__model__cap_mim
* device instance $1349 r0 *1 10.2,13.95 sky130_fd_pr__model__cap_mim
C$1349 \$534 TOP_P|VINP 8.664e-15 sky130_fd_pr__model__cap_mim
* device instance $1350 r0 *1 13.6,13.95 sky130_fd_pr__model__cap_mim
C$1350 \$532 TOP_P|VINP 8.664e-15 sky130_fd_pr__model__cap_mim
* device instance $1351 r0 *1 17,13.95 sky130_fd_pr__model__cap_mim
C$1351 \$533 TOP_P|VINP 8.664e-15 sky130_fd_pr__model__cap_mim
* device instance $1352 r0 *1 20.4,13.95 sky130_fd_pr__model__cap_mim
C$1352 \$532 TOP_P|VINP 8.664e-15 sky130_fd_pr__model__cap_mim
* device instance $1353 r0 *1 23.8,13.95 sky130_fd_pr__model__cap_mim
C$1353 \$521 TOP_P|VINP 8.664e-15 sky130_fd_pr__model__cap_mim
* device instance $1354 r0 *1 27.2,13.95 sky130_fd_pr__model__cap_mim
C$1354 \$532 TOP_P|VINP 8.664e-15 sky130_fd_pr__model__cap_mim
* device instance $1355 r0 *1 30.6,13.95 sky130_fd_pr__model__cap_mim
C$1355 \$533 TOP_P|VINP 8.664e-15 sky130_fd_pr__model__cap_mim
* device instance $1356 r0 *1 34,13.95 sky130_fd_pr__model__cap_mim
C$1356 \$532 TOP_P|VINP 8.664e-15 sky130_fd_pr__model__cap_mim
* device instance $1357 r0 *1 37.4,13.95 sky130_fd_pr__model__cap_mim
C$1357 \$534 TOP_P|VINP 8.664e-15 sky130_fd_pr__model__cap_mim
* device instance $1358 r0 *1 40.8,13.95 sky130_fd_pr__model__cap_mim
C$1358 \$532 TOP_P|VINP 8.664e-15 sky130_fd_pr__model__cap_mim
* device instance $1359 r0 *1 44.2,13.95 sky130_fd_pr__model__cap_mim
C$1359 \$533 TOP_P|VINP 8.664e-15 sky130_fd_pr__model__cap_mim
* device instance $1360 r0 *1 47.6,13.95 sky130_fd_pr__model__cap_mim
C$1360 \$532 TOP_P|VINP 8.664e-15 sky130_fd_pr__model__cap_mim
* device instance $1361 r0 *1 51,13.95 sky130_fd_pr__model__cap_mim
C$1361 \$520 TOP_P|VINP 8.664e-15 sky130_fd_pr__model__cap_mim
* device instance $1362 r0 *1 54.4,13.95 sky130_fd_pr__model__cap_mim
C$1362 \$532 TOP_P|VINP 8.664e-15 sky130_fd_pr__model__cap_mim
* device instance $1363 r0 *1 57.8,13.95 sky130_fd_pr__model__cap_mim
C$1363 \$533 TOP_P|VINP 8.664e-15 sky130_fd_pr__model__cap_mim
* device instance $1364 r0 *1 61.2,13.95 sky130_fd_pr__model__cap_mim
C$1364 \$532 TOP_P|VINP 8.664e-15 sky130_fd_pr__model__cap_mim
* device instance $1365 r0 *1 64.6,13.95 sky130_fd_pr__model__cap_mim
C$1365 \$534 TOP_P|VINP 8.664e-15 sky130_fd_pr__model__cap_mim
* device instance $1366 r0 *1 68,13.95 sky130_fd_pr__model__cap_mim
C$1366 \$532 TOP_P|VINP 8.664e-15 sky130_fd_pr__model__cap_mim
* device instance $1367 r0 *1 71.4,13.95 sky130_fd_pr__model__cap_mim
C$1367 \$533 TOP_P|VINP 8.664e-15 sky130_fd_pr__model__cap_mim
* device instance $1368 r0 *1 74.8,13.95 sky130_fd_pr__model__cap_mim
C$1368 \$532 TOP_P|VINP 8.664e-15 sky130_fd_pr__model__cap_mim
* device instance $1369 r0 *1 78.2,13.95 sky130_fd_pr__model__cap_mim
C$1369 \$521 TOP_P|VINP 8.664e-15 sky130_fd_pr__model__cap_mim
* device instance $1370 r0 *1 81.6,13.95 sky130_fd_pr__model__cap_mim
C$1370 \$532 TOP_P|VINP 8.664e-15 sky130_fd_pr__model__cap_mim
* device instance $1371 r0 *1 85,13.95 sky130_fd_pr__model__cap_mim
C$1371 \$533 TOP_P|VINP 8.664e-15 sky130_fd_pr__model__cap_mim
* device instance $1372 r0 *1 88.4,13.95 sky130_fd_pr__model__cap_mim
C$1372 \$532 TOP_P|VINP 8.664e-15 sky130_fd_pr__model__cap_mim
* device instance $1373 r0 *1 91.8,13.95 sky130_fd_pr__model__cap_mim
C$1373 \$534 TOP_P|VINP 8.664e-15 sky130_fd_pr__model__cap_mim
* device instance $1374 r0 *1 95.2,13.95 sky130_fd_pr__model__cap_mim
C$1374 \$532 TOP_P|VINP 8.664e-15 sky130_fd_pr__model__cap_mim
* device instance $1375 r0 *1 98.6,13.95 sky130_fd_pr__model__cap_mim
C$1375 \$533 TOP_P|VINP 8.664e-15 sky130_fd_pr__model__cap_mim
* device instance $1376 r0 *1 102,13.95 sky130_fd_pr__model__cap_mim
C$1376 \$532 TOP_P|VINP 8.664e-15 sky130_fd_pr__model__cap_mim
* device instance $1377 r0 *1 105.4,13.95 sky130_fd_pr__model__cap_mim
C$1377 \$519 TOP_P|VINP 8.664e-15 sky130_fd_pr__model__cap_mim
* device instance $1378 r0 *1 108.8,13.95 sky130_fd_pr__model__cap_mim
C$1378 \$517 TOP_P|VINP 8.664e-15 sky130_fd_pr__model__cap_mim
* device instance $1379 r0 *1 112.2,13.95 sky130_fd_pr__model__cap_mim
C$1379 \$532 TOP_P|VINP 8.664e-15 sky130_fd_pr__model__cap_mim
* device instance $1380 r0 *1 115.6,13.95 sky130_fd_pr__model__cap_mim
C$1380 \$533 TOP_P|VINP 8.664e-15 sky130_fd_pr__model__cap_mim
* device instance $1381 r0 *1 119,13.95 sky130_fd_pr__model__cap_mim
C$1381 \$532 TOP_P|VINP 8.664e-15 sky130_fd_pr__model__cap_mim
* device instance $1382 r0 *1 122.4,13.95 sky130_fd_pr__model__cap_mim
C$1382 \$534 TOP_P|VINP 8.664e-15 sky130_fd_pr__model__cap_mim
* device instance $1383 r0 *1 125.8,13.95 sky130_fd_pr__model__cap_mim
C$1383 \$532 TOP_P|VINP 8.664e-15 sky130_fd_pr__model__cap_mim
* device instance $1384 r0 *1 129.2,13.95 sky130_fd_pr__model__cap_mim
C$1384 \$533 TOP_P|VINP 8.664e-15 sky130_fd_pr__model__cap_mim
* device instance $1385 r0 *1 132.6,13.95 sky130_fd_pr__model__cap_mim
C$1385 \$532 TOP_P|VINP 8.664e-15 sky130_fd_pr__model__cap_mim
* device instance $1386 r0 *1 136,13.95 sky130_fd_pr__model__cap_mim
C$1386 \$521 TOP_P|VINP 8.664e-15 sky130_fd_pr__model__cap_mim
* device instance $1387 r0 *1 139.4,13.95 sky130_fd_pr__model__cap_mim
C$1387 \$532 TOP_P|VINP 8.664e-15 sky130_fd_pr__model__cap_mim
* device instance $1388 r0 *1 142.8,13.95 sky130_fd_pr__model__cap_mim
C$1388 \$533 TOP_P|VINP 8.664e-15 sky130_fd_pr__model__cap_mim
* device instance $1389 r0 *1 146.2,13.95 sky130_fd_pr__model__cap_mim
C$1389 \$532 TOP_P|VINP 8.664e-15 sky130_fd_pr__model__cap_mim
* device instance $1390 r0 *1 149.6,13.95 sky130_fd_pr__model__cap_mim
C$1390 \$534 TOP_P|VINP 8.664e-15 sky130_fd_pr__model__cap_mim
* device instance $1391 r0 *1 153,13.95 sky130_fd_pr__model__cap_mim
C$1391 \$532 TOP_P|VINP 8.664e-15 sky130_fd_pr__model__cap_mim
* device instance $1392 r0 *1 156.4,13.95 sky130_fd_pr__model__cap_mim
C$1392 \$533 TOP_P|VINP 8.664e-15 sky130_fd_pr__model__cap_mim
* device instance $1393 r0 *1 159.8,13.95 sky130_fd_pr__model__cap_mim
C$1393 \$532 TOP_P|VINP 8.664e-15 sky130_fd_pr__model__cap_mim
* device instance $1394 r0 *1 163.2,13.95 sky130_fd_pr__model__cap_mim
C$1394 \$520 TOP_P|VINP 8.664e-15 sky130_fd_pr__model__cap_mim
* device instance $1395 r0 *1 166.6,13.95 sky130_fd_pr__model__cap_mim
C$1395 \$532 TOP_P|VINP 8.664e-15 sky130_fd_pr__model__cap_mim
* device instance $1396 r0 *1 170,13.95 sky130_fd_pr__model__cap_mim
C$1396 \$533 TOP_P|VINP 8.664e-15 sky130_fd_pr__model__cap_mim
* device instance $1397 r0 *1 173.4,13.95 sky130_fd_pr__model__cap_mim
C$1397 \$532 TOP_P|VINP 8.664e-15 sky130_fd_pr__model__cap_mim
* device instance $1398 r0 *1 176.8,13.95 sky130_fd_pr__model__cap_mim
C$1398 \$534 TOP_P|VINP 8.664e-15 sky130_fd_pr__model__cap_mim
* device instance $1399 r0 *1 180.2,13.95 sky130_fd_pr__model__cap_mim
C$1399 \$532 TOP_P|VINP 8.664e-15 sky130_fd_pr__model__cap_mim
* device instance $1400 r0 *1 183.6,13.95 sky130_fd_pr__model__cap_mim
C$1400 \$533 TOP_P|VINP 8.664e-15 sky130_fd_pr__model__cap_mim
* device instance $1401 r0 *1 187,13.95 sky130_fd_pr__model__cap_mim
C$1401 \$532 TOP_P|VINP 8.664e-15 sky130_fd_pr__model__cap_mim
* device instance $1402 r0 *1 190.4,13.95 sky130_fd_pr__model__cap_mim
C$1402 \$521 TOP_P|VINP 8.664e-15 sky130_fd_pr__model__cap_mim
* device instance $1403 r0 *1 193.8,13.95 sky130_fd_pr__model__cap_mim
C$1403 \$532 TOP_P|VINP 8.664e-15 sky130_fd_pr__model__cap_mim
* device instance $1404 r0 *1 197.2,13.95 sky130_fd_pr__model__cap_mim
C$1404 \$533 TOP_P|VINP 8.664e-15 sky130_fd_pr__model__cap_mim
* device instance $1405 r0 *1 200.6,13.95 sky130_fd_pr__model__cap_mim
C$1405 \$532 TOP_P|VINP 8.664e-15 sky130_fd_pr__model__cap_mim
* device instance $1406 r0 *1 204,13.95 sky130_fd_pr__model__cap_mim
C$1406 \$534 TOP_P|VINP 8.664e-15 sky130_fd_pr__model__cap_mim
* device instance $1407 r0 *1 207.4,13.95 sky130_fd_pr__model__cap_mim
C$1407 \$532 TOP_P|VINP 8.664e-15 sky130_fd_pr__model__cap_mim
* device instance $1408 r0 *1 210.8,13.95 sky130_fd_pr__model__cap_mim
C$1408 \$533 TOP_P|VINP 8.664e-15 sky130_fd_pr__model__cap_mim
* device instance $1409 r0 *1 214.2,13.95 sky130_fd_pr__model__cap_mim
C$1409 \$532 TOP_P|VINP 8.664e-15 sky130_fd_pr__model__cap_mim
* device instance $1410 r0 *1 0,17.35 sky130_fd_pr__model__cap_mim
C$1410 \$528 TOP_N|VINN 8.664e-15 sky130_fd_pr__model__cap_mim
* device instance $1411 r0 *1 3.4,17.35 sky130_fd_pr__model__cap_mim
C$1411 \$529 TOP_N|VINN 8.664e-15 sky130_fd_pr__model__cap_mim
* device instance $1412 r0 *1 6.8,17.35 sky130_fd_pr__model__cap_mim
C$1412 \$528 TOP_N|VINN 8.664e-15 sky130_fd_pr__model__cap_mim
* device instance $1413 r0 *1 10.2,17.35 sky130_fd_pr__model__cap_mim
C$1413 \$530 TOP_N|VINN 8.664e-15 sky130_fd_pr__model__cap_mim
* device instance $1414 r0 *1 13.6,17.35 sky130_fd_pr__model__cap_mim
C$1414 \$528 TOP_N|VINN 8.664e-15 sky130_fd_pr__model__cap_mim
* device instance $1415 r0 *1 17,17.35 sky130_fd_pr__model__cap_mim
C$1415 \$529 TOP_N|VINN 8.664e-15 sky130_fd_pr__model__cap_mim
* device instance $1416 r0 *1 20.4,17.35 sky130_fd_pr__model__cap_mim
C$1416 \$528 TOP_N|VINN 8.664e-15 sky130_fd_pr__model__cap_mim
* device instance $1417 r0 *1 23.8,17.35 sky130_fd_pr__model__cap_mim
C$1417 \$531 TOP_N|VINN 8.664e-15 sky130_fd_pr__model__cap_mim
* device instance $1418 r0 *1 27.2,17.35 sky130_fd_pr__model__cap_mim
C$1418 \$528 TOP_N|VINN 8.664e-15 sky130_fd_pr__model__cap_mim
* device instance $1419 r0 *1 30.6,17.35 sky130_fd_pr__model__cap_mim
C$1419 \$529 TOP_N|VINN 8.664e-15 sky130_fd_pr__model__cap_mim
* device instance $1420 r0 *1 34,17.35 sky130_fd_pr__model__cap_mim
C$1420 \$528 TOP_N|VINN 8.664e-15 sky130_fd_pr__model__cap_mim
* device instance $1421 r0 *1 37.4,17.35 sky130_fd_pr__model__cap_mim
C$1421 \$530 TOP_N|VINN 8.664e-15 sky130_fd_pr__model__cap_mim
* device instance $1422 r0 *1 40.8,17.35 sky130_fd_pr__model__cap_mim
C$1422 \$528 TOP_N|VINN 8.664e-15 sky130_fd_pr__model__cap_mim
* device instance $1423 r0 *1 44.2,17.35 sky130_fd_pr__model__cap_mim
C$1423 \$529 TOP_N|VINN 8.664e-15 sky130_fd_pr__model__cap_mim
* device instance $1424 r0 *1 47.6,17.35 sky130_fd_pr__model__cap_mim
C$1424 \$528 TOP_N|VINN 8.664e-15 sky130_fd_pr__model__cap_mim
* device instance $1425 r0 *1 51,17.35 sky130_fd_pr__model__cap_mim
C$1425 \$526 TOP_N|VINN 8.664e-15 sky130_fd_pr__model__cap_mim
* device instance $1426 r0 *1 54.4,17.35 sky130_fd_pr__model__cap_mim
C$1426 \$528 TOP_N|VINN 8.664e-15 sky130_fd_pr__model__cap_mim
* device instance $1427 r0 *1 57.8,17.35 sky130_fd_pr__model__cap_mim
C$1427 \$529 TOP_N|VINN 8.664e-15 sky130_fd_pr__model__cap_mim
* device instance $1428 r0 *1 61.2,17.35 sky130_fd_pr__model__cap_mim
C$1428 \$528 TOP_N|VINN 8.664e-15 sky130_fd_pr__model__cap_mim
* device instance $1429 r0 *1 64.6,17.35 sky130_fd_pr__model__cap_mim
C$1429 \$530 TOP_N|VINN 8.664e-15 sky130_fd_pr__model__cap_mim
* device instance $1430 r0 *1 68,17.35 sky130_fd_pr__model__cap_mim
C$1430 \$528 TOP_N|VINN 8.664e-15 sky130_fd_pr__model__cap_mim
* device instance $1431 r0 *1 71.4,17.35 sky130_fd_pr__model__cap_mim
C$1431 \$529 TOP_N|VINN 8.664e-15 sky130_fd_pr__model__cap_mim
* device instance $1432 r0 *1 74.8,17.35 sky130_fd_pr__model__cap_mim
C$1432 \$528 TOP_N|VINN 8.664e-15 sky130_fd_pr__model__cap_mim
* device instance $1433 r0 *1 78.2,17.35 sky130_fd_pr__model__cap_mim
C$1433 \$531 TOP_N|VINN 8.664e-15 sky130_fd_pr__model__cap_mim
* device instance $1434 r0 *1 81.6,17.35 sky130_fd_pr__model__cap_mim
C$1434 \$528 TOP_N|VINN 8.664e-15 sky130_fd_pr__model__cap_mim
* device instance $1435 r0 *1 85,17.35 sky130_fd_pr__model__cap_mim
C$1435 \$529 TOP_N|VINN 8.664e-15 sky130_fd_pr__model__cap_mim
* device instance $1436 r0 *1 88.4,17.35 sky130_fd_pr__model__cap_mim
C$1436 \$528 TOP_N|VINN 8.664e-15 sky130_fd_pr__model__cap_mim
* device instance $1437 r0 *1 91.8,17.35 sky130_fd_pr__model__cap_mim
C$1437 \$530 TOP_N|VINN 8.664e-15 sky130_fd_pr__model__cap_mim
* device instance $1438 r0 *1 95.2,17.35 sky130_fd_pr__model__cap_mim
C$1438 \$528 TOP_N|VINN 8.664e-15 sky130_fd_pr__model__cap_mim
* device instance $1439 r0 *1 98.6,17.35 sky130_fd_pr__model__cap_mim
C$1439 \$529 TOP_N|VINN 8.664e-15 sky130_fd_pr__model__cap_mim
* device instance $1440 r0 *1 102,17.35 sky130_fd_pr__model__cap_mim
C$1440 \$528 TOP_N|VINN 8.664e-15 sky130_fd_pr__model__cap_mim
* device instance $1441 r0 *1 105.4,17.35 sky130_fd_pr__model__cap_mim
C$1441 \$525 TOP_N|VINN 8.664e-15 sky130_fd_pr__model__cap_mim
* device instance $1442 r0 *1 108.8,17.35 sky130_fd_pr__model__cap_mim
C$1442 \$523 TOP_N|VINN 8.664e-15 sky130_fd_pr__model__cap_mim
* device instance $1443 r0 *1 112.2,17.35 sky130_fd_pr__model__cap_mim
C$1443 \$528 TOP_N|VINN 8.664e-15 sky130_fd_pr__model__cap_mim
* device instance $1444 r0 *1 115.6,17.35 sky130_fd_pr__model__cap_mim
C$1444 \$529 TOP_N|VINN 8.664e-15 sky130_fd_pr__model__cap_mim
* device instance $1445 r0 *1 119,17.35 sky130_fd_pr__model__cap_mim
C$1445 \$528 TOP_N|VINN 8.664e-15 sky130_fd_pr__model__cap_mim
* device instance $1446 r0 *1 122.4,17.35 sky130_fd_pr__model__cap_mim
C$1446 \$530 TOP_N|VINN 8.664e-15 sky130_fd_pr__model__cap_mim
* device instance $1447 r0 *1 125.8,17.35 sky130_fd_pr__model__cap_mim
C$1447 \$528 TOP_N|VINN 8.664e-15 sky130_fd_pr__model__cap_mim
* device instance $1448 r0 *1 129.2,17.35 sky130_fd_pr__model__cap_mim
C$1448 \$529 TOP_N|VINN 8.664e-15 sky130_fd_pr__model__cap_mim
* device instance $1449 r0 *1 132.6,17.35 sky130_fd_pr__model__cap_mim
C$1449 \$528 TOP_N|VINN 8.664e-15 sky130_fd_pr__model__cap_mim
* device instance $1450 r0 *1 136,17.35 sky130_fd_pr__model__cap_mim
C$1450 \$531 TOP_N|VINN 8.664e-15 sky130_fd_pr__model__cap_mim
* device instance $1451 r0 *1 139.4,17.35 sky130_fd_pr__model__cap_mim
C$1451 \$528 TOP_N|VINN 8.664e-15 sky130_fd_pr__model__cap_mim
* device instance $1452 r0 *1 142.8,17.35 sky130_fd_pr__model__cap_mim
C$1452 \$529 TOP_N|VINN 8.664e-15 sky130_fd_pr__model__cap_mim
* device instance $1453 r0 *1 146.2,17.35 sky130_fd_pr__model__cap_mim
C$1453 \$528 TOP_N|VINN 8.664e-15 sky130_fd_pr__model__cap_mim
* device instance $1454 r0 *1 149.6,17.35 sky130_fd_pr__model__cap_mim
C$1454 \$530 TOP_N|VINN 8.664e-15 sky130_fd_pr__model__cap_mim
* device instance $1455 r0 *1 153,17.35 sky130_fd_pr__model__cap_mim
C$1455 \$528 TOP_N|VINN 8.664e-15 sky130_fd_pr__model__cap_mim
* device instance $1456 r0 *1 156.4,17.35 sky130_fd_pr__model__cap_mim
C$1456 \$529 TOP_N|VINN 8.664e-15 sky130_fd_pr__model__cap_mim
* device instance $1457 r0 *1 159.8,17.35 sky130_fd_pr__model__cap_mim
C$1457 \$528 TOP_N|VINN 8.664e-15 sky130_fd_pr__model__cap_mim
* device instance $1458 r0 *1 163.2,17.35 sky130_fd_pr__model__cap_mim
C$1458 \$526 TOP_N|VINN 8.664e-15 sky130_fd_pr__model__cap_mim
* device instance $1459 r0 *1 166.6,17.35 sky130_fd_pr__model__cap_mim
C$1459 \$528 TOP_N|VINN 8.664e-15 sky130_fd_pr__model__cap_mim
* device instance $1460 r0 *1 170,17.35 sky130_fd_pr__model__cap_mim
C$1460 \$529 TOP_N|VINN 8.664e-15 sky130_fd_pr__model__cap_mim
* device instance $1461 r0 *1 173.4,17.35 sky130_fd_pr__model__cap_mim
C$1461 \$528 TOP_N|VINN 8.664e-15 sky130_fd_pr__model__cap_mim
* device instance $1462 r0 *1 176.8,17.35 sky130_fd_pr__model__cap_mim
C$1462 \$530 TOP_N|VINN 8.664e-15 sky130_fd_pr__model__cap_mim
* device instance $1463 r0 *1 180.2,17.35 sky130_fd_pr__model__cap_mim
C$1463 \$528 TOP_N|VINN 8.664e-15 sky130_fd_pr__model__cap_mim
* device instance $1464 r0 *1 183.6,17.35 sky130_fd_pr__model__cap_mim
C$1464 \$529 TOP_N|VINN 8.664e-15 sky130_fd_pr__model__cap_mim
* device instance $1465 r0 *1 187,17.35 sky130_fd_pr__model__cap_mim
C$1465 \$528 TOP_N|VINN 8.664e-15 sky130_fd_pr__model__cap_mim
* device instance $1466 r0 *1 190.4,17.35 sky130_fd_pr__model__cap_mim
C$1466 \$531 TOP_N|VINN 8.664e-15 sky130_fd_pr__model__cap_mim
* device instance $1467 r0 *1 193.8,17.35 sky130_fd_pr__model__cap_mim
C$1467 \$528 TOP_N|VINN 8.664e-15 sky130_fd_pr__model__cap_mim
* device instance $1468 r0 *1 197.2,17.35 sky130_fd_pr__model__cap_mim
C$1468 \$529 TOP_N|VINN 8.664e-15 sky130_fd_pr__model__cap_mim
* device instance $1469 r0 *1 200.6,17.35 sky130_fd_pr__model__cap_mim
C$1469 \$528 TOP_N|VINN 8.664e-15 sky130_fd_pr__model__cap_mim
* device instance $1470 r0 *1 204,17.35 sky130_fd_pr__model__cap_mim
C$1470 \$530 TOP_N|VINN 8.664e-15 sky130_fd_pr__model__cap_mim
* device instance $1471 r0 *1 207.4,17.35 sky130_fd_pr__model__cap_mim
C$1471 \$528 TOP_N|VINN 8.664e-15 sky130_fd_pr__model__cap_mim
* device instance $1472 r0 *1 210.8,17.35 sky130_fd_pr__model__cap_mim
C$1472 \$529 TOP_N|VINN 8.664e-15 sky130_fd_pr__model__cap_mim
* device instance $1473 r0 *1 214.2,17.35 sky130_fd_pr__model__cap_mim
C$1473 \$528 TOP_N|VINN 8.664e-15 sky130_fd_pr__model__cap_mim
* device instance $1474 r0 *1 0,20.75 sky130_fd_pr__model__cap_mim
C$1474 \$532 TOP_P|VINP 8.664e-15 sky130_fd_pr__model__cap_mim
* device instance $1475 r0 *1 3.4,20.75 sky130_fd_pr__model__cap_mim
C$1475 \$533 TOP_P|VINP 8.664e-15 sky130_fd_pr__model__cap_mim
* device instance $1476 r0 *1 6.8,20.75 sky130_fd_pr__model__cap_mim
C$1476 \$532 TOP_P|VINP 8.664e-15 sky130_fd_pr__model__cap_mim
* device instance $1477 r0 *1 10.2,20.75 sky130_fd_pr__model__cap_mim
C$1477 \$534 TOP_P|VINP 8.664e-15 sky130_fd_pr__model__cap_mim
* device instance $1478 r0 *1 13.6,20.75 sky130_fd_pr__model__cap_mim
C$1478 \$532 TOP_P|VINP 8.664e-15 sky130_fd_pr__model__cap_mim
* device instance $1479 r0 *1 17,20.75 sky130_fd_pr__model__cap_mim
C$1479 \$533 TOP_P|VINP 8.664e-15 sky130_fd_pr__model__cap_mim
* device instance $1480 r0 *1 20.4,20.75 sky130_fd_pr__model__cap_mim
C$1480 \$532 TOP_P|VINP 8.664e-15 sky130_fd_pr__model__cap_mim
* device instance $1481 r0 *1 23.8,20.75 sky130_fd_pr__model__cap_mim
C$1481 \$521 TOP_P|VINP 8.664e-15 sky130_fd_pr__model__cap_mim
* device instance $1482 r0 *1 27.2,20.75 sky130_fd_pr__model__cap_mim
C$1482 \$532 TOP_P|VINP 8.664e-15 sky130_fd_pr__model__cap_mim
* device instance $1483 r0 *1 30.6,20.75 sky130_fd_pr__model__cap_mim
C$1483 \$533 TOP_P|VINP 8.664e-15 sky130_fd_pr__model__cap_mim
* device instance $1484 r0 *1 34,20.75 sky130_fd_pr__model__cap_mim
C$1484 \$532 TOP_P|VINP 8.664e-15 sky130_fd_pr__model__cap_mim
* device instance $1485 r0 *1 37.4,20.75 sky130_fd_pr__model__cap_mim
C$1485 \$534 TOP_P|VINP 8.664e-15 sky130_fd_pr__model__cap_mim
* device instance $1486 r0 *1 40.8,20.75 sky130_fd_pr__model__cap_mim
C$1486 \$532 TOP_P|VINP 8.664e-15 sky130_fd_pr__model__cap_mim
* device instance $1487 r0 *1 44.2,20.75 sky130_fd_pr__model__cap_mim
C$1487 \$533 TOP_P|VINP 8.664e-15 sky130_fd_pr__model__cap_mim
* device instance $1488 r0 *1 47.6,20.75 sky130_fd_pr__model__cap_mim
C$1488 \$532 TOP_P|VINP 8.664e-15 sky130_fd_pr__model__cap_mim
* device instance $1489 r0 *1 51,20.75 sky130_fd_pr__model__cap_mim
C$1489 \$520 TOP_P|VINP 8.664e-15 sky130_fd_pr__model__cap_mim
* device instance $1490 r0 *1 54.4,20.75 sky130_fd_pr__model__cap_mim
C$1490 \$532 TOP_P|VINP 8.664e-15 sky130_fd_pr__model__cap_mim
* device instance $1491 r0 *1 57.8,20.75 sky130_fd_pr__model__cap_mim
C$1491 \$533 TOP_P|VINP 8.664e-15 sky130_fd_pr__model__cap_mim
* device instance $1492 r0 *1 61.2,20.75 sky130_fd_pr__model__cap_mim
C$1492 \$532 TOP_P|VINP 8.664e-15 sky130_fd_pr__model__cap_mim
* device instance $1493 r0 *1 64.6,20.75 sky130_fd_pr__model__cap_mim
C$1493 \$534 TOP_P|VINP 8.664e-15 sky130_fd_pr__model__cap_mim
* device instance $1494 r0 *1 68,20.75 sky130_fd_pr__model__cap_mim
C$1494 \$532 TOP_P|VINP 8.664e-15 sky130_fd_pr__model__cap_mim
* device instance $1495 r0 *1 71.4,20.75 sky130_fd_pr__model__cap_mim
C$1495 \$533 TOP_P|VINP 8.664e-15 sky130_fd_pr__model__cap_mim
* device instance $1496 r0 *1 74.8,20.75 sky130_fd_pr__model__cap_mim
C$1496 \$532 TOP_P|VINP 8.664e-15 sky130_fd_pr__model__cap_mim
* device instance $1497 r0 *1 78.2,20.75 sky130_fd_pr__model__cap_mim
C$1497 \$521 TOP_P|VINP 8.664e-15 sky130_fd_pr__model__cap_mim
* device instance $1498 r0 *1 81.6,20.75 sky130_fd_pr__model__cap_mim
C$1498 \$532 TOP_P|VINP 8.664e-15 sky130_fd_pr__model__cap_mim
* device instance $1499 r0 *1 85,20.75 sky130_fd_pr__model__cap_mim
C$1499 \$533 TOP_P|VINP 8.664e-15 sky130_fd_pr__model__cap_mim
* device instance $1500 r0 *1 88.4,20.75 sky130_fd_pr__model__cap_mim
C$1500 \$532 TOP_P|VINP 8.664e-15 sky130_fd_pr__model__cap_mim
* device instance $1501 r0 *1 91.8,20.75 sky130_fd_pr__model__cap_mim
C$1501 \$534 TOP_P|VINP 8.664e-15 sky130_fd_pr__model__cap_mim
* device instance $1502 r0 *1 95.2,20.75 sky130_fd_pr__model__cap_mim
C$1502 \$532 TOP_P|VINP 8.664e-15 sky130_fd_pr__model__cap_mim
* device instance $1503 r0 *1 98.6,20.75 sky130_fd_pr__model__cap_mim
C$1503 \$533 TOP_P|VINP 8.664e-15 sky130_fd_pr__model__cap_mim
* device instance $1504 r0 *1 102,20.75 sky130_fd_pr__model__cap_mim
C$1504 \$532 TOP_P|VINP 8.664e-15 sky130_fd_pr__model__cap_mim
* device instance $1505 r0 *1 105.4,20.75 sky130_fd_pr__model__cap_mim
C$1505 \$519 TOP_P|VINP 8.664e-15 sky130_fd_pr__model__cap_mim
* device instance $1506 r0 *1 108.8,20.75 sky130_fd_pr__model__cap_mim
C$1506 \$518 TOP_P|VINP 8.664e-15 sky130_fd_pr__model__cap_mim
* device instance $1507 r0 *1 112.2,20.75 sky130_fd_pr__model__cap_mim
C$1507 \$532 TOP_P|VINP 8.664e-15 sky130_fd_pr__model__cap_mim
* device instance $1508 r0 *1 115.6,20.75 sky130_fd_pr__model__cap_mim
C$1508 \$533 TOP_P|VINP 8.664e-15 sky130_fd_pr__model__cap_mim
* device instance $1509 r0 *1 119,20.75 sky130_fd_pr__model__cap_mim
C$1509 \$532 TOP_P|VINP 8.664e-15 sky130_fd_pr__model__cap_mim
* device instance $1510 r0 *1 122.4,20.75 sky130_fd_pr__model__cap_mim
C$1510 \$534 TOP_P|VINP 8.664e-15 sky130_fd_pr__model__cap_mim
* device instance $1511 r0 *1 125.8,20.75 sky130_fd_pr__model__cap_mim
C$1511 \$532 TOP_P|VINP 8.664e-15 sky130_fd_pr__model__cap_mim
* device instance $1512 r0 *1 129.2,20.75 sky130_fd_pr__model__cap_mim
C$1512 \$533 TOP_P|VINP 8.664e-15 sky130_fd_pr__model__cap_mim
* device instance $1513 r0 *1 132.6,20.75 sky130_fd_pr__model__cap_mim
C$1513 \$532 TOP_P|VINP 8.664e-15 sky130_fd_pr__model__cap_mim
* device instance $1514 r0 *1 136,20.75 sky130_fd_pr__model__cap_mim
C$1514 \$521 TOP_P|VINP 8.664e-15 sky130_fd_pr__model__cap_mim
* device instance $1515 r0 *1 139.4,20.75 sky130_fd_pr__model__cap_mim
C$1515 \$532 TOP_P|VINP 8.664e-15 sky130_fd_pr__model__cap_mim
* device instance $1516 r0 *1 142.8,20.75 sky130_fd_pr__model__cap_mim
C$1516 \$533 TOP_P|VINP 8.664e-15 sky130_fd_pr__model__cap_mim
* device instance $1517 r0 *1 146.2,20.75 sky130_fd_pr__model__cap_mim
C$1517 \$532 TOP_P|VINP 8.664e-15 sky130_fd_pr__model__cap_mim
* device instance $1518 r0 *1 149.6,20.75 sky130_fd_pr__model__cap_mim
C$1518 \$534 TOP_P|VINP 8.664e-15 sky130_fd_pr__model__cap_mim
* device instance $1519 r0 *1 153,20.75 sky130_fd_pr__model__cap_mim
C$1519 \$532 TOP_P|VINP 8.664e-15 sky130_fd_pr__model__cap_mim
* device instance $1520 r0 *1 156.4,20.75 sky130_fd_pr__model__cap_mim
C$1520 \$533 TOP_P|VINP 8.664e-15 sky130_fd_pr__model__cap_mim
* device instance $1521 r0 *1 159.8,20.75 sky130_fd_pr__model__cap_mim
C$1521 \$532 TOP_P|VINP 8.664e-15 sky130_fd_pr__model__cap_mim
* device instance $1522 r0 *1 163.2,20.75 sky130_fd_pr__model__cap_mim
C$1522 \$520 TOP_P|VINP 8.664e-15 sky130_fd_pr__model__cap_mim
* device instance $1523 r0 *1 166.6,20.75 sky130_fd_pr__model__cap_mim
C$1523 \$532 TOP_P|VINP 8.664e-15 sky130_fd_pr__model__cap_mim
* device instance $1524 r0 *1 170,20.75 sky130_fd_pr__model__cap_mim
C$1524 \$533 TOP_P|VINP 8.664e-15 sky130_fd_pr__model__cap_mim
* device instance $1525 r0 *1 173.4,20.75 sky130_fd_pr__model__cap_mim
C$1525 \$532 TOP_P|VINP 8.664e-15 sky130_fd_pr__model__cap_mim
* device instance $1526 r0 *1 176.8,20.75 sky130_fd_pr__model__cap_mim
C$1526 \$534 TOP_P|VINP 8.664e-15 sky130_fd_pr__model__cap_mim
* device instance $1527 r0 *1 180.2,20.75 sky130_fd_pr__model__cap_mim
C$1527 \$532 TOP_P|VINP 8.664e-15 sky130_fd_pr__model__cap_mim
* device instance $1528 r0 *1 183.6,20.75 sky130_fd_pr__model__cap_mim
C$1528 \$533 TOP_P|VINP 8.664e-15 sky130_fd_pr__model__cap_mim
* device instance $1529 r0 *1 187,20.75 sky130_fd_pr__model__cap_mim
C$1529 \$532 TOP_P|VINP 8.664e-15 sky130_fd_pr__model__cap_mim
* device instance $1530 r0 *1 190.4,20.75 sky130_fd_pr__model__cap_mim
C$1530 \$521 TOP_P|VINP 8.664e-15 sky130_fd_pr__model__cap_mim
* device instance $1531 r0 *1 193.8,20.75 sky130_fd_pr__model__cap_mim
C$1531 \$532 TOP_P|VINP 8.664e-15 sky130_fd_pr__model__cap_mim
* device instance $1532 r0 *1 197.2,20.75 sky130_fd_pr__model__cap_mim
C$1532 \$533 TOP_P|VINP 8.664e-15 sky130_fd_pr__model__cap_mim
* device instance $1533 r0 *1 200.6,20.75 sky130_fd_pr__model__cap_mim
C$1533 \$532 TOP_P|VINP 8.664e-15 sky130_fd_pr__model__cap_mim
* device instance $1534 r0 *1 204,20.75 sky130_fd_pr__model__cap_mim
C$1534 \$534 TOP_P|VINP 8.664e-15 sky130_fd_pr__model__cap_mim
* device instance $1535 r0 *1 207.4,20.75 sky130_fd_pr__model__cap_mim
C$1535 \$532 TOP_P|VINP 8.664e-15 sky130_fd_pr__model__cap_mim
* device instance $1536 r0 *1 210.8,20.75 sky130_fd_pr__model__cap_mim
C$1536 \$533 TOP_P|VINP 8.664e-15 sky130_fd_pr__model__cap_mim
* device instance $1537 r0 *1 214.2,20.75 sky130_fd_pr__model__cap_mim
C$1537 \$532 TOP_P|VINP 8.664e-15 sky130_fd_pr__model__cap_mim
* device instance $1538 r0 *1 0,24.15 sky130_fd_pr__model__cap_mim
C$1538 \$528 TOP_N|VINN 8.664e-15 sky130_fd_pr__model__cap_mim
* device instance $1539 r0 *1 3.4,24.15 sky130_fd_pr__model__cap_mim
C$1539 \$529 TOP_N|VINN 8.664e-15 sky130_fd_pr__model__cap_mim
* device instance $1540 r0 *1 6.8,24.15 sky130_fd_pr__model__cap_mim
C$1540 \$528 TOP_N|VINN 8.664e-15 sky130_fd_pr__model__cap_mim
* device instance $1541 r0 *1 10.2,24.15 sky130_fd_pr__model__cap_mim
C$1541 \$530 TOP_N|VINN 8.664e-15 sky130_fd_pr__model__cap_mim
* device instance $1542 r0 *1 13.6,24.15 sky130_fd_pr__model__cap_mim
C$1542 \$528 TOP_N|VINN 8.664e-15 sky130_fd_pr__model__cap_mim
* device instance $1543 r0 *1 17,24.15 sky130_fd_pr__model__cap_mim
C$1543 \$529 TOP_N|VINN 8.664e-15 sky130_fd_pr__model__cap_mim
* device instance $1544 r0 *1 20.4,24.15 sky130_fd_pr__model__cap_mim
C$1544 \$528 TOP_N|VINN 8.664e-15 sky130_fd_pr__model__cap_mim
* device instance $1545 r0 *1 23.8,24.15 sky130_fd_pr__model__cap_mim
C$1545 \$531 TOP_N|VINN 8.664e-15 sky130_fd_pr__model__cap_mim
* device instance $1546 r0 *1 27.2,24.15 sky130_fd_pr__model__cap_mim
C$1546 \$528 TOP_N|VINN 8.664e-15 sky130_fd_pr__model__cap_mim
* device instance $1547 r0 *1 30.6,24.15 sky130_fd_pr__model__cap_mim
C$1547 \$529 TOP_N|VINN 8.664e-15 sky130_fd_pr__model__cap_mim
* device instance $1548 r0 *1 34,24.15 sky130_fd_pr__model__cap_mim
C$1548 \$528 TOP_N|VINN 8.664e-15 sky130_fd_pr__model__cap_mim
* device instance $1549 r0 *1 37.4,24.15 sky130_fd_pr__model__cap_mim
C$1549 \$530 TOP_N|VINN 8.664e-15 sky130_fd_pr__model__cap_mim
* device instance $1550 r0 *1 40.8,24.15 sky130_fd_pr__model__cap_mim
C$1550 \$528 TOP_N|VINN 8.664e-15 sky130_fd_pr__model__cap_mim
* device instance $1551 r0 *1 44.2,24.15 sky130_fd_pr__model__cap_mim
C$1551 \$529 TOP_N|VINN 8.664e-15 sky130_fd_pr__model__cap_mim
* device instance $1552 r0 *1 47.6,24.15 sky130_fd_pr__model__cap_mim
C$1552 \$528 TOP_N|VINN 8.664e-15 sky130_fd_pr__model__cap_mim
* device instance $1553 r0 *1 51,24.15 sky130_fd_pr__model__cap_mim
C$1553 \$526 TOP_N|VINN 8.664e-15 sky130_fd_pr__model__cap_mim
* device instance $1554 r0 *1 54.4,24.15 sky130_fd_pr__model__cap_mim
C$1554 \$528 TOP_N|VINN 8.664e-15 sky130_fd_pr__model__cap_mim
* device instance $1555 r0 *1 57.8,24.15 sky130_fd_pr__model__cap_mim
C$1555 \$529 TOP_N|VINN 8.664e-15 sky130_fd_pr__model__cap_mim
* device instance $1556 r0 *1 61.2,24.15 sky130_fd_pr__model__cap_mim
C$1556 \$528 TOP_N|VINN 8.664e-15 sky130_fd_pr__model__cap_mim
* device instance $1557 r0 *1 64.6,24.15 sky130_fd_pr__model__cap_mim
C$1557 \$530 TOP_N|VINN 8.664e-15 sky130_fd_pr__model__cap_mim
* device instance $1558 r0 *1 68,24.15 sky130_fd_pr__model__cap_mim
C$1558 \$528 TOP_N|VINN 8.664e-15 sky130_fd_pr__model__cap_mim
* device instance $1559 r0 *1 71.4,24.15 sky130_fd_pr__model__cap_mim
C$1559 \$529 TOP_N|VINN 8.664e-15 sky130_fd_pr__model__cap_mim
* device instance $1560 r0 *1 74.8,24.15 sky130_fd_pr__model__cap_mim
C$1560 \$528 TOP_N|VINN 8.664e-15 sky130_fd_pr__model__cap_mim
* device instance $1561 r0 *1 78.2,24.15 sky130_fd_pr__model__cap_mim
C$1561 \$531 TOP_N|VINN 8.664e-15 sky130_fd_pr__model__cap_mim
* device instance $1562 r0 *1 81.6,24.15 sky130_fd_pr__model__cap_mim
C$1562 \$528 TOP_N|VINN 8.664e-15 sky130_fd_pr__model__cap_mim
* device instance $1563 r0 *1 85,24.15 sky130_fd_pr__model__cap_mim
C$1563 \$529 TOP_N|VINN 8.664e-15 sky130_fd_pr__model__cap_mim
* device instance $1564 r0 *1 88.4,24.15 sky130_fd_pr__model__cap_mim
C$1564 \$528 TOP_N|VINN 8.664e-15 sky130_fd_pr__model__cap_mim
* device instance $1565 r0 *1 91.8,24.15 sky130_fd_pr__model__cap_mim
C$1565 \$530 TOP_N|VINN 8.664e-15 sky130_fd_pr__model__cap_mim
* device instance $1566 r0 *1 95.2,24.15 sky130_fd_pr__model__cap_mim
C$1566 \$528 TOP_N|VINN 8.664e-15 sky130_fd_pr__model__cap_mim
* device instance $1567 r0 *1 98.6,24.15 sky130_fd_pr__model__cap_mim
C$1567 \$529 TOP_N|VINN 8.664e-15 sky130_fd_pr__model__cap_mim
* device instance $1568 r0 *1 102,24.15 sky130_fd_pr__model__cap_mim
C$1568 \$528 TOP_N|VINN 8.664e-15 sky130_fd_pr__model__cap_mim
* device instance $1569 r0 *1 105.4,24.15 sky130_fd_pr__model__cap_mim
C$1569 \$525 TOP_N|VINN 8.664e-15 sky130_fd_pr__model__cap_mim
* device instance $1570 r0 *1 108.8,24.15 sky130_fd_pr__model__cap_mim
C$1570 \$524 TOP_N|VINN 8.664e-15 sky130_fd_pr__model__cap_mim
* device instance $1571 r0 *1 112.2,24.15 sky130_fd_pr__model__cap_mim
C$1571 \$528 TOP_N|VINN 8.664e-15 sky130_fd_pr__model__cap_mim
* device instance $1572 r0 *1 115.6,24.15 sky130_fd_pr__model__cap_mim
C$1572 \$529 TOP_N|VINN 8.664e-15 sky130_fd_pr__model__cap_mim
* device instance $1573 r0 *1 119,24.15 sky130_fd_pr__model__cap_mim
C$1573 \$528 TOP_N|VINN 8.664e-15 sky130_fd_pr__model__cap_mim
* device instance $1574 r0 *1 122.4,24.15 sky130_fd_pr__model__cap_mim
C$1574 \$530 TOP_N|VINN 8.664e-15 sky130_fd_pr__model__cap_mim
* device instance $1575 r0 *1 125.8,24.15 sky130_fd_pr__model__cap_mim
C$1575 \$528 TOP_N|VINN 8.664e-15 sky130_fd_pr__model__cap_mim
* device instance $1576 r0 *1 129.2,24.15 sky130_fd_pr__model__cap_mim
C$1576 \$529 TOP_N|VINN 8.664e-15 sky130_fd_pr__model__cap_mim
* device instance $1577 r0 *1 132.6,24.15 sky130_fd_pr__model__cap_mim
C$1577 \$528 TOP_N|VINN 8.664e-15 sky130_fd_pr__model__cap_mim
* device instance $1578 r0 *1 136,24.15 sky130_fd_pr__model__cap_mim
C$1578 \$531 TOP_N|VINN 8.664e-15 sky130_fd_pr__model__cap_mim
* device instance $1579 r0 *1 139.4,24.15 sky130_fd_pr__model__cap_mim
C$1579 \$528 TOP_N|VINN 8.664e-15 sky130_fd_pr__model__cap_mim
* device instance $1580 r0 *1 142.8,24.15 sky130_fd_pr__model__cap_mim
C$1580 \$529 TOP_N|VINN 8.664e-15 sky130_fd_pr__model__cap_mim
* device instance $1581 r0 *1 146.2,24.15 sky130_fd_pr__model__cap_mim
C$1581 \$528 TOP_N|VINN 8.664e-15 sky130_fd_pr__model__cap_mim
* device instance $1582 r0 *1 149.6,24.15 sky130_fd_pr__model__cap_mim
C$1582 \$530 TOP_N|VINN 8.664e-15 sky130_fd_pr__model__cap_mim
* device instance $1583 r0 *1 153,24.15 sky130_fd_pr__model__cap_mim
C$1583 \$528 TOP_N|VINN 8.664e-15 sky130_fd_pr__model__cap_mim
* device instance $1584 r0 *1 156.4,24.15 sky130_fd_pr__model__cap_mim
C$1584 \$529 TOP_N|VINN 8.664e-15 sky130_fd_pr__model__cap_mim
* device instance $1585 r0 *1 159.8,24.15 sky130_fd_pr__model__cap_mim
C$1585 \$528 TOP_N|VINN 8.664e-15 sky130_fd_pr__model__cap_mim
* device instance $1586 r0 *1 163.2,24.15 sky130_fd_pr__model__cap_mim
C$1586 \$526 TOP_N|VINN 8.664e-15 sky130_fd_pr__model__cap_mim
* device instance $1587 r0 *1 166.6,24.15 sky130_fd_pr__model__cap_mim
C$1587 \$528 TOP_N|VINN 8.664e-15 sky130_fd_pr__model__cap_mim
* device instance $1588 r0 *1 170,24.15 sky130_fd_pr__model__cap_mim
C$1588 \$529 TOP_N|VINN 8.664e-15 sky130_fd_pr__model__cap_mim
* device instance $1589 r0 *1 173.4,24.15 sky130_fd_pr__model__cap_mim
C$1589 \$528 TOP_N|VINN 8.664e-15 sky130_fd_pr__model__cap_mim
* device instance $1590 r0 *1 176.8,24.15 sky130_fd_pr__model__cap_mim
C$1590 \$530 TOP_N|VINN 8.664e-15 sky130_fd_pr__model__cap_mim
* device instance $1591 r0 *1 180.2,24.15 sky130_fd_pr__model__cap_mim
C$1591 \$528 TOP_N|VINN 8.664e-15 sky130_fd_pr__model__cap_mim
* device instance $1592 r0 *1 183.6,24.15 sky130_fd_pr__model__cap_mim
C$1592 \$529 TOP_N|VINN 8.664e-15 sky130_fd_pr__model__cap_mim
* device instance $1593 r0 *1 187,24.15 sky130_fd_pr__model__cap_mim
C$1593 \$528 TOP_N|VINN 8.664e-15 sky130_fd_pr__model__cap_mim
* device instance $1594 r0 *1 190.4,24.15 sky130_fd_pr__model__cap_mim
C$1594 \$531 TOP_N|VINN 8.664e-15 sky130_fd_pr__model__cap_mim
* device instance $1595 r0 *1 193.8,24.15 sky130_fd_pr__model__cap_mim
C$1595 \$528 TOP_N|VINN 8.664e-15 sky130_fd_pr__model__cap_mim
* device instance $1596 r0 *1 197.2,24.15 sky130_fd_pr__model__cap_mim
C$1596 \$529 TOP_N|VINN 8.664e-15 sky130_fd_pr__model__cap_mim
* device instance $1597 r0 *1 200.6,24.15 sky130_fd_pr__model__cap_mim
C$1597 \$528 TOP_N|VINN 8.664e-15 sky130_fd_pr__model__cap_mim
* device instance $1598 r0 *1 204,24.15 sky130_fd_pr__model__cap_mim
C$1598 \$530 TOP_N|VINN 8.664e-15 sky130_fd_pr__model__cap_mim
* device instance $1599 r0 *1 207.4,24.15 sky130_fd_pr__model__cap_mim
C$1599 \$528 TOP_N|VINN 8.664e-15 sky130_fd_pr__model__cap_mim
* device instance $1600 r0 *1 210.8,24.15 sky130_fd_pr__model__cap_mim
C$1600 \$529 TOP_N|VINN 8.664e-15 sky130_fd_pr__model__cap_mim
* device instance $1601 r0 *1 214.2,24.15 sky130_fd_pr__model__cap_mim
C$1601 \$528 TOP_N|VINN 8.664e-15 sky130_fd_pr__model__cap_mim
* device instance $1602 r0 *1 0,27.55 sky130_fd_pr__model__cap_mim
C$1602 \$528 TOP_N|VINN 8.664e-15 sky130_fd_pr__model__cap_mim
* device instance $1603 r0 *1 3.4,27.55 sky130_fd_pr__model__cap_mim
C$1603 \$529 TOP_N|VINN 8.664e-15 sky130_fd_pr__model__cap_mim
* device instance $1604 r0 *1 6.8,27.55 sky130_fd_pr__model__cap_mim
C$1604 \$528 TOP_N|VINN 8.664e-15 sky130_fd_pr__model__cap_mim
* device instance $1605 r0 *1 10.2,27.55 sky130_fd_pr__model__cap_mim
C$1605 \$530 TOP_N|VINN 8.664e-15 sky130_fd_pr__model__cap_mim
* device instance $1606 r0 *1 13.6,27.55 sky130_fd_pr__model__cap_mim
C$1606 \$528 TOP_N|VINN 8.664e-15 sky130_fd_pr__model__cap_mim
* device instance $1607 r0 *1 17,27.55 sky130_fd_pr__model__cap_mim
C$1607 \$529 TOP_N|VINN 8.664e-15 sky130_fd_pr__model__cap_mim
* device instance $1608 r0 *1 20.4,27.55 sky130_fd_pr__model__cap_mim
C$1608 \$528 TOP_N|VINN 8.664e-15 sky130_fd_pr__model__cap_mim
* device instance $1609 r0 *1 23.8,27.55 sky130_fd_pr__model__cap_mim
C$1609 \$531 TOP_N|VINN 8.664e-15 sky130_fd_pr__model__cap_mim
* device instance $1610 r0 *1 27.2,27.55 sky130_fd_pr__model__cap_mim
C$1610 \$528 TOP_N|VINN 8.664e-15 sky130_fd_pr__model__cap_mim
* device instance $1611 r0 *1 30.6,27.55 sky130_fd_pr__model__cap_mim
C$1611 \$529 TOP_N|VINN 8.664e-15 sky130_fd_pr__model__cap_mim
* device instance $1612 r0 *1 34,27.55 sky130_fd_pr__model__cap_mim
C$1612 \$528 TOP_N|VINN 8.664e-15 sky130_fd_pr__model__cap_mim
* device instance $1613 r0 *1 37.4,27.55 sky130_fd_pr__model__cap_mim
C$1613 \$530 TOP_N|VINN 8.664e-15 sky130_fd_pr__model__cap_mim
* device instance $1614 r0 *1 40.8,27.55 sky130_fd_pr__model__cap_mim
C$1614 \$528 TOP_N|VINN 8.664e-15 sky130_fd_pr__model__cap_mim
* device instance $1615 r0 *1 44.2,27.55 sky130_fd_pr__model__cap_mim
C$1615 \$529 TOP_N|VINN 8.664e-15 sky130_fd_pr__model__cap_mim
* device instance $1616 r0 *1 47.6,27.55 sky130_fd_pr__model__cap_mim
C$1616 \$528 TOP_N|VINN 8.664e-15 sky130_fd_pr__model__cap_mim
* device instance $1617 r0 *1 51,27.55 sky130_fd_pr__model__cap_mim
C$1617 \$526 TOP_N|VINN 8.664e-15 sky130_fd_pr__model__cap_mim
* device instance $1618 r0 *1 54.4,27.55 sky130_fd_pr__model__cap_mim
C$1618 \$528 TOP_N|VINN 8.664e-15 sky130_fd_pr__model__cap_mim
* device instance $1619 r0 *1 57.8,27.55 sky130_fd_pr__model__cap_mim
C$1619 \$529 TOP_N|VINN 8.664e-15 sky130_fd_pr__model__cap_mim
* device instance $1620 r0 *1 61.2,27.55 sky130_fd_pr__model__cap_mim
C$1620 \$528 TOP_N|VINN 8.664e-15 sky130_fd_pr__model__cap_mim
* device instance $1621 r0 *1 64.6,27.55 sky130_fd_pr__model__cap_mim
C$1621 \$530 TOP_N|VINN 8.664e-15 sky130_fd_pr__model__cap_mim
* device instance $1622 r0 *1 68,27.55 sky130_fd_pr__model__cap_mim
C$1622 \$528 TOP_N|VINN 8.664e-15 sky130_fd_pr__model__cap_mim
* device instance $1623 r0 *1 71.4,27.55 sky130_fd_pr__model__cap_mim
C$1623 \$529 TOP_N|VINN 8.664e-15 sky130_fd_pr__model__cap_mim
* device instance $1624 r0 *1 74.8,27.55 sky130_fd_pr__model__cap_mim
C$1624 \$528 TOP_N|VINN 8.664e-15 sky130_fd_pr__model__cap_mim
* device instance $1625 r0 *1 78.2,27.55 sky130_fd_pr__model__cap_mim
C$1625 \$531 TOP_N|VINN 8.664e-15 sky130_fd_pr__model__cap_mim
* device instance $1626 r0 *1 81.6,27.55 sky130_fd_pr__model__cap_mim
C$1626 \$528 TOP_N|VINN 8.664e-15 sky130_fd_pr__model__cap_mim
* device instance $1627 r0 *1 85,27.55 sky130_fd_pr__model__cap_mim
C$1627 \$529 TOP_N|VINN 8.664e-15 sky130_fd_pr__model__cap_mim
* device instance $1628 r0 *1 88.4,27.55 sky130_fd_pr__model__cap_mim
C$1628 \$528 TOP_N|VINN 8.664e-15 sky130_fd_pr__model__cap_mim
* device instance $1629 r0 *1 91.8,27.55 sky130_fd_pr__model__cap_mim
C$1629 \$530 TOP_N|VINN 8.664e-15 sky130_fd_pr__model__cap_mim
* device instance $1630 r0 *1 95.2,27.55 sky130_fd_pr__model__cap_mim
C$1630 \$528 TOP_N|VINN 8.664e-15 sky130_fd_pr__model__cap_mim
* device instance $1631 r0 *1 98.6,27.55 sky130_fd_pr__model__cap_mim
C$1631 \$529 TOP_N|VINN 8.664e-15 sky130_fd_pr__model__cap_mim
* device instance $1632 r0 *1 102,27.55 sky130_fd_pr__model__cap_mim
C$1632 \$528 TOP_N|VINN 8.664e-15 sky130_fd_pr__model__cap_mim
* device instance $1633 r0 *1 105.4,27.55 sky130_fd_pr__model__cap_mim
C$1633 \$525 TOP_N|VINN 8.664e-15 sky130_fd_pr__model__cap_mim
* device instance $1634 r0 *1 108.8,27.55 sky130_fd_pr__model__cap_mim
C$1634 \$524 TOP_N|VINN 8.664e-15 sky130_fd_pr__model__cap_mim
* device instance $1635 r0 *1 112.2,27.55 sky130_fd_pr__model__cap_mim
C$1635 \$528 TOP_N|VINN 8.664e-15 sky130_fd_pr__model__cap_mim
* device instance $1636 r0 *1 115.6,27.55 sky130_fd_pr__model__cap_mim
C$1636 \$529 TOP_N|VINN 8.664e-15 sky130_fd_pr__model__cap_mim
* device instance $1637 r0 *1 119,27.55 sky130_fd_pr__model__cap_mim
C$1637 \$528 TOP_N|VINN 8.664e-15 sky130_fd_pr__model__cap_mim
* device instance $1638 r0 *1 122.4,27.55 sky130_fd_pr__model__cap_mim
C$1638 \$530 TOP_N|VINN 8.664e-15 sky130_fd_pr__model__cap_mim
* device instance $1639 r0 *1 125.8,27.55 sky130_fd_pr__model__cap_mim
C$1639 \$528 TOP_N|VINN 8.664e-15 sky130_fd_pr__model__cap_mim
* device instance $1640 r0 *1 129.2,27.55 sky130_fd_pr__model__cap_mim
C$1640 \$529 TOP_N|VINN 8.664e-15 sky130_fd_pr__model__cap_mim
* device instance $1641 r0 *1 132.6,27.55 sky130_fd_pr__model__cap_mim
C$1641 \$528 TOP_N|VINN 8.664e-15 sky130_fd_pr__model__cap_mim
* device instance $1642 r0 *1 136,27.55 sky130_fd_pr__model__cap_mim
C$1642 \$531 TOP_N|VINN 8.664e-15 sky130_fd_pr__model__cap_mim
* device instance $1643 r0 *1 139.4,27.55 sky130_fd_pr__model__cap_mim
C$1643 \$528 TOP_N|VINN 8.664e-15 sky130_fd_pr__model__cap_mim
* device instance $1644 r0 *1 142.8,27.55 sky130_fd_pr__model__cap_mim
C$1644 \$529 TOP_N|VINN 8.664e-15 sky130_fd_pr__model__cap_mim
* device instance $1645 r0 *1 146.2,27.55 sky130_fd_pr__model__cap_mim
C$1645 \$528 TOP_N|VINN 8.664e-15 sky130_fd_pr__model__cap_mim
* device instance $1646 r0 *1 149.6,27.55 sky130_fd_pr__model__cap_mim
C$1646 \$530 TOP_N|VINN 8.664e-15 sky130_fd_pr__model__cap_mim
* device instance $1647 r0 *1 153,27.55 sky130_fd_pr__model__cap_mim
C$1647 \$528 TOP_N|VINN 8.664e-15 sky130_fd_pr__model__cap_mim
* device instance $1648 r0 *1 156.4,27.55 sky130_fd_pr__model__cap_mim
C$1648 \$529 TOP_N|VINN 8.664e-15 sky130_fd_pr__model__cap_mim
* device instance $1649 r0 *1 159.8,27.55 sky130_fd_pr__model__cap_mim
C$1649 \$528 TOP_N|VINN 8.664e-15 sky130_fd_pr__model__cap_mim
* device instance $1650 r0 *1 163.2,27.55 sky130_fd_pr__model__cap_mim
C$1650 \$526 TOP_N|VINN 8.664e-15 sky130_fd_pr__model__cap_mim
* device instance $1651 r0 *1 166.6,27.55 sky130_fd_pr__model__cap_mim
C$1651 \$528 TOP_N|VINN 8.664e-15 sky130_fd_pr__model__cap_mim
* device instance $1652 r0 *1 170,27.55 sky130_fd_pr__model__cap_mim
C$1652 \$529 TOP_N|VINN 8.664e-15 sky130_fd_pr__model__cap_mim
* device instance $1653 r0 *1 173.4,27.55 sky130_fd_pr__model__cap_mim
C$1653 \$528 TOP_N|VINN 8.664e-15 sky130_fd_pr__model__cap_mim
* device instance $1654 r0 *1 176.8,27.55 sky130_fd_pr__model__cap_mim
C$1654 \$530 TOP_N|VINN 8.664e-15 sky130_fd_pr__model__cap_mim
* device instance $1655 r0 *1 180.2,27.55 sky130_fd_pr__model__cap_mim
C$1655 \$528 TOP_N|VINN 8.664e-15 sky130_fd_pr__model__cap_mim
* device instance $1656 r0 *1 183.6,27.55 sky130_fd_pr__model__cap_mim
C$1656 \$529 TOP_N|VINN 8.664e-15 sky130_fd_pr__model__cap_mim
* device instance $1657 r0 *1 187,27.55 sky130_fd_pr__model__cap_mim
C$1657 \$528 TOP_N|VINN 8.664e-15 sky130_fd_pr__model__cap_mim
* device instance $1658 r0 *1 190.4,27.55 sky130_fd_pr__model__cap_mim
C$1658 \$531 TOP_N|VINN 8.664e-15 sky130_fd_pr__model__cap_mim
* device instance $1659 r0 *1 193.8,27.55 sky130_fd_pr__model__cap_mim
C$1659 \$528 TOP_N|VINN 8.664e-15 sky130_fd_pr__model__cap_mim
* device instance $1660 r0 *1 197.2,27.55 sky130_fd_pr__model__cap_mim
C$1660 \$529 TOP_N|VINN 8.664e-15 sky130_fd_pr__model__cap_mim
* device instance $1661 r0 *1 200.6,27.55 sky130_fd_pr__model__cap_mim
C$1661 \$528 TOP_N|VINN 8.664e-15 sky130_fd_pr__model__cap_mim
* device instance $1662 r0 *1 204,27.55 sky130_fd_pr__model__cap_mim
C$1662 \$530 TOP_N|VINN 8.664e-15 sky130_fd_pr__model__cap_mim
* device instance $1663 r0 *1 207.4,27.55 sky130_fd_pr__model__cap_mim
C$1663 \$528 TOP_N|VINN 8.664e-15 sky130_fd_pr__model__cap_mim
* device instance $1664 r0 *1 210.8,27.55 sky130_fd_pr__model__cap_mim
C$1664 \$529 TOP_N|VINN 8.664e-15 sky130_fd_pr__model__cap_mim
* device instance $1665 r0 *1 214.2,27.55 sky130_fd_pr__model__cap_mim
C$1665 \$528 TOP_N|VINN 8.664e-15 sky130_fd_pr__model__cap_mim
* device instance $1666 r0 *1 0,30.95 sky130_fd_pr__model__cap_mim
C$1666 \$532 TOP_P|VINP 8.664e-15 sky130_fd_pr__model__cap_mim
* device instance $1667 r0 *1 3.4,30.95 sky130_fd_pr__model__cap_mim
C$1667 \$533 TOP_P|VINP 8.664e-15 sky130_fd_pr__model__cap_mim
* device instance $1668 r0 *1 6.8,30.95 sky130_fd_pr__model__cap_mim
C$1668 \$532 TOP_P|VINP 8.664e-15 sky130_fd_pr__model__cap_mim
* device instance $1669 r0 *1 10.2,30.95 sky130_fd_pr__model__cap_mim
C$1669 \$534 TOP_P|VINP 8.664e-15 sky130_fd_pr__model__cap_mim
* device instance $1670 r0 *1 13.6,30.95 sky130_fd_pr__model__cap_mim
C$1670 \$532 TOP_P|VINP 8.664e-15 sky130_fd_pr__model__cap_mim
* device instance $1671 r0 *1 17,30.95 sky130_fd_pr__model__cap_mim
C$1671 \$533 TOP_P|VINP 8.664e-15 sky130_fd_pr__model__cap_mim
* device instance $1672 r0 *1 20.4,30.95 sky130_fd_pr__model__cap_mim
C$1672 \$532 TOP_P|VINP 8.664e-15 sky130_fd_pr__model__cap_mim
* device instance $1673 r0 *1 23.8,30.95 sky130_fd_pr__model__cap_mim
C$1673 \$521 TOP_P|VINP 8.664e-15 sky130_fd_pr__model__cap_mim
* device instance $1674 r0 *1 27.2,30.95 sky130_fd_pr__model__cap_mim
C$1674 \$532 TOP_P|VINP 8.664e-15 sky130_fd_pr__model__cap_mim
* device instance $1675 r0 *1 30.6,30.95 sky130_fd_pr__model__cap_mim
C$1675 \$533 TOP_P|VINP 8.664e-15 sky130_fd_pr__model__cap_mim
* device instance $1676 r0 *1 34,30.95 sky130_fd_pr__model__cap_mim
C$1676 \$532 TOP_P|VINP 8.664e-15 sky130_fd_pr__model__cap_mim
* device instance $1677 r0 *1 37.4,30.95 sky130_fd_pr__model__cap_mim
C$1677 \$534 TOP_P|VINP 8.664e-15 sky130_fd_pr__model__cap_mim
* device instance $1678 r0 *1 40.8,30.95 sky130_fd_pr__model__cap_mim
C$1678 \$532 TOP_P|VINP 8.664e-15 sky130_fd_pr__model__cap_mim
* device instance $1679 r0 *1 44.2,30.95 sky130_fd_pr__model__cap_mim
C$1679 \$533 TOP_P|VINP 8.664e-15 sky130_fd_pr__model__cap_mim
* device instance $1680 r0 *1 47.6,30.95 sky130_fd_pr__model__cap_mim
C$1680 \$532 TOP_P|VINP 8.664e-15 sky130_fd_pr__model__cap_mim
* device instance $1681 r0 *1 51,30.95 sky130_fd_pr__model__cap_mim
C$1681 \$520 TOP_P|VINP 8.664e-15 sky130_fd_pr__model__cap_mim
* device instance $1682 r0 *1 54.4,30.95 sky130_fd_pr__model__cap_mim
C$1682 \$532 TOP_P|VINP 8.664e-15 sky130_fd_pr__model__cap_mim
* device instance $1683 r0 *1 57.8,30.95 sky130_fd_pr__model__cap_mim
C$1683 \$533 TOP_P|VINP 8.664e-15 sky130_fd_pr__model__cap_mim
* device instance $1684 r0 *1 61.2,30.95 sky130_fd_pr__model__cap_mim
C$1684 \$532 TOP_P|VINP 8.664e-15 sky130_fd_pr__model__cap_mim
* device instance $1685 r0 *1 64.6,30.95 sky130_fd_pr__model__cap_mim
C$1685 \$534 TOP_P|VINP 8.664e-15 sky130_fd_pr__model__cap_mim
* device instance $1686 r0 *1 68,30.95 sky130_fd_pr__model__cap_mim
C$1686 \$532 TOP_P|VINP 8.664e-15 sky130_fd_pr__model__cap_mim
* device instance $1687 r0 *1 71.4,30.95 sky130_fd_pr__model__cap_mim
C$1687 \$533 TOP_P|VINP 8.664e-15 sky130_fd_pr__model__cap_mim
* device instance $1688 r0 *1 74.8,30.95 sky130_fd_pr__model__cap_mim
C$1688 \$532 TOP_P|VINP 8.664e-15 sky130_fd_pr__model__cap_mim
* device instance $1689 r0 *1 78.2,30.95 sky130_fd_pr__model__cap_mim
C$1689 \$521 TOP_P|VINP 8.664e-15 sky130_fd_pr__model__cap_mim
* device instance $1690 r0 *1 81.6,30.95 sky130_fd_pr__model__cap_mim
C$1690 \$532 TOP_P|VINP 8.664e-15 sky130_fd_pr__model__cap_mim
* device instance $1691 r0 *1 85,30.95 sky130_fd_pr__model__cap_mim
C$1691 \$533 TOP_P|VINP 8.664e-15 sky130_fd_pr__model__cap_mim
* device instance $1692 r0 *1 88.4,30.95 sky130_fd_pr__model__cap_mim
C$1692 \$532 TOP_P|VINP 8.664e-15 sky130_fd_pr__model__cap_mim
* device instance $1693 r0 *1 91.8,30.95 sky130_fd_pr__model__cap_mim
C$1693 \$534 TOP_P|VINP 8.664e-15 sky130_fd_pr__model__cap_mim
* device instance $1694 r0 *1 95.2,30.95 sky130_fd_pr__model__cap_mim
C$1694 \$532 TOP_P|VINP 8.664e-15 sky130_fd_pr__model__cap_mim
* device instance $1695 r0 *1 98.6,30.95 sky130_fd_pr__model__cap_mim
C$1695 \$533 TOP_P|VINP 8.664e-15 sky130_fd_pr__model__cap_mim
* device instance $1696 r0 *1 102,30.95 sky130_fd_pr__model__cap_mim
C$1696 \$532 TOP_P|VINP 8.664e-15 sky130_fd_pr__model__cap_mim
* device instance $1697 r0 *1 105.4,30.95 sky130_fd_pr__model__cap_mim
C$1697 \$519 TOP_P|VINP 8.664e-15 sky130_fd_pr__model__cap_mim
* device instance $1698 r0 *1 108.8,30.95 sky130_fd_pr__model__cap_mim
C$1698 \$518 TOP_P|VINP 8.664e-15 sky130_fd_pr__model__cap_mim
* device instance $1699 r0 *1 112.2,30.95 sky130_fd_pr__model__cap_mim
C$1699 \$532 TOP_P|VINP 8.664e-15 sky130_fd_pr__model__cap_mim
* device instance $1700 r0 *1 115.6,30.95 sky130_fd_pr__model__cap_mim
C$1700 \$533 TOP_P|VINP 8.664e-15 sky130_fd_pr__model__cap_mim
* device instance $1701 r0 *1 119,30.95 sky130_fd_pr__model__cap_mim
C$1701 \$532 TOP_P|VINP 8.664e-15 sky130_fd_pr__model__cap_mim
* device instance $1702 r0 *1 122.4,30.95 sky130_fd_pr__model__cap_mim
C$1702 \$534 TOP_P|VINP 8.664e-15 sky130_fd_pr__model__cap_mim
* device instance $1703 r0 *1 125.8,30.95 sky130_fd_pr__model__cap_mim
C$1703 \$532 TOP_P|VINP 8.664e-15 sky130_fd_pr__model__cap_mim
* device instance $1704 r0 *1 129.2,30.95 sky130_fd_pr__model__cap_mim
C$1704 \$533 TOP_P|VINP 8.664e-15 sky130_fd_pr__model__cap_mim
* device instance $1705 r0 *1 132.6,30.95 sky130_fd_pr__model__cap_mim
C$1705 \$532 TOP_P|VINP 8.664e-15 sky130_fd_pr__model__cap_mim
* device instance $1706 r0 *1 136,30.95 sky130_fd_pr__model__cap_mim
C$1706 \$521 TOP_P|VINP 8.664e-15 sky130_fd_pr__model__cap_mim
* device instance $1707 r0 *1 139.4,30.95 sky130_fd_pr__model__cap_mim
C$1707 \$532 TOP_P|VINP 8.664e-15 sky130_fd_pr__model__cap_mim
* device instance $1708 r0 *1 142.8,30.95 sky130_fd_pr__model__cap_mim
C$1708 \$533 TOP_P|VINP 8.664e-15 sky130_fd_pr__model__cap_mim
* device instance $1709 r0 *1 146.2,30.95 sky130_fd_pr__model__cap_mim
C$1709 \$532 TOP_P|VINP 8.664e-15 sky130_fd_pr__model__cap_mim
* device instance $1710 r0 *1 149.6,30.95 sky130_fd_pr__model__cap_mim
C$1710 \$534 TOP_P|VINP 8.664e-15 sky130_fd_pr__model__cap_mim
* device instance $1711 r0 *1 153,30.95 sky130_fd_pr__model__cap_mim
C$1711 \$532 TOP_P|VINP 8.664e-15 sky130_fd_pr__model__cap_mim
* device instance $1712 r0 *1 156.4,30.95 sky130_fd_pr__model__cap_mim
C$1712 \$533 TOP_P|VINP 8.664e-15 sky130_fd_pr__model__cap_mim
* device instance $1713 r0 *1 159.8,30.95 sky130_fd_pr__model__cap_mim
C$1713 \$532 TOP_P|VINP 8.664e-15 sky130_fd_pr__model__cap_mim
* device instance $1714 r0 *1 163.2,30.95 sky130_fd_pr__model__cap_mim
C$1714 \$520 TOP_P|VINP 8.664e-15 sky130_fd_pr__model__cap_mim
* device instance $1715 r0 *1 166.6,30.95 sky130_fd_pr__model__cap_mim
C$1715 \$532 TOP_P|VINP 8.664e-15 sky130_fd_pr__model__cap_mim
* device instance $1716 r0 *1 170,30.95 sky130_fd_pr__model__cap_mim
C$1716 \$533 TOP_P|VINP 8.664e-15 sky130_fd_pr__model__cap_mim
* device instance $1717 r0 *1 173.4,30.95 sky130_fd_pr__model__cap_mim
C$1717 \$532 TOP_P|VINP 8.664e-15 sky130_fd_pr__model__cap_mim
* device instance $1718 r0 *1 176.8,30.95 sky130_fd_pr__model__cap_mim
C$1718 \$534 TOP_P|VINP 8.664e-15 sky130_fd_pr__model__cap_mim
* device instance $1719 r0 *1 180.2,30.95 sky130_fd_pr__model__cap_mim
C$1719 \$532 TOP_P|VINP 8.664e-15 sky130_fd_pr__model__cap_mim
* device instance $1720 r0 *1 183.6,30.95 sky130_fd_pr__model__cap_mim
C$1720 \$533 TOP_P|VINP 8.664e-15 sky130_fd_pr__model__cap_mim
* device instance $1721 r0 *1 187,30.95 sky130_fd_pr__model__cap_mim
C$1721 \$532 TOP_P|VINP 8.664e-15 sky130_fd_pr__model__cap_mim
* device instance $1722 r0 *1 190.4,30.95 sky130_fd_pr__model__cap_mim
C$1722 \$521 TOP_P|VINP 8.664e-15 sky130_fd_pr__model__cap_mim
* device instance $1723 r0 *1 193.8,30.95 sky130_fd_pr__model__cap_mim
C$1723 \$532 TOP_P|VINP 8.664e-15 sky130_fd_pr__model__cap_mim
* device instance $1724 r0 *1 197.2,30.95 sky130_fd_pr__model__cap_mim
C$1724 \$533 TOP_P|VINP 8.664e-15 sky130_fd_pr__model__cap_mim
* device instance $1725 r0 *1 200.6,30.95 sky130_fd_pr__model__cap_mim
C$1725 \$532 TOP_P|VINP 8.664e-15 sky130_fd_pr__model__cap_mim
* device instance $1726 r0 *1 204,30.95 sky130_fd_pr__model__cap_mim
C$1726 \$534 TOP_P|VINP 8.664e-15 sky130_fd_pr__model__cap_mim
* device instance $1727 r0 *1 207.4,30.95 sky130_fd_pr__model__cap_mim
C$1727 \$532 TOP_P|VINP 8.664e-15 sky130_fd_pr__model__cap_mim
* device instance $1728 r0 *1 210.8,30.95 sky130_fd_pr__model__cap_mim
C$1728 \$533 TOP_P|VINP 8.664e-15 sky130_fd_pr__model__cap_mim
* device instance $1729 r0 *1 214.2,30.95 sky130_fd_pr__model__cap_mim
C$1729 \$532 TOP_P|VINP 8.664e-15 sky130_fd_pr__model__cap_mim
* device instance $1730 r0 *1 0,34.35 sky130_fd_pr__model__cap_mim
C$1730 \$528 TOP_N|VINN 8.664e-15 sky130_fd_pr__model__cap_mim
* device instance $1731 r0 *1 3.4,34.35 sky130_fd_pr__model__cap_mim
C$1731 \$529 TOP_N|VINN 8.664e-15 sky130_fd_pr__model__cap_mim
* device instance $1732 r0 *1 6.8,34.35 sky130_fd_pr__model__cap_mim
C$1732 \$528 TOP_N|VINN 8.664e-15 sky130_fd_pr__model__cap_mim
* device instance $1733 r0 *1 10.2,34.35 sky130_fd_pr__model__cap_mim
C$1733 \$530 TOP_N|VINN 8.664e-15 sky130_fd_pr__model__cap_mim
* device instance $1734 r0 *1 13.6,34.35 sky130_fd_pr__model__cap_mim
C$1734 \$528 TOP_N|VINN 8.664e-15 sky130_fd_pr__model__cap_mim
* device instance $1735 r0 *1 17,34.35 sky130_fd_pr__model__cap_mim
C$1735 \$529 TOP_N|VINN 8.664e-15 sky130_fd_pr__model__cap_mim
* device instance $1736 r0 *1 20.4,34.35 sky130_fd_pr__model__cap_mim
C$1736 \$528 TOP_N|VINN 8.664e-15 sky130_fd_pr__model__cap_mim
* device instance $1737 r0 *1 23.8,34.35 sky130_fd_pr__model__cap_mim
C$1737 \$531 TOP_N|VINN 8.664e-15 sky130_fd_pr__model__cap_mim
* device instance $1738 r0 *1 27.2,34.35 sky130_fd_pr__model__cap_mim
C$1738 \$528 TOP_N|VINN 8.664e-15 sky130_fd_pr__model__cap_mim
* device instance $1739 r0 *1 30.6,34.35 sky130_fd_pr__model__cap_mim
C$1739 \$529 TOP_N|VINN 8.664e-15 sky130_fd_pr__model__cap_mim
* device instance $1740 r0 *1 34,34.35 sky130_fd_pr__model__cap_mim
C$1740 \$528 TOP_N|VINN 8.664e-15 sky130_fd_pr__model__cap_mim
* device instance $1741 r0 *1 37.4,34.35 sky130_fd_pr__model__cap_mim
C$1741 \$530 TOP_N|VINN 8.664e-15 sky130_fd_pr__model__cap_mim
* device instance $1742 r0 *1 40.8,34.35 sky130_fd_pr__model__cap_mim
C$1742 \$528 TOP_N|VINN 8.664e-15 sky130_fd_pr__model__cap_mim
* device instance $1743 r0 *1 44.2,34.35 sky130_fd_pr__model__cap_mim
C$1743 \$529 TOP_N|VINN 8.664e-15 sky130_fd_pr__model__cap_mim
* device instance $1744 r0 *1 47.6,34.35 sky130_fd_pr__model__cap_mim
C$1744 \$528 TOP_N|VINN 8.664e-15 sky130_fd_pr__model__cap_mim
* device instance $1745 r0 *1 51,34.35 sky130_fd_pr__model__cap_mim
C$1745 \$526 TOP_N|VINN 8.664e-15 sky130_fd_pr__model__cap_mim
* device instance $1746 r0 *1 54.4,34.35 sky130_fd_pr__model__cap_mim
C$1746 \$528 TOP_N|VINN 8.664e-15 sky130_fd_pr__model__cap_mim
* device instance $1747 r0 *1 57.8,34.35 sky130_fd_pr__model__cap_mim
C$1747 \$529 TOP_N|VINN 8.664e-15 sky130_fd_pr__model__cap_mim
* device instance $1748 r0 *1 61.2,34.35 sky130_fd_pr__model__cap_mim
C$1748 \$528 TOP_N|VINN 8.664e-15 sky130_fd_pr__model__cap_mim
* device instance $1749 r0 *1 64.6,34.35 sky130_fd_pr__model__cap_mim
C$1749 \$530 TOP_N|VINN 8.664e-15 sky130_fd_pr__model__cap_mim
* device instance $1750 r0 *1 68,34.35 sky130_fd_pr__model__cap_mim
C$1750 \$528 TOP_N|VINN 8.664e-15 sky130_fd_pr__model__cap_mim
* device instance $1751 r0 *1 71.4,34.35 sky130_fd_pr__model__cap_mim
C$1751 \$529 TOP_N|VINN 8.664e-15 sky130_fd_pr__model__cap_mim
* device instance $1752 r0 *1 74.8,34.35 sky130_fd_pr__model__cap_mim
C$1752 \$528 TOP_N|VINN 8.664e-15 sky130_fd_pr__model__cap_mim
* device instance $1753 r0 *1 78.2,34.35 sky130_fd_pr__model__cap_mim
C$1753 \$531 TOP_N|VINN 8.664e-15 sky130_fd_pr__model__cap_mim
* device instance $1754 r0 *1 81.6,34.35 sky130_fd_pr__model__cap_mim
C$1754 \$528 TOP_N|VINN 8.664e-15 sky130_fd_pr__model__cap_mim
* device instance $1755 r0 *1 85,34.35 sky130_fd_pr__model__cap_mim
C$1755 \$529 TOP_N|VINN 8.664e-15 sky130_fd_pr__model__cap_mim
* device instance $1756 r0 *1 88.4,34.35 sky130_fd_pr__model__cap_mim
C$1756 \$528 TOP_N|VINN 8.664e-15 sky130_fd_pr__model__cap_mim
* device instance $1757 r0 *1 91.8,34.35 sky130_fd_pr__model__cap_mim
C$1757 \$530 TOP_N|VINN 8.664e-15 sky130_fd_pr__model__cap_mim
* device instance $1758 r0 *1 95.2,34.35 sky130_fd_pr__model__cap_mim
C$1758 \$528 TOP_N|VINN 8.664e-15 sky130_fd_pr__model__cap_mim
* device instance $1759 r0 *1 98.6,34.35 sky130_fd_pr__model__cap_mim
C$1759 \$529 TOP_N|VINN 8.664e-15 sky130_fd_pr__model__cap_mim
* device instance $1760 r0 *1 102,34.35 sky130_fd_pr__model__cap_mim
C$1760 \$528 TOP_N|VINN 8.664e-15 sky130_fd_pr__model__cap_mim
* device instance $1761 r0 *1 105.4,34.35 sky130_fd_pr__model__cap_mim
C$1761 \$525 TOP_N|VINN 8.664e-15 sky130_fd_pr__model__cap_mim
* device instance $1762 r0 *1 108.8,34.35 sky130_fd_pr__model__cap_mim
C$1762 \$523 TOP_N|VINN 8.664e-15 sky130_fd_pr__model__cap_mim
* device instance $1763 r0 *1 112.2,34.35 sky130_fd_pr__model__cap_mim
C$1763 \$528 TOP_N|VINN 8.664e-15 sky130_fd_pr__model__cap_mim
* device instance $1764 r0 *1 115.6,34.35 sky130_fd_pr__model__cap_mim
C$1764 \$529 TOP_N|VINN 8.664e-15 sky130_fd_pr__model__cap_mim
* device instance $1765 r0 *1 119,34.35 sky130_fd_pr__model__cap_mim
C$1765 \$528 TOP_N|VINN 8.664e-15 sky130_fd_pr__model__cap_mim
* device instance $1766 r0 *1 122.4,34.35 sky130_fd_pr__model__cap_mim
C$1766 \$530 TOP_N|VINN 8.664e-15 sky130_fd_pr__model__cap_mim
* device instance $1767 r0 *1 125.8,34.35 sky130_fd_pr__model__cap_mim
C$1767 \$528 TOP_N|VINN 8.664e-15 sky130_fd_pr__model__cap_mim
* device instance $1768 r0 *1 129.2,34.35 sky130_fd_pr__model__cap_mim
C$1768 \$529 TOP_N|VINN 8.664e-15 sky130_fd_pr__model__cap_mim
* device instance $1769 r0 *1 132.6,34.35 sky130_fd_pr__model__cap_mim
C$1769 \$528 TOP_N|VINN 8.664e-15 sky130_fd_pr__model__cap_mim
* device instance $1770 r0 *1 136,34.35 sky130_fd_pr__model__cap_mim
C$1770 \$531 TOP_N|VINN 8.664e-15 sky130_fd_pr__model__cap_mim
* device instance $1771 r0 *1 139.4,34.35 sky130_fd_pr__model__cap_mim
C$1771 \$528 TOP_N|VINN 8.664e-15 sky130_fd_pr__model__cap_mim
* device instance $1772 r0 *1 142.8,34.35 sky130_fd_pr__model__cap_mim
C$1772 \$529 TOP_N|VINN 8.664e-15 sky130_fd_pr__model__cap_mim
* device instance $1773 r0 *1 146.2,34.35 sky130_fd_pr__model__cap_mim
C$1773 \$528 TOP_N|VINN 8.664e-15 sky130_fd_pr__model__cap_mim
* device instance $1774 r0 *1 149.6,34.35 sky130_fd_pr__model__cap_mim
C$1774 \$530 TOP_N|VINN 8.664e-15 sky130_fd_pr__model__cap_mim
* device instance $1775 r0 *1 153,34.35 sky130_fd_pr__model__cap_mim
C$1775 \$528 TOP_N|VINN 8.664e-15 sky130_fd_pr__model__cap_mim
* device instance $1776 r0 *1 156.4,34.35 sky130_fd_pr__model__cap_mim
C$1776 \$529 TOP_N|VINN 8.664e-15 sky130_fd_pr__model__cap_mim
* device instance $1777 r0 *1 159.8,34.35 sky130_fd_pr__model__cap_mim
C$1777 \$528 TOP_N|VINN 8.664e-15 sky130_fd_pr__model__cap_mim
* device instance $1778 r0 *1 163.2,34.35 sky130_fd_pr__model__cap_mim
C$1778 \$526 TOP_N|VINN 8.664e-15 sky130_fd_pr__model__cap_mim
* device instance $1779 r0 *1 166.6,34.35 sky130_fd_pr__model__cap_mim
C$1779 \$528 TOP_N|VINN 8.664e-15 sky130_fd_pr__model__cap_mim
* device instance $1780 r0 *1 170,34.35 sky130_fd_pr__model__cap_mim
C$1780 \$529 TOP_N|VINN 8.664e-15 sky130_fd_pr__model__cap_mim
* device instance $1781 r0 *1 173.4,34.35 sky130_fd_pr__model__cap_mim
C$1781 \$528 TOP_N|VINN 8.664e-15 sky130_fd_pr__model__cap_mim
* device instance $1782 r0 *1 176.8,34.35 sky130_fd_pr__model__cap_mim
C$1782 \$530 TOP_N|VINN 8.664e-15 sky130_fd_pr__model__cap_mim
* device instance $1783 r0 *1 180.2,34.35 sky130_fd_pr__model__cap_mim
C$1783 \$528 TOP_N|VINN 8.664e-15 sky130_fd_pr__model__cap_mim
* device instance $1784 r0 *1 183.6,34.35 sky130_fd_pr__model__cap_mim
C$1784 \$529 TOP_N|VINN 8.664e-15 sky130_fd_pr__model__cap_mim
* device instance $1785 r0 *1 187,34.35 sky130_fd_pr__model__cap_mim
C$1785 \$528 TOP_N|VINN 8.664e-15 sky130_fd_pr__model__cap_mim
* device instance $1786 r0 *1 190.4,34.35 sky130_fd_pr__model__cap_mim
C$1786 \$531 TOP_N|VINN 8.664e-15 sky130_fd_pr__model__cap_mim
* device instance $1787 r0 *1 193.8,34.35 sky130_fd_pr__model__cap_mim
C$1787 \$528 TOP_N|VINN 8.664e-15 sky130_fd_pr__model__cap_mim
* device instance $1788 r0 *1 197.2,34.35 sky130_fd_pr__model__cap_mim
C$1788 \$529 TOP_N|VINN 8.664e-15 sky130_fd_pr__model__cap_mim
* device instance $1789 r0 *1 200.6,34.35 sky130_fd_pr__model__cap_mim
C$1789 \$528 TOP_N|VINN 8.664e-15 sky130_fd_pr__model__cap_mim
* device instance $1790 r0 *1 204,34.35 sky130_fd_pr__model__cap_mim
C$1790 \$530 TOP_N|VINN 8.664e-15 sky130_fd_pr__model__cap_mim
* device instance $1791 r0 *1 207.4,34.35 sky130_fd_pr__model__cap_mim
C$1791 \$528 TOP_N|VINN 8.664e-15 sky130_fd_pr__model__cap_mim
* device instance $1792 r0 *1 210.8,34.35 sky130_fd_pr__model__cap_mim
C$1792 \$529 TOP_N|VINN 8.664e-15 sky130_fd_pr__model__cap_mim
* device instance $1793 r0 *1 214.2,34.35 sky130_fd_pr__model__cap_mim
C$1793 \$528 TOP_N|VINN 8.664e-15 sky130_fd_pr__model__cap_mim
* device instance $1794 r0 *1 0,37.75 sky130_fd_pr__model__cap_mim
C$1794 \$532 TOP_P|VINP 8.664e-15 sky130_fd_pr__model__cap_mim
* device instance $1795 r0 *1 3.4,37.75 sky130_fd_pr__model__cap_mim
C$1795 \$533 TOP_P|VINP 8.664e-15 sky130_fd_pr__model__cap_mim
* device instance $1796 r0 *1 6.8,37.75 sky130_fd_pr__model__cap_mim
C$1796 \$532 TOP_P|VINP 8.664e-15 sky130_fd_pr__model__cap_mim
* device instance $1797 r0 *1 10.2,37.75 sky130_fd_pr__model__cap_mim
C$1797 \$534 TOP_P|VINP 8.664e-15 sky130_fd_pr__model__cap_mim
* device instance $1798 r0 *1 13.6,37.75 sky130_fd_pr__model__cap_mim
C$1798 \$532 TOP_P|VINP 8.664e-15 sky130_fd_pr__model__cap_mim
* device instance $1799 r0 *1 17,37.75 sky130_fd_pr__model__cap_mim
C$1799 \$533 TOP_P|VINP 8.664e-15 sky130_fd_pr__model__cap_mim
* device instance $1800 r0 *1 20.4,37.75 sky130_fd_pr__model__cap_mim
C$1800 \$532 TOP_P|VINP 8.664e-15 sky130_fd_pr__model__cap_mim
* device instance $1801 r0 *1 23.8,37.75 sky130_fd_pr__model__cap_mim
C$1801 \$521 TOP_P|VINP 8.664e-15 sky130_fd_pr__model__cap_mim
* device instance $1802 r0 *1 27.2,37.75 sky130_fd_pr__model__cap_mim
C$1802 \$532 TOP_P|VINP 8.664e-15 sky130_fd_pr__model__cap_mim
* device instance $1803 r0 *1 30.6,37.75 sky130_fd_pr__model__cap_mim
C$1803 \$533 TOP_P|VINP 8.664e-15 sky130_fd_pr__model__cap_mim
* device instance $1804 r0 *1 34,37.75 sky130_fd_pr__model__cap_mim
C$1804 \$532 TOP_P|VINP 8.664e-15 sky130_fd_pr__model__cap_mim
* device instance $1805 r0 *1 37.4,37.75 sky130_fd_pr__model__cap_mim
C$1805 \$534 TOP_P|VINP 8.664e-15 sky130_fd_pr__model__cap_mim
* device instance $1806 r0 *1 40.8,37.75 sky130_fd_pr__model__cap_mim
C$1806 \$532 TOP_P|VINP 8.664e-15 sky130_fd_pr__model__cap_mim
* device instance $1807 r0 *1 44.2,37.75 sky130_fd_pr__model__cap_mim
C$1807 \$533 TOP_P|VINP 8.664e-15 sky130_fd_pr__model__cap_mim
* device instance $1808 r0 *1 47.6,37.75 sky130_fd_pr__model__cap_mim
C$1808 \$532 TOP_P|VINP 8.664e-15 sky130_fd_pr__model__cap_mim
* device instance $1809 r0 *1 51,37.75 sky130_fd_pr__model__cap_mim
C$1809 \$520 TOP_P|VINP 8.664e-15 sky130_fd_pr__model__cap_mim
* device instance $1810 r0 *1 54.4,37.75 sky130_fd_pr__model__cap_mim
C$1810 \$532 TOP_P|VINP 8.664e-15 sky130_fd_pr__model__cap_mim
* device instance $1811 r0 *1 57.8,37.75 sky130_fd_pr__model__cap_mim
C$1811 \$533 TOP_P|VINP 8.664e-15 sky130_fd_pr__model__cap_mim
* device instance $1812 r0 *1 61.2,37.75 sky130_fd_pr__model__cap_mim
C$1812 \$532 TOP_P|VINP 8.664e-15 sky130_fd_pr__model__cap_mim
* device instance $1813 r0 *1 64.6,37.75 sky130_fd_pr__model__cap_mim
C$1813 \$534 TOP_P|VINP 8.664e-15 sky130_fd_pr__model__cap_mim
* device instance $1814 r0 *1 68,37.75 sky130_fd_pr__model__cap_mim
C$1814 \$532 TOP_P|VINP 8.664e-15 sky130_fd_pr__model__cap_mim
* device instance $1815 r0 *1 71.4,37.75 sky130_fd_pr__model__cap_mim
C$1815 \$533 TOP_P|VINP 8.664e-15 sky130_fd_pr__model__cap_mim
* device instance $1816 r0 *1 74.8,37.75 sky130_fd_pr__model__cap_mim
C$1816 \$532 TOP_P|VINP 8.664e-15 sky130_fd_pr__model__cap_mim
* device instance $1817 r0 *1 78.2,37.75 sky130_fd_pr__model__cap_mim
C$1817 \$521 TOP_P|VINP 8.664e-15 sky130_fd_pr__model__cap_mim
* device instance $1818 r0 *1 81.6,37.75 sky130_fd_pr__model__cap_mim
C$1818 \$532 TOP_P|VINP 8.664e-15 sky130_fd_pr__model__cap_mim
* device instance $1819 r0 *1 85,37.75 sky130_fd_pr__model__cap_mim
C$1819 \$533 TOP_P|VINP 8.664e-15 sky130_fd_pr__model__cap_mim
* device instance $1820 r0 *1 88.4,37.75 sky130_fd_pr__model__cap_mim
C$1820 \$532 TOP_P|VINP 8.664e-15 sky130_fd_pr__model__cap_mim
* device instance $1821 r0 *1 91.8,37.75 sky130_fd_pr__model__cap_mim
C$1821 \$534 TOP_P|VINP 8.664e-15 sky130_fd_pr__model__cap_mim
* device instance $1822 r0 *1 95.2,37.75 sky130_fd_pr__model__cap_mim
C$1822 \$532 TOP_P|VINP 8.664e-15 sky130_fd_pr__model__cap_mim
* device instance $1823 r0 *1 98.6,37.75 sky130_fd_pr__model__cap_mim
C$1823 \$533 TOP_P|VINP 8.664e-15 sky130_fd_pr__model__cap_mim
* device instance $1824 r0 *1 102,37.75 sky130_fd_pr__model__cap_mim
C$1824 \$532 TOP_P|VINP 8.664e-15 sky130_fd_pr__model__cap_mim
* device instance $1825 r0 *1 105.4,37.75 sky130_fd_pr__model__cap_mim
C$1825 \$519 TOP_P|VINP 8.664e-15 sky130_fd_pr__model__cap_mim
* device instance $1826 r0 *1 108.8,37.75 sky130_fd_pr__model__cap_mim
C$1826 \$517 TOP_P|VINP 8.664e-15 sky130_fd_pr__model__cap_mim
* device instance $1827 r0 *1 112.2,37.75 sky130_fd_pr__model__cap_mim
C$1827 \$532 TOP_P|VINP 8.664e-15 sky130_fd_pr__model__cap_mim
* device instance $1828 r0 *1 115.6,37.75 sky130_fd_pr__model__cap_mim
C$1828 \$533 TOP_P|VINP 8.664e-15 sky130_fd_pr__model__cap_mim
* device instance $1829 r0 *1 119,37.75 sky130_fd_pr__model__cap_mim
C$1829 \$532 TOP_P|VINP 8.664e-15 sky130_fd_pr__model__cap_mim
* device instance $1830 r0 *1 122.4,37.75 sky130_fd_pr__model__cap_mim
C$1830 \$534 TOP_P|VINP 8.664e-15 sky130_fd_pr__model__cap_mim
* device instance $1831 r0 *1 125.8,37.75 sky130_fd_pr__model__cap_mim
C$1831 \$532 TOP_P|VINP 8.664e-15 sky130_fd_pr__model__cap_mim
* device instance $1832 r0 *1 129.2,37.75 sky130_fd_pr__model__cap_mim
C$1832 \$533 TOP_P|VINP 8.664e-15 sky130_fd_pr__model__cap_mim
* device instance $1833 r0 *1 132.6,37.75 sky130_fd_pr__model__cap_mim
C$1833 \$532 TOP_P|VINP 8.664e-15 sky130_fd_pr__model__cap_mim
* device instance $1834 r0 *1 136,37.75 sky130_fd_pr__model__cap_mim
C$1834 \$521 TOP_P|VINP 8.664e-15 sky130_fd_pr__model__cap_mim
* device instance $1835 r0 *1 139.4,37.75 sky130_fd_pr__model__cap_mim
C$1835 \$532 TOP_P|VINP 8.664e-15 sky130_fd_pr__model__cap_mim
* device instance $1836 r0 *1 142.8,37.75 sky130_fd_pr__model__cap_mim
C$1836 \$533 TOP_P|VINP 8.664e-15 sky130_fd_pr__model__cap_mim
* device instance $1837 r0 *1 146.2,37.75 sky130_fd_pr__model__cap_mim
C$1837 \$532 TOP_P|VINP 8.664e-15 sky130_fd_pr__model__cap_mim
* device instance $1838 r0 *1 149.6,37.75 sky130_fd_pr__model__cap_mim
C$1838 \$534 TOP_P|VINP 8.664e-15 sky130_fd_pr__model__cap_mim
* device instance $1839 r0 *1 153,37.75 sky130_fd_pr__model__cap_mim
C$1839 \$532 TOP_P|VINP 8.664e-15 sky130_fd_pr__model__cap_mim
* device instance $1840 r0 *1 156.4,37.75 sky130_fd_pr__model__cap_mim
C$1840 \$533 TOP_P|VINP 8.664e-15 sky130_fd_pr__model__cap_mim
* device instance $1841 r0 *1 159.8,37.75 sky130_fd_pr__model__cap_mim
C$1841 \$532 TOP_P|VINP 8.664e-15 sky130_fd_pr__model__cap_mim
* device instance $1842 r0 *1 163.2,37.75 sky130_fd_pr__model__cap_mim
C$1842 \$520 TOP_P|VINP 8.664e-15 sky130_fd_pr__model__cap_mim
* device instance $1843 r0 *1 166.6,37.75 sky130_fd_pr__model__cap_mim
C$1843 \$532 TOP_P|VINP 8.664e-15 sky130_fd_pr__model__cap_mim
* device instance $1844 r0 *1 170,37.75 sky130_fd_pr__model__cap_mim
C$1844 \$533 TOP_P|VINP 8.664e-15 sky130_fd_pr__model__cap_mim
* device instance $1845 r0 *1 173.4,37.75 sky130_fd_pr__model__cap_mim
C$1845 \$532 TOP_P|VINP 8.664e-15 sky130_fd_pr__model__cap_mim
* device instance $1846 r0 *1 176.8,37.75 sky130_fd_pr__model__cap_mim
C$1846 \$534 TOP_P|VINP 8.664e-15 sky130_fd_pr__model__cap_mim
* device instance $1847 r0 *1 180.2,37.75 sky130_fd_pr__model__cap_mim
C$1847 \$532 TOP_P|VINP 8.664e-15 sky130_fd_pr__model__cap_mim
* device instance $1848 r0 *1 183.6,37.75 sky130_fd_pr__model__cap_mim
C$1848 \$533 TOP_P|VINP 8.664e-15 sky130_fd_pr__model__cap_mim
* device instance $1849 r0 *1 187,37.75 sky130_fd_pr__model__cap_mim
C$1849 \$532 TOP_P|VINP 8.664e-15 sky130_fd_pr__model__cap_mim
* device instance $1850 r0 *1 190.4,37.75 sky130_fd_pr__model__cap_mim
C$1850 \$521 TOP_P|VINP 8.664e-15 sky130_fd_pr__model__cap_mim
* device instance $1851 r0 *1 193.8,37.75 sky130_fd_pr__model__cap_mim
C$1851 \$532 TOP_P|VINP 8.664e-15 sky130_fd_pr__model__cap_mim
* device instance $1852 r0 *1 197.2,37.75 sky130_fd_pr__model__cap_mim
C$1852 \$533 TOP_P|VINP 8.664e-15 sky130_fd_pr__model__cap_mim
* device instance $1853 r0 *1 200.6,37.75 sky130_fd_pr__model__cap_mim
C$1853 \$532 TOP_P|VINP 8.664e-15 sky130_fd_pr__model__cap_mim
* device instance $1854 r0 *1 204,37.75 sky130_fd_pr__model__cap_mim
C$1854 \$534 TOP_P|VINP 8.664e-15 sky130_fd_pr__model__cap_mim
* device instance $1855 r0 *1 207.4,37.75 sky130_fd_pr__model__cap_mim
C$1855 \$532 TOP_P|VINP 8.664e-15 sky130_fd_pr__model__cap_mim
* device instance $1856 r0 *1 210.8,37.75 sky130_fd_pr__model__cap_mim
C$1856 \$533 TOP_P|VINP 8.664e-15 sky130_fd_pr__model__cap_mim
* device instance $1857 r0 *1 214.2,37.75 sky130_fd_pr__model__cap_mim
C$1857 \$532 TOP_P|VINP 8.664e-15 sky130_fd_pr__model__cap_mim
* device instance $1858 r0 *1 0,41.15 sky130_fd_pr__model__cap_mim
C$1858 \$528 TOP_N|VINN 8.664e-15 sky130_fd_pr__model__cap_mim
* device instance $1859 r0 *1 3.4,41.15 sky130_fd_pr__model__cap_mim
C$1859 \$529 TOP_N|VINN 8.664e-15 sky130_fd_pr__model__cap_mim
* device instance $1860 r0 *1 6.8,41.15 sky130_fd_pr__model__cap_mim
C$1860 \$528 TOP_N|VINN 8.664e-15 sky130_fd_pr__model__cap_mim
* device instance $1861 r0 *1 10.2,41.15 sky130_fd_pr__model__cap_mim
C$1861 \$530 TOP_N|VINN 8.664e-15 sky130_fd_pr__model__cap_mim
* device instance $1862 r0 *1 13.6,41.15 sky130_fd_pr__model__cap_mim
C$1862 \$528 TOP_N|VINN 8.664e-15 sky130_fd_pr__model__cap_mim
* device instance $1863 r0 *1 17,41.15 sky130_fd_pr__model__cap_mim
C$1863 \$529 TOP_N|VINN 8.664e-15 sky130_fd_pr__model__cap_mim
* device instance $1864 r0 *1 20.4,41.15 sky130_fd_pr__model__cap_mim
C$1864 \$528 TOP_N|VINN 8.664e-15 sky130_fd_pr__model__cap_mim
* device instance $1865 r0 *1 23.8,41.15 sky130_fd_pr__model__cap_mim
C$1865 \$531 TOP_N|VINN 8.664e-15 sky130_fd_pr__model__cap_mim
* device instance $1866 r0 *1 27.2,41.15 sky130_fd_pr__model__cap_mim
C$1866 \$528 TOP_N|VINN 8.664e-15 sky130_fd_pr__model__cap_mim
* device instance $1867 r0 *1 30.6,41.15 sky130_fd_pr__model__cap_mim
C$1867 \$529 TOP_N|VINN 8.664e-15 sky130_fd_pr__model__cap_mim
* device instance $1868 r0 *1 34,41.15 sky130_fd_pr__model__cap_mim
C$1868 \$528 TOP_N|VINN 8.664e-15 sky130_fd_pr__model__cap_mim
* device instance $1869 r0 *1 37.4,41.15 sky130_fd_pr__model__cap_mim
C$1869 \$530 TOP_N|VINN 8.664e-15 sky130_fd_pr__model__cap_mim
* device instance $1870 r0 *1 40.8,41.15 sky130_fd_pr__model__cap_mim
C$1870 \$528 TOP_N|VINN 8.664e-15 sky130_fd_pr__model__cap_mim
* device instance $1871 r0 *1 44.2,41.15 sky130_fd_pr__model__cap_mim
C$1871 \$529 TOP_N|VINN 8.664e-15 sky130_fd_pr__model__cap_mim
* device instance $1872 r0 *1 47.6,41.15 sky130_fd_pr__model__cap_mim
C$1872 \$528 TOP_N|VINN 8.664e-15 sky130_fd_pr__model__cap_mim
* device instance $1873 r0 *1 51,41.15 sky130_fd_pr__model__cap_mim
C$1873 \$526 TOP_N|VINN 8.664e-15 sky130_fd_pr__model__cap_mim
* device instance $1874 r0 *1 54.4,41.15 sky130_fd_pr__model__cap_mim
C$1874 \$528 TOP_N|VINN 8.664e-15 sky130_fd_pr__model__cap_mim
* device instance $1875 r0 *1 57.8,41.15 sky130_fd_pr__model__cap_mim
C$1875 \$529 TOP_N|VINN 8.664e-15 sky130_fd_pr__model__cap_mim
* device instance $1876 r0 *1 61.2,41.15 sky130_fd_pr__model__cap_mim
C$1876 \$528 TOP_N|VINN 8.664e-15 sky130_fd_pr__model__cap_mim
* device instance $1877 r0 *1 64.6,41.15 sky130_fd_pr__model__cap_mim
C$1877 \$530 TOP_N|VINN 8.664e-15 sky130_fd_pr__model__cap_mim
* device instance $1878 r0 *1 68,41.15 sky130_fd_pr__model__cap_mim
C$1878 \$528 TOP_N|VINN 8.664e-15 sky130_fd_pr__model__cap_mim
* device instance $1879 r0 *1 71.4,41.15 sky130_fd_pr__model__cap_mim
C$1879 \$529 TOP_N|VINN 8.664e-15 sky130_fd_pr__model__cap_mim
* device instance $1880 r0 *1 74.8,41.15 sky130_fd_pr__model__cap_mim
C$1880 \$528 TOP_N|VINN 8.664e-15 sky130_fd_pr__model__cap_mim
* device instance $1881 r0 *1 78.2,41.15 sky130_fd_pr__model__cap_mim
C$1881 \$531 TOP_N|VINN 8.664e-15 sky130_fd_pr__model__cap_mim
* device instance $1882 r0 *1 81.6,41.15 sky130_fd_pr__model__cap_mim
C$1882 \$528 TOP_N|VINN 8.664e-15 sky130_fd_pr__model__cap_mim
* device instance $1883 r0 *1 85,41.15 sky130_fd_pr__model__cap_mim
C$1883 \$529 TOP_N|VINN 8.664e-15 sky130_fd_pr__model__cap_mim
* device instance $1884 r0 *1 88.4,41.15 sky130_fd_pr__model__cap_mim
C$1884 \$528 TOP_N|VINN 8.664e-15 sky130_fd_pr__model__cap_mim
* device instance $1885 r0 *1 91.8,41.15 sky130_fd_pr__model__cap_mim
C$1885 \$530 TOP_N|VINN 8.664e-15 sky130_fd_pr__model__cap_mim
* device instance $1886 r0 *1 95.2,41.15 sky130_fd_pr__model__cap_mim
C$1886 \$528 TOP_N|VINN 8.664e-15 sky130_fd_pr__model__cap_mim
* device instance $1887 r0 *1 98.6,41.15 sky130_fd_pr__model__cap_mim
C$1887 \$529 TOP_N|VINN 8.664e-15 sky130_fd_pr__model__cap_mim
* device instance $1888 r0 *1 102,41.15 sky130_fd_pr__model__cap_mim
C$1888 \$528 TOP_N|VINN 8.664e-15 sky130_fd_pr__model__cap_mim
* device instance $1889 r0 *1 105.4,41.15 sky130_fd_pr__model__cap_mim
C$1889 \$525 TOP_N|VINN 8.664e-15 sky130_fd_pr__model__cap_mim
* device instance $1890 r0 *1 108.8,41.15 sky130_fd_pr__model__cap_mim
C$1890 \$524 TOP_N|VINN 8.664e-15 sky130_fd_pr__model__cap_mim
* device instance $1891 r0 *1 112.2,41.15 sky130_fd_pr__model__cap_mim
C$1891 \$528 TOP_N|VINN 8.664e-15 sky130_fd_pr__model__cap_mim
* device instance $1892 r0 *1 115.6,41.15 sky130_fd_pr__model__cap_mim
C$1892 \$529 TOP_N|VINN 8.664e-15 sky130_fd_pr__model__cap_mim
* device instance $1893 r0 *1 119,41.15 sky130_fd_pr__model__cap_mim
C$1893 \$528 TOP_N|VINN 8.664e-15 sky130_fd_pr__model__cap_mim
* device instance $1894 r0 *1 122.4,41.15 sky130_fd_pr__model__cap_mim
C$1894 \$530 TOP_N|VINN 8.664e-15 sky130_fd_pr__model__cap_mim
* device instance $1895 r0 *1 125.8,41.15 sky130_fd_pr__model__cap_mim
C$1895 \$528 TOP_N|VINN 8.664e-15 sky130_fd_pr__model__cap_mim
* device instance $1896 r0 *1 129.2,41.15 sky130_fd_pr__model__cap_mim
C$1896 \$529 TOP_N|VINN 8.664e-15 sky130_fd_pr__model__cap_mim
* device instance $1897 r0 *1 132.6,41.15 sky130_fd_pr__model__cap_mim
C$1897 \$528 TOP_N|VINN 8.664e-15 sky130_fd_pr__model__cap_mim
* device instance $1898 r0 *1 136,41.15 sky130_fd_pr__model__cap_mim
C$1898 \$531 TOP_N|VINN 8.664e-15 sky130_fd_pr__model__cap_mim
* device instance $1899 r0 *1 139.4,41.15 sky130_fd_pr__model__cap_mim
C$1899 \$528 TOP_N|VINN 8.664e-15 sky130_fd_pr__model__cap_mim
* device instance $1900 r0 *1 142.8,41.15 sky130_fd_pr__model__cap_mim
C$1900 \$529 TOP_N|VINN 8.664e-15 sky130_fd_pr__model__cap_mim
* device instance $1901 r0 *1 146.2,41.15 sky130_fd_pr__model__cap_mim
C$1901 \$528 TOP_N|VINN 8.664e-15 sky130_fd_pr__model__cap_mim
* device instance $1902 r0 *1 149.6,41.15 sky130_fd_pr__model__cap_mim
C$1902 \$530 TOP_N|VINN 8.664e-15 sky130_fd_pr__model__cap_mim
* device instance $1903 r0 *1 153,41.15 sky130_fd_pr__model__cap_mim
C$1903 \$528 TOP_N|VINN 8.664e-15 sky130_fd_pr__model__cap_mim
* device instance $1904 r0 *1 156.4,41.15 sky130_fd_pr__model__cap_mim
C$1904 \$529 TOP_N|VINN 8.664e-15 sky130_fd_pr__model__cap_mim
* device instance $1905 r0 *1 159.8,41.15 sky130_fd_pr__model__cap_mim
C$1905 \$528 TOP_N|VINN 8.664e-15 sky130_fd_pr__model__cap_mim
* device instance $1906 r0 *1 163.2,41.15 sky130_fd_pr__model__cap_mim
C$1906 \$526 TOP_N|VINN 8.664e-15 sky130_fd_pr__model__cap_mim
* device instance $1907 r0 *1 166.6,41.15 sky130_fd_pr__model__cap_mim
C$1907 \$528 TOP_N|VINN 8.664e-15 sky130_fd_pr__model__cap_mim
* device instance $1908 r0 *1 170,41.15 sky130_fd_pr__model__cap_mim
C$1908 \$529 TOP_N|VINN 8.664e-15 sky130_fd_pr__model__cap_mim
* device instance $1909 r0 *1 173.4,41.15 sky130_fd_pr__model__cap_mim
C$1909 \$528 TOP_N|VINN 8.664e-15 sky130_fd_pr__model__cap_mim
* device instance $1910 r0 *1 176.8,41.15 sky130_fd_pr__model__cap_mim
C$1910 \$530 TOP_N|VINN 8.664e-15 sky130_fd_pr__model__cap_mim
* device instance $1911 r0 *1 180.2,41.15 sky130_fd_pr__model__cap_mim
C$1911 \$528 TOP_N|VINN 8.664e-15 sky130_fd_pr__model__cap_mim
* device instance $1912 r0 *1 183.6,41.15 sky130_fd_pr__model__cap_mim
C$1912 \$529 TOP_N|VINN 8.664e-15 sky130_fd_pr__model__cap_mim
* device instance $1913 r0 *1 187,41.15 sky130_fd_pr__model__cap_mim
C$1913 \$528 TOP_N|VINN 8.664e-15 sky130_fd_pr__model__cap_mim
* device instance $1914 r0 *1 190.4,41.15 sky130_fd_pr__model__cap_mim
C$1914 \$531 TOP_N|VINN 8.664e-15 sky130_fd_pr__model__cap_mim
* device instance $1915 r0 *1 193.8,41.15 sky130_fd_pr__model__cap_mim
C$1915 \$528 TOP_N|VINN 8.664e-15 sky130_fd_pr__model__cap_mim
* device instance $1916 r0 *1 197.2,41.15 sky130_fd_pr__model__cap_mim
C$1916 \$529 TOP_N|VINN 8.664e-15 sky130_fd_pr__model__cap_mim
* device instance $1917 r0 *1 200.6,41.15 sky130_fd_pr__model__cap_mim
C$1917 \$528 TOP_N|VINN 8.664e-15 sky130_fd_pr__model__cap_mim
* device instance $1918 r0 *1 204,41.15 sky130_fd_pr__model__cap_mim
C$1918 \$530 TOP_N|VINN 8.664e-15 sky130_fd_pr__model__cap_mim
* device instance $1919 r0 *1 207.4,41.15 sky130_fd_pr__model__cap_mim
C$1919 \$528 TOP_N|VINN 8.664e-15 sky130_fd_pr__model__cap_mim
* device instance $1920 r0 *1 210.8,41.15 sky130_fd_pr__model__cap_mim
C$1920 \$529 TOP_N|VINN 8.664e-15 sky130_fd_pr__model__cap_mim
* device instance $1921 r0 *1 214.2,41.15 sky130_fd_pr__model__cap_mim
C$1921 \$528 TOP_N|VINN 8.664e-15 sky130_fd_pr__model__cap_mim
* device instance $1922 r0 *1 0,44.55 sky130_fd_pr__model__cap_mim
C$1922 \$532 TOP_P|VINP 8.664e-15 sky130_fd_pr__model__cap_mim
* device instance $1923 r0 *1 3.4,44.55 sky130_fd_pr__model__cap_mim
C$1923 \$533 TOP_P|VINP 8.664e-15 sky130_fd_pr__model__cap_mim
* device instance $1924 r0 *1 6.8,44.55 sky130_fd_pr__model__cap_mim
C$1924 \$532 TOP_P|VINP 8.664e-15 sky130_fd_pr__model__cap_mim
* device instance $1925 r0 *1 10.2,44.55 sky130_fd_pr__model__cap_mim
C$1925 \$534 TOP_P|VINP 8.664e-15 sky130_fd_pr__model__cap_mim
* device instance $1926 r0 *1 13.6,44.55 sky130_fd_pr__model__cap_mim
C$1926 \$532 TOP_P|VINP 8.664e-15 sky130_fd_pr__model__cap_mim
* device instance $1927 r0 *1 17,44.55 sky130_fd_pr__model__cap_mim
C$1927 \$533 TOP_P|VINP 8.664e-15 sky130_fd_pr__model__cap_mim
* device instance $1928 r0 *1 20.4,44.55 sky130_fd_pr__model__cap_mim
C$1928 \$532 TOP_P|VINP 8.664e-15 sky130_fd_pr__model__cap_mim
* device instance $1929 r0 *1 23.8,44.55 sky130_fd_pr__model__cap_mim
C$1929 \$521 TOP_P|VINP 8.664e-15 sky130_fd_pr__model__cap_mim
* device instance $1930 r0 *1 27.2,44.55 sky130_fd_pr__model__cap_mim
C$1930 \$532 TOP_P|VINP 8.664e-15 sky130_fd_pr__model__cap_mim
* device instance $1931 r0 *1 30.6,44.55 sky130_fd_pr__model__cap_mim
C$1931 \$533 TOP_P|VINP 8.664e-15 sky130_fd_pr__model__cap_mim
* device instance $1932 r0 *1 34,44.55 sky130_fd_pr__model__cap_mim
C$1932 \$532 TOP_P|VINP 8.664e-15 sky130_fd_pr__model__cap_mim
* device instance $1933 r0 *1 37.4,44.55 sky130_fd_pr__model__cap_mim
C$1933 \$534 TOP_P|VINP 8.664e-15 sky130_fd_pr__model__cap_mim
* device instance $1934 r0 *1 40.8,44.55 sky130_fd_pr__model__cap_mim
C$1934 \$532 TOP_P|VINP 8.664e-15 sky130_fd_pr__model__cap_mim
* device instance $1935 r0 *1 44.2,44.55 sky130_fd_pr__model__cap_mim
C$1935 \$533 TOP_P|VINP 8.664e-15 sky130_fd_pr__model__cap_mim
* device instance $1936 r0 *1 47.6,44.55 sky130_fd_pr__model__cap_mim
C$1936 \$532 TOP_P|VINP 8.664e-15 sky130_fd_pr__model__cap_mim
* device instance $1937 r0 *1 51,44.55 sky130_fd_pr__model__cap_mim
C$1937 \$520 TOP_P|VINP 8.664e-15 sky130_fd_pr__model__cap_mim
* device instance $1938 r0 *1 54.4,44.55 sky130_fd_pr__model__cap_mim
C$1938 \$532 TOP_P|VINP 8.664e-15 sky130_fd_pr__model__cap_mim
* device instance $1939 r0 *1 57.8,44.55 sky130_fd_pr__model__cap_mim
C$1939 \$533 TOP_P|VINP 8.664e-15 sky130_fd_pr__model__cap_mim
* device instance $1940 r0 *1 61.2,44.55 sky130_fd_pr__model__cap_mim
C$1940 \$532 TOP_P|VINP 8.664e-15 sky130_fd_pr__model__cap_mim
* device instance $1941 r0 *1 64.6,44.55 sky130_fd_pr__model__cap_mim
C$1941 \$534 TOP_P|VINP 8.664e-15 sky130_fd_pr__model__cap_mim
* device instance $1942 r0 *1 68,44.55 sky130_fd_pr__model__cap_mim
C$1942 \$532 TOP_P|VINP 8.664e-15 sky130_fd_pr__model__cap_mim
* device instance $1943 r0 *1 71.4,44.55 sky130_fd_pr__model__cap_mim
C$1943 \$533 TOP_P|VINP 8.664e-15 sky130_fd_pr__model__cap_mim
* device instance $1944 r0 *1 74.8,44.55 sky130_fd_pr__model__cap_mim
C$1944 \$532 TOP_P|VINP 8.664e-15 sky130_fd_pr__model__cap_mim
* device instance $1945 r0 *1 78.2,44.55 sky130_fd_pr__model__cap_mim
C$1945 \$521 TOP_P|VINP 8.664e-15 sky130_fd_pr__model__cap_mim
* device instance $1946 r0 *1 81.6,44.55 sky130_fd_pr__model__cap_mim
C$1946 \$532 TOP_P|VINP 8.664e-15 sky130_fd_pr__model__cap_mim
* device instance $1947 r0 *1 85,44.55 sky130_fd_pr__model__cap_mim
C$1947 \$533 TOP_P|VINP 8.664e-15 sky130_fd_pr__model__cap_mim
* device instance $1948 r0 *1 88.4,44.55 sky130_fd_pr__model__cap_mim
C$1948 \$532 TOP_P|VINP 8.664e-15 sky130_fd_pr__model__cap_mim
* device instance $1949 r0 *1 91.8,44.55 sky130_fd_pr__model__cap_mim
C$1949 \$534 TOP_P|VINP 8.664e-15 sky130_fd_pr__model__cap_mim
* device instance $1950 r0 *1 95.2,44.55 sky130_fd_pr__model__cap_mim
C$1950 \$532 TOP_P|VINP 8.664e-15 sky130_fd_pr__model__cap_mim
* device instance $1951 r0 *1 98.6,44.55 sky130_fd_pr__model__cap_mim
C$1951 \$533 TOP_P|VINP 8.664e-15 sky130_fd_pr__model__cap_mim
* device instance $1952 r0 *1 102,44.55 sky130_fd_pr__model__cap_mim
C$1952 \$532 TOP_P|VINP 8.664e-15 sky130_fd_pr__model__cap_mim
* device instance $1953 r0 *1 105.4,44.55 sky130_fd_pr__model__cap_mim
C$1953 \$519 TOP_P|VINP 8.664e-15 sky130_fd_pr__model__cap_mim
* device instance $1954 r0 *1 108.8,44.55 sky130_fd_pr__model__cap_mim
C$1954 \$518 TOP_P|VINP 8.664e-15 sky130_fd_pr__model__cap_mim
* device instance $1955 r0 *1 112.2,44.55 sky130_fd_pr__model__cap_mim
C$1955 \$532 TOP_P|VINP 8.664e-15 sky130_fd_pr__model__cap_mim
* device instance $1956 r0 *1 115.6,44.55 sky130_fd_pr__model__cap_mim
C$1956 \$533 TOP_P|VINP 8.664e-15 sky130_fd_pr__model__cap_mim
* device instance $1957 r0 *1 119,44.55 sky130_fd_pr__model__cap_mim
C$1957 \$532 TOP_P|VINP 8.664e-15 sky130_fd_pr__model__cap_mim
* device instance $1958 r0 *1 122.4,44.55 sky130_fd_pr__model__cap_mim
C$1958 \$534 TOP_P|VINP 8.664e-15 sky130_fd_pr__model__cap_mim
* device instance $1959 r0 *1 125.8,44.55 sky130_fd_pr__model__cap_mim
C$1959 \$532 TOP_P|VINP 8.664e-15 sky130_fd_pr__model__cap_mim
* device instance $1960 r0 *1 129.2,44.55 sky130_fd_pr__model__cap_mim
C$1960 \$533 TOP_P|VINP 8.664e-15 sky130_fd_pr__model__cap_mim
* device instance $1961 r0 *1 132.6,44.55 sky130_fd_pr__model__cap_mim
C$1961 \$532 TOP_P|VINP 8.664e-15 sky130_fd_pr__model__cap_mim
* device instance $1962 r0 *1 136,44.55 sky130_fd_pr__model__cap_mim
C$1962 \$521 TOP_P|VINP 8.664e-15 sky130_fd_pr__model__cap_mim
* device instance $1963 r0 *1 139.4,44.55 sky130_fd_pr__model__cap_mim
C$1963 \$532 TOP_P|VINP 8.664e-15 sky130_fd_pr__model__cap_mim
* device instance $1964 r0 *1 142.8,44.55 sky130_fd_pr__model__cap_mim
C$1964 \$533 TOP_P|VINP 8.664e-15 sky130_fd_pr__model__cap_mim
* device instance $1965 r0 *1 146.2,44.55 sky130_fd_pr__model__cap_mim
C$1965 \$532 TOP_P|VINP 8.664e-15 sky130_fd_pr__model__cap_mim
* device instance $1966 r0 *1 149.6,44.55 sky130_fd_pr__model__cap_mim
C$1966 \$534 TOP_P|VINP 8.664e-15 sky130_fd_pr__model__cap_mim
* device instance $1967 r0 *1 153,44.55 sky130_fd_pr__model__cap_mim
C$1967 \$532 TOP_P|VINP 8.664e-15 sky130_fd_pr__model__cap_mim
* device instance $1968 r0 *1 156.4,44.55 sky130_fd_pr__model__cap_mim
C$1968 \$533 TOP_P|VINP 8.664e-15 sky130_fd_pr__model__cap_mim
* device instance $1969 r0 *1 159.8,44.55 sky130_fd_pr__model__cap_mim
C$1969 \$532 TOP_P|VINP 8.664e-15 sky130_fd_pr__model__cap_mim
* device instance $1970 r0 *1 163.2,44.55 sky130_fd_pr__model__cap_mim
C$1970 \$520 TOP_P|VINP 8.664e-15 sky130_fd_pr__model__cap_mim
* device instance $1971 r0 *1 166.6,44.55 sky130_fd_pr__model__cap_mim
C$1971 \$532 TOP_P|VINP 8.664e-15 sky130_fd_pr__model__cap_mim
* device instance $1972 r0 *1 170,44.55 sky130_fd_pr__model__cap_mim
C$1972 \$533 TOP_P|VINP 8.664e-15 sky130_fd_pr__model__cap_mim
* device instance $1973 r0 *1 173.4,44.55 sky130_fd_pr__model__cap_mim
C$1973 \$532 TOP_P|VINP 8.664e-15 sky130_fd_pr__model__cap_mim
* device instance $1974 r0 *1 176.8,44.55 sky130_fd_pr__model__cap_mim
C$1974 \$534 TOP_P|VINP 8.664e-15 sky130_fd_pr__model__cap_mim
* device instance $1975 r0 *1 180.2,44.55 sky130_fd_pr__model__cap_mim
C$1975 \$532 TOP_P|VINP 8.664e-15 sky130_fd_pr__model__cap_mim
* device instance $1976 r0 *1 183.6,44.55 sky130_fd_pr__model__cap_mim
C$1976 \$533 TOP_P|VINP 8.664e-15 sky130_fd_pr__model__cap_mim
* device instance $1977 r0 *1 187,44.55 sky130_fd_pr__model__cap_mim
C$1977 \$532 TOP_P|VINP 8.664e-15 sky130_fd_pr__model__cap_mim
* device instance $1978 r0 *1 190.4,44.55 sky130_fd_pr__model__cap_mim
C$1978 \$521 TOP_P|VINP 8.664e-15 sky130_fd_pr__model__cap_mim
* device instance $1979 r0 *1 193.8,44.55 sky130_fd_pr__model__cap_mim
C$1979 \$532 TOP_P|VINP 8.664e-15 sky130_fd_pr__model__cap_mim
* device instance $1980 r0 *1 197.2,44.55 sky130_fd_pr__model__cap_mim
C$1980 \$533 TOP_P|VINP 8.664e-15 sky130_fd_pr__model__cap_mim
* device instance $1981 r0 *1 200.6,44.55 sky130_fd_pr__model__cap_mim
C$1981 \$532 TOP_P|VINP 8.664e-15 sky130_fd_pr__model__cap_mim
* device instance $1982 r0 *1 204,44.55 sky130_fd_pr__model__cap_mim
C$1982 \$534 TOP_P|VINP 8.664e-15 sky130_fd_pr__model__cap_mim
* device instance $1983 r0 *1 207.4,44.55 sky130_fd_pr__model__cap_mim
C$1983 \$532 TOP_P|VINP 8.664e-15 sky130_fd_pr__model__cap_mim
* device instance $1984 r0 *1 210.8,44.55 sky130_fd_pr__model__cap_mim
C$1984 \$533 TOP_P|VINP 8.664e-15 sky130_fd_pr__model__cap_mim
* device instance $1985 r0 *1 214.2,44.55 sky130_fd_pr__model__cap_mim
C$1985 \$532 TOP_P|VINP 8.664e-15 sky130_fd_pr__model__cap_mim
* device instance $1986 r0 *1 0,47.95 sky130_fd_pr__model__cap_mim
C$1986 \$528 TOP_N|VINN 8.664e-15 sky130_fd_pr__model__cap_mim
* device instance $1987 r0 *1 3.4,47.95 sky130_fd_pr__model__cap_mim
C$1987 \$529 TOP_N|VINN 8.664e-15 sky130_fd_pr__model__cap_mim
* device instance $1988 r0 *1 6.8,47.95 sky130_fd_pr__model__cap_mim
C$1988 \$528 TOP_N|VINN 8.664e-15 sky130_fd_pr__model__cap_mim
* device instance $1989 r0 *1 10.2,47.95 sky130_fd_pr__model__cap_mim
C$1989 \$530 TOP_N|VINN 8.664e-15 sky130_fd_pr__model__cap_mim
* device instance $1990 r0 *1 13.6,47.95 sky130_fd_pr__model__cap_mim
C$1990 \$528 TOP_N|VINN 8.664e-15 sky130_fd_pr__model__cap_mim
* device instance $1991 r0 *1 17,47.95 sky130_fd_pr__model__cap_mim
C$1991 \$529 TOP_N|VINN 8.664e-15 sky130_fd_pr__model__cap_mim
* device instance $1992 r0 *1 20.4,47.95 sky130_fd_pr__model__cap_mim
C$1992 \$528 TOP_N|VINN 8.664e-15 sky130_fd_pr__model__cap_mim
* device instance $1993 r0 *1 23.8,47.95 sky130_fd_pr__model__cap_mim
C$1993 \$531 TOP_N|VINN 8.664e-15 sky130_fd_pr__model__cap_mim
* device instance $1994 r0 *1 27.2,47.95 sky130_fd_pr__model__cap_mim
C$1994 \$528 TOP_N|VINN 8.664e-15 sky130_fd_pr__model__cap_mim
* device instance $1995 r0 *1 30.6,47.95 sky130_fd_pr__model__cap_mim
C$1995 \$529 TOP_N|VINN 8.664e-15 sky130_fd_pr__model__cap_mim
* device instance $1996 r0 *1 34,47.95 sky130_fd_pr__model__cap_mim
C$1996 \$528 TOP_N|VINN 8.664e-15 sky130_fd_pr__model__cap_mim
* device instance $1997 r0 *1 37.4,47.95 sky130_fd_pr__model__cap_mim
C$1997 \$530 TOP_N|VINN 8.664e-15 sky130_fd_pr__model__cap_mim
* device instance $1998 r0 *1 40.8,47.95 sky130_fd_pr__model__cap_mim
C$1998 \$528 TOP_N|VINN 8.664e-15 sky130_fd_pr__model__cap_mim
* device instance $1999 r0 *1 44.2,47.95 sky130_fd_pr__model__cap_mim
C$1999 \$529 TOP_N|VINN 8.664e-15 sky130_fd_pr__model__cap_mim
* device instance $2000 r0 *1 47.6,47.95 sky130_fd_pr__model__cap_mim
C$2000 \$528 TOP_N|VINN 8.664e-15 sky130_fd_pr__model__cap_mim
* device instance $2001 r0 *1 51,47.95 sky130_fd_pr__model__cap_mim
C$2001 \$526 TOP_N|VINN 8.664e-15 sky130_fd_pr__model__cap_mim
* device instance $2002 r0 *1 54.4,47.95 sky130_fd_pr__model__cap_mim
C$2002 \$528 TOP_N|VINN 8.664e-15 sky130_fd_pr__model__cap_mim
* device instance $2003 r0 *1 57.8,47.95 sky130_fd_pr__model__cap_mim
C$2003 \$529 TOP_N|VINN 8.664e-15 sky130_fd_pr__model__cap_mim
* device instance $2004 r0 *1 61.2,47.95 sky130_fd_pr__model__cap_mim
C$2004 \$528 TOP_N|VINN 8.664e-15 sky130_fd_pr__model__cap_mim
* device instance $2005 r0 *1 64.6,47.95 sky130_fd_pr__model__cap_mim
C$2005 \$530 TOP_N|VINN 8.664e-15 sky130_fd_pr__model__cap_mim
* device instance $2006 r0 *1 68,47.95 sky130_fd_pr__model__cap_mim
C$2006 \$528 TOP_N|VINN 8.664e-15 sky130_fd_pr__model__cap_mim
* device instance $2007 r0 *1 71.4,47.95 sky130_fd_pr__model__cap_mim
C$2007 \$529 TOP_N|VINN 8.664e-15 sky130_fd_pr__model__cap_mim
* device instance $2008 r0 *1 74.8,47.95 sky130_fd_pr__model__cap_mim
C$2008 \$528 TOP_N|VINN 8.664e-15 sky130_fd_pr__model__cap_mim
* device instance $2009 r0 *1 78.2,47.95 sky130_fd_pr__model__cap_mim
C$2009 \$531 TOP_N|VINN 8.664e-15 sky130_fd_pr__model__cap_mim
* device instance $2010 r0 *1 81.6,47.95 sky130_fd_pr__model__cap_mim
C$2010 \$528 TOP_N|VINN 8.664e-15 sky130_fd_pr__model__cap_mim
* device instance $2011 r0 *1 85,47.95 sky130_fd_pr__model__cap_mim
C$2011 \$529 TOP_N|VINN 8.664e-15 sky130_fd_pr__model__cap_mim
* device instance $2012 r0 *1 88.4,47.95 sky130_fd_pr__model__cap_mim
C$2012 \$528 TOP_N|VINN 8.664e-15 sky130_fd_pr__model__cap_mim
* device instance $2013 r0 *1 91.8,47.95 sky130_fd_pr__model__cap_mim
C$2013 \$530 TOP_N|VINN 8.664e-15 sky130_fd_pr__model__cap_mim
* device instance $2014 r0 *1 95.2,47.95 sky130_fd_pr__model__cap_mim
C$2014 \$528 TOP_N|VINN 8.664e-15 sky130_fd_pr__model__cap_mim
* device instance $2015 r0 *1 98.6,47.95 sky130_fd_pr__model__cap_mim
C$2015 \$529 TOP_N|VINN 8.664e-15 sky130_fd_pr__model__cap_mim
* device instance $2016 r0 *1 102,47.95 sky130_fd_pr__model__cap_mim
C$2016 \$528 TOP_N|VINN 8.664e-15 sky130_fd_pr__model__cap_mim
* device instance $2017 r0 *1 105.4,47.95 sky130_fd_pr__model__cap_mim
C$2017 \$525 TOP_N|VINN 8.664e-15 sky130_fd_pr__model__cap_mim
* device instance $2018 r0 *1 108.8,47.95 sky130_fd_pr__model__cap_mim
C$2018 VREFN TOP_N|VINN 8.664e-15 sky130_fd_pr__model__cap_mim
* device instance $2019 r0 *1 112.2,47.95 sky130_fd_pr__model__cap_mim
C$2019 \$528 TOP_N|VINN 8.664e-15 sky130_fd_pr__model__cap_mim
* device instance $2020 r0 *1 115.6,47.95 sky130_fd_pr__model__cap_mim
C$2020 \$529 TOP_N|VINN 8.664e-15 sky130_fd_pr__model__cap_mim
* device instance $2021 r0 *1 119,47.95 sky130_fd_pr__model__cap_mim
C$2021 \$528 TOP_N|VINN 8.664e-15 sky130_fd_pr__model__cap_mim
* device instance $2022 r0 *1 122.4,47.95 sky130_fd_pr__model__cap_mim
C$2022 \$530 TOP_N|VINN 8.664e-15 sky130_fd_pr__model__cap_mim
* device instance $2023 r0 *1 125.8,47.95 sky130_fd_pr__model__cap_mim
C$2023 \$528 TOP_N|VINN 8.664e-15 sky130_fd_pr__model__cap_mim
* device instance $2024 r0 *1 129.2,47.95 sky130_fd_pr__model__cap_mim
C$2024 \$529 TOP_N|VINN 8.664e-15 sky130_fd_pr__model__cap_mim
* device instance $2025 r0 *1 132.6,47.95 sky130_fd_pr__model__cap_mim
C$2025 \$528 TOP_N|VINN 8.664e-15 sky130_fd_pr__model__cap_mim
* device instance $2026 r0 *1 136,47.95 sky130_fd_pr__model__cap_mim
C$2026 \$531 TOP_N|VINN 8.664e-15 sky130_fd_pr__model__cap_mim
* device instance $2027 r0 *1 139.4,47.95 sky130_fd_pr__model__cap_mim
C$2027 \$528 TOP_N|VINN 8.664e-15 sky130_fd_pr__model__cap_mim
* device instance $2028 r0 *1 142.8,47.95 sky130_fd_pr__model__cap_mim
C$2028 \$529 TOP_N|VINN 8.664e-15 sky130_fd_pr__model__cap_mim
* device instance $2029 r0 *1 146.2,47.95 sky130_fd_pr__model__cap_mim
C$2029 \$528 TOP_N|VINN 8.664e-15 sky130_fd_pr__model__cap_mim
* device instance $2030 r0 *1 149.6,47.95 sky130_fd_pr__model__cap_mim
C$2030 \$530 TOP_N|VINN 8.664e-15 sky130_fd_pr__model__cap_mim
* device instance $2031 r0 *1 153,47.95 sky130_fd_pr__model__cap_mim
C$2031 \$528 TOP_N|VINN 8.664e-15 sky130_fd_pr__model__cap_mim
* device instance $2032 r0 *1 156.4,47.95 sky130_fd_pr__model__cap_mim
C$2032 \$529 TOP_N|VINN 8.664e-15 sky130_fd_pr__model__cap_mim
* device instance $2033 r0 *1 159.8,47.95 sky130_fd_pr__model__cap_mim
C$2033 \$528 TOP_N|VINN 8.664e-15 sky130_fd_pr__model__cap_mim
* device instance $2034 r0 *1 163.2,47.95 sky130_fd_pr__model__cap_mim
C$2034 \$526 TOP_N|VINN 8.664e-15 sky130_fd_pr__model__cap_mim
* device instance $2035 r0 *1 166.6,47.95 sky130_fd_pr__model__cap_mim
C$2035 \$528 TOP_N|VINN 8.664e-15 sky130_fd_pr__model__cap_mim
* device instance $2036 r0 *1 170,47.95 sky130_fd_pr__model__cap_mim
C$2036 \$529 TOP_N|VINN 8.664e-15 sky130_fd_pr__model__cap_mim
* device instance $2037 r0 *1 173.4,47.95 sky130_fd_pr__model__cap_mim
C$2037 \$528 TOP_N|VINN 8.664e-15 sky130_fd_pr__model__cap_mim
* device instance $2038 r0 *1 176.8,47.95 sky130_fd_pr__model__cap_mim
C$2038 \$530 TOP_N|VINN 8.664e-15 sky130_fd_pr__model__cap_mim
* device instance $2039 r0 *1 180.2,47.95 sky130_fd_pr__model__cap_mim
C$2039 \$528 TOP_N|VINN 8.664e-15 sky130_fd_pr__model__cap_mim
* device instance $2040 r0 *1 183.6,47.95 sky130_fd_pr__model__cap_mim
C$2040 \$529 TOP_N|VINN 8.664e-15 sky130_fd_pr__model__cap_mim
* device instance $2041 r0 *1 187,47.95 sky130_fd_pr__model__cap_mim
C$2041 \$528 TOP_N|VINN 8.664e-15 sky130_fd_pr__model__cap_mim
* device instance $2042 r0 *1 190.4,47.95 sky130_fd_pr__model__cap_mim
C$2042 \$531 TOP_N|VINN 8.664e-15 sky130_fd_pr__model__cap_mim
* device instance $2043 r0 *1 193.8,47.95 sky130_fd_pr__model__cap_mim
C$2043 \$528 TOP_N|VINN 8.664e-15 sky130_fd_pr__model__cap_mim
* device instance $2044 r0 *1 197.2,47.95 sky130_fd_pr__model__cap_mim
C$2044 \$529 TOP_N|VINN 8.664e-15 sky130_fd_pr__model__cap_mim
* device instance $2045 r0 *1 200.6,47.95 sky130_fd_pr__model__cap_mim
C$2045 \$528 TOP_N|VINN 8.664e-15 sky130_fd_pr__model__cap_mim
* device instance $2046 r0 *1 204,47.95 sky130_fd_pr__model__cap_mim
C$2046 \$530 TOP_N|VINN 8.664e-15 sky130_fd_pr__model__cap_mim
* device instance $2047 r0 *1 207.4,47.95 sky130_fd_pr__model__cap_mim
C$2047 \$528 TOP_N|VINN 8.664e-15 sky130_fd_pr__model__cap_mim
* device instance $2048 r0 *1 210.8,47.95 sky130_fd_pr__model__cap_mim
C$2048 \$529 TOP_N|VINN 8.664e-15 sky130_fd_pr__model__cap_mim
* device instance $2049 r0 *1 214.2,47.95 sky130_fd_pr__model__cap_mim
C$2049 \$528 TOP_N|VINN 8.664e-15 sky130_fd_pr__model__cap_mim
* device instance $2050 r0 *1 0,51.35 sky130_fd_pr__model__cap_mim
C$2050 \$532 TOP_P|VINP 8.664e-15 sky130_fd_pr__model__cap_mim
* device instance $2051 r0 *1 3.4,51.35 sky130_fd_pr__model__cap_mim
C$2051 \$533 TOP_P|VINP 8.664e-15 sky130_fd_pr__model__cap_mim
* device instance $2052 r0 *1 6.8,51.35 sky130_fd_pr__model__cap_mim
C$2052 \$532 TOP_P|VINP 8.664e-15 sky130_fd_pr__model__cap_mim
* device instance $2053 r0 *1 10.2,51.35 sky130_fd_pr__model__cap_mim
C$2053 \$534 TOP_P|VINP 8.664e-15 sky130_fd_pr__model__cap_mim
* device instance $2054 r0 *1 13.6,51.35 sky130_fd_pr__model__cap_mim
C$2054 \$532 TOP_P|VINP 8.664e-15 sky130_fd_pr__model__cap_mim
* device instance $2055 r0 *1 17,51.35 sky130_fd_pr__model__cap_mim
C$2055 \$533 TOP_P|VINP 8.664e-15 sky130_fd_pr__model__cap_mim
* device instance $2056 r0 *1 20.4,51.35 sky130_fd_pr__model__cap_mim
C$2056 \$532 TOP_P|VINP 8.664e-15 sky130_fd_pr__model__cap_mim
* device instance $2057 r0 *1 23.8,51.35 sky130_fd_pr__model__cap_mim
C$2057 \$521 TOP_P|VINP 8.664e-15 sky130_fd_pr__model__cap_mim
* device instance $2058 r0 *1 27.2,51.35 sky130_fd_pr__model__cap_mim
C$2058 \$532 TOP_P|VINP 8.664e-15 sky130_fd_pr__model__cap_mim
* device instance $2059 r0 *1 30.6,51.35 sky130_fd_pr__model__cap_mim
C$2059 \$533 TOP_P|VINP 8.664e-15 sky130_fd_pr__model__cap_mim
* device instance $2060 r0 *1 34,51.35 sky130_fd_pr__model__cap_mim
C$2060 \$532 TOP_P|VINP 8.664e-15 sky130_fd_pr__model__cap_mim
* device instance $2061 r0 *1 37.4,51.35 sky130_fd_pr__model__cap_mim
C$2061 \$534 TOP_P|VINP 8.664e-15 sky130_fd_pr__model__cap_mim
* device instance $2062 r0 *1 40.8,51.35 sky130_fd_pr__model__cap_mim
C$2062 \$532 TOP_P|VINP 8.664e-15 sky130_fd_pr__model__cap_mim
* device instance $2063 r0 *1 44.2,51.35 sky130_fd_pr__model__cap_mim
C$2063 \$533 TOP_P|VINP 8.664e-15 sky130_fd_pr__model__cap_mim
* device instance $2064 r0 *1 47.6,51.35 sky130_fd_pr__model__cap_mim
C$2064 \$532 TOP_P|VINP 8.664e-15 sky130_fd_pr__model__cap_mim
* device instance $2065 r0 *1 51,51.35 sky130_fd_pr__model__cap_mim
C$2065 \$520 TOP_P|VINP 8.664e-15 sky130_fd_pr__model__cap_mim
* device instance $2066 r0 *1 54.4,51.35 sky130_fd_pr__model__cap_mim
C$2066 \$532 TOP_P|VINP 8.664e-15 sky130_fd_pr__model__cap_mim
* device instance $2067 r0 *1 57.8,51.35 sky130_fd_pr__model__cap_mim
C$2067 \$533 TOP_P|VINP 8.664e-15 sky130_fd_pr__model__cap_mim
* device instance $2068 r0 *1 61.2,51.35 sky130_fd_pr__model__cap_mim
C$2068 \$532 TOP_P|VINP 8.664e-15 sky130_fd_pr__model__cap_mim
* device instance $2069 r0 *1 64.6,51.35 sky130_fd_pr__model__cap_mim
C$2069 \$534 TOP_P|VINP 8.664e-15 sky130_fd_pr__model__cap_mim
* device instance $2070 r0 *1 68,51.35 sky130_fd_pr__model__cap_mim
C$2070 \$532 TOP_P|VINP 8.664e-15 sky130_fd_pr__model__cap_mim
* device instance $2071 r0 *1 71.4,51.35 sky130_fd_pr__model__cap_mim
C$2071 \$533 TOP_P|VINP 8.664e-15 sky130_fd_pr__model__cap_mim
* device instance $2072 r0 *1 74.8,51.35 sky130_fd_pr__model__cap_mim
C$2072 \$532 TOP_P|VINP 8.664e-15 sky130_fd_pr__model__cap_mim
* device instance $2073 r0 *1 78.2,51.35 sky130_fd_pr__model__cap_mim
C$2073 \$521 TOP_P|VINP 8.664e-15 sky130_fd_pr__model__cap_mim
* device instance $2074 r0 *1 81.6,51.35 sky130_fd_pr__model__cap_mim
C$2074 \$532 TOP_P|VINP 8.664e-15 sky130_fd_pr__model__cap_mim
* device instance $2075 r0 *1 85,51.35 sky130_fd_pr__model__cap_mim
C$2075 \$533 TOP_P|VINP 8.664e-15 sky130_fd_pr__model__cap_mim
* device instance $2076 r0 *1 88.4,51.35 sky130_fd_pr__model__cap_mim
C$2076 \$532 TOP_P|VINP 8.664e-15 sky130_fd_pr__model__cap_mim
* device instance $2077 r0 *1 91.8,51.35 sky130_fd_pr__model__cap_mim
C$2077 \$534 TOP_P|VINP 8.664e-15 sky130_fd_pr__model__cap_mim
* device instance $2078 r0 *1 95.2,51.35 sky130_fd_pr__model__cap_mim
C$2078 \$532 TOP_P|VINP 8.664e-15 sky130_fd_pr__model__cap_mim
* device instance $2079 r0 *1 98.6,51.35 sky130_fd_pr__model__cap_mim
C$2079 \$533 TOP_P|VINP 8.664e-15 sky130_fd_pr__model__cap_mim
* device instance $2080 r0 *1 102,51.35 sky130_fd_pr__model__cap_mim
C$2080 \$532 TOP_P|VINP 8.664e-15 sky130_fd_pr__model__cap_mim
* device instance $2081 r0 *1 105.4,51.35 sky130_fd_pr__model__cap_mim
C$2081 \$519 TOP_P|VINP 8.664e-15 sky130_fd_pr__model__cap_mim
* device instance $2082 r0 *1 108.8,51.35 sky130_fd_pr__model__cap_mim
C$2082 VREFN TOP_P|VINP 8.664e-15 sky130_fd_pr__model__cap_mim
* device instance $2083 r0 *1 112.2,51.35 sky130_fd_pr__model__cap_mim
C$2083 \$532 TOP_P|VINP 8.664e-15 sky130_fd_pr__model__cap_mim
* device instance $2084 r0 *1 115.6,51.35 sky130_fd_pr__model__cap_mim
C$2084 \$533 TOP_P|VINP 8.664e-15 sky130_fd_pr__model__cap_mim
* device instance $2085 r0 *1 119,51.35 sky130_fd_pr__model__cap_mim
C$2085 \$532 TOP_P|VINP 8.664e-15 sky130_fd_pr__model__cap_mim
* device instance $2086 r0 *1 122.4,51.35 sky130_fd_pr__model__cap_mim
C$2086 \$534 TOP_P|VINP 8.664e-15 sky130_fd_pr__model__cap_mim
* device instance $2087 r0 *1 125.8,51.35 sky130_fd_pr__model__cap_mim
C$2087 \$532 TOP_P|VINP 8.664e-15 sky130_fd_pr__model__cap_mim
* device instance $2088 r0 *1 129.2,51.35 sky130_fd_pr__model__cap_mim
C$2088 \$533 TOP_P|VINP 8.664e-15 sky130_fd_pr__model__cap_mim
* device instance $2089 r0 *1 132.6,51.35 sky130_fd_pr__model__cap_mim
C$2089 \$532 TOP_P|VINP 8.664e-15 sky130_fd_pr__model__cap_mim
* device instance $2090 r0 *1 136,51.35 sky130_fd_pr__model__cap_mim
C$2090 \$521 TOP_P|VINP 8.664e-15 sky130_fd_pr__model__cap_mim
* device instance $2091 r0 *1 139.4,51.35 sky130_fd_pr__model__cap_mim
C$2091 \$532 TOP_P|VINP 8.664e-15 sky130_fd_pr__model__cap_mim
* device instance $2092 r0 *1 142.8,51.35 sky130_fd_pr__model__cap_mim
C$2092 \$533 TOP_P|VINP 8.664e-15 sky130_fd_pr__model__cap_mim
* device instance $2093 r0 *1 146.2,51.35 sky130_fd_pr__model__cap_mim
C$2093 \$532 TOP_P|VINP 8.664e-15 sky130_fd_pr__model__cap_mim
* device instance $2094 r0 *1 149.6,51.35 sky130_fd_pr__model__cap_mim
C$2094 \$534 TOP_P|VINP 8.664e-15 sky130_fd_pr__model__cap_mim
* device instance $2095 r0 *1 153,51.35 sky130_fd_pr__model__cap_mim
C$2095 \$532 TOP_P|VINP 8.664e-15 sky130_fd_pr__model__cap_mim
* device instance $2096 r0 *1 156.4,51.35 sky130_fd_pr__model__cap_mim
C$2096 \$533 TOP_P|VINP 8.664e-15 sky130_fd_pr__model__cap_mim
* device instance $2097 r0 *1 159.8,51.35 sky130_fd_pr__model__cap_mim
C$2097 \$532 TOP_P|VINP 8.664e-15 sky130_fd_pr__model__cap_mim
* device instance $2098 r0 *1 163.2,51.35 sky130_fd_pr__model__cap_mim
C$2098 \$520 TOP_P|VINP 8.664e-15 sky130_fd_pr__model__cap_mim
* device instance $2099 r0 *1 166.6,51.35 sky130_fd_pr__model__cap_mim
C$2099 \$532 TOP_P|VINP 8.664e-15 sky130_fd_pr__model__cap_mim
* device instance $2100 r0 *1 170,51.35 sky130_fd_pr__model__cap_mim
C$2100 \$533 TOP_P|VINP 8.664e-15 sky130_fd_pr__model__cap_mim
* device instance $2101 r0 *1 173.4,51.35 sky130_fd_pr__model__cap_mim
C$2101 \$532 TOP_P|VINP 8.664e-15 sky130_fd_pr__model__cap_mim
* device instance $2102 r0 *1 176.8,51.35 sky130_fd_pr__model__cap_mim
C$2102 \$534 TOP_P|VINP 8.664e-15 sky130_fd_pr__model__cap_mim
* device instance $2103 r0 *1 180.2,51.35 sky130_fd_pr__model__cap_mim
C$2103 \$532 TOP_P|VINP 8.664e-15 sky130_fd_pr__model__cap_mim
* device instance $2104 r0 *1 183.6,51.35 sky130_fd_pr__model__cap_mim
C$2104 \$533 TOP_P|VINP 8.664e-15 sky130_fd_pr__model__cap_mim
* device instance $2105 r0 *1 187,51.35 sky130_fd_pr__model__cap_mim
C$2105 \$532 TOP_P|VINP 8.664e-15 sky130_fd_pr__model__cap_mim
* device instance $2106 r0 *1 190.4,51.35 sky130_fd_pr__model__cap_mim
C$2106 \$521 TOP_P|VINP 8.664e-15 sky130_fd_pr__model__cap_mim
* device instance $2107 r0 *1 193.8,51.35 sky130_fd_pr__model__cap_mim
C$2107 \$532 TOP_P|VINP 8.664e-15 sky130_fd_pr__model__cap_mim
* device instance $2108 r0 *1 197.2,51.35 sky130_fd_pr__model__cap_mim
C$2108 \$533 TOP_P|VINP 8.664e-15 sky130_fd_pr__model__cap_mim
* device instance $2109 r0 *1 200.6,51.35 sky130_fd_pr__model__cap_mim
C$2109 \$532 TOP_P|VINP 8.664e-15 sky130_fd_pr__model__cap_mim
* device instance $2110 r0 *1 204,51.35 sky130_fd_pr__model__cap_mim
C$2110 \$534 TOP_P|VINP 8.664e-15 sky130_fd_pr__model__cap_mim
* device instance $2111 r0 *1 207.4,51.35 sky130_fd_pr__model__cap_mim
C$2111 \$532 TOP_P|VINP 8.664e-15 sky130_fd_pr__model__cap_mim
* device instance $2112 r0 *1 210.8,51.35 sky130_fd_pr__model__cap_mim
C$2112 \$533 TOP_P|VINP 8.664e-15 sky130_fd_pr__model__cap_mim
* device instance $2113 r0 *1 214.2,51.35 sky130_fd_pr__model__cap_mim
C$2113 \$532 TOP_P|VINP 8.664e-15 sky130_fd_pr__model__cap_mim
* device instance $2114 r0 *1 120.901,73.45 sky130_fd_pr__model__cap_mim
C$2114 BOT_OFF_N TOP_N|VINN 8.664e-15 sky130_fd_pr__model__cap_mim
* device instance $2115 r0 *1 136.901,73.45 sky130_fd_pr__model__cap_mim
C$2115 BOT_OFF_P TOP_P|VINP 8.664e-15 sky130_fd_pr__model__cap_mim
* device instance $2116 r0 *1 143.385,93.65 sky130_fd_pr__model__cap_mim
C$2116 \$545 BOOST_P 1.99528e-13 sky130_fd_pr__model__cap_mim
* device instance $2117 r0 *1 154.685,93.65 sky130_fd_pr__model__cap_mim
C$2117 \$547 BOOST_N 1.99528e-13 sky130_fd_pr__model__cap_mim
* device instance $2118 r0 *1 187.035,112.2 sky130_fd_pr__model__cap_mim
C$2118 BPREF_P TOP_P|VINP 4.434864e-12 sky130_fd_pr__model__cap_mim
* device instance $2119 r0 *1 235.435,112.2 sky130_fd_pr__model__cap_mim
C$2119 BPREF_N TOP_N|VINN 4.434864e-12 sky130_fd_pr__model__cap_mim
* device instance $2120 r0 *1 151.95,173.95 sky130_fd_pr__model__cap_mim
C$2120 GND|VGND|VSS VDD 4.434864e-12 sky130_fd_pr__model__cap_mim
* device instance $2121 r0 *1 203.95,173.95 sky130_fd_pr__model__cap_mim
C$2121 GND|VGND|VSS VDD 4.434864e-12 sky130_fd_pr__model__cap_mim
.ENDS gen_compose_0
