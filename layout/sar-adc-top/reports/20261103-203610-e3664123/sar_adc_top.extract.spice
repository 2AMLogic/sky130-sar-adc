* extracted by klt extract --deck sky130

* cell gen_compose_0
* pin A,A0,B,DOUT9
* pin A,A_N,B,D,DOUT0,DOUT7,PH_B6,PH_B9,Q,S,VPB,VPWR
* pin A,B,BUSY,DOUT2,GND,VGND,VSS
* pin A,B,DOUT1
* pin A,B,DOUT3
* pin A,B,DOUT4
* pin A,B,DOUT5
* pin A,B,DOUT6
* pin A,B,DOUT8
* pin A,CLK
* pin A,CLK
* pin VCM
* pin VDD
* pin VINN
* pin VINP
* pin VREFN
* pin VREFP
* pin RST_B
.SUBCKT gen_compose_0 A|A0|B|DOUT9
+ A|A_N|B|D|DOUT0|DOUT7|PH_B6|PH_B9|Q|S|VPB|VPWR A|B|BUSY|DOUT2|GND|VGND|VSS
+ A|B|DOUT1 A|B|DOUT3 A|B|DOUT4 A|B|DOUT5 A|B|DOUT6 A|B|DOUT8 A|CLK A|CLK$1 VCM
+ VDD VINN VINP VREFN VREFP RST_B
* device instance $1 r0 *1 45.03,-142.4 nfet
M$1 A0|DOUT5|Q \$12 A|B|BUSY|DOUT2|GND|VGND|VSS A|B|BUSY|DOUT2|GND|VGND|VSS
+ nfet L=0.15U W=0.65U AS=0.2087P AD=0.169P PS=2.02U PD=1.82U
* device instance $2 r0 *1 36.77,-142.285 nfet
M$2 A|B|BUSY|DOUT2|GND|VGND|VSS A|CLK|X \$3 A|B|BUSY|DOUT2|GND|VGND|VSS nfet
+ L=0.15U W=0.42U AS=0.1092P AD=0.0567P PS=1.36U PD=0.69U
* device instance $3 r0 *1 37.19,-142.285 nfet
M$3 \$4 \$3 A|B|BUSY|DOUT2|GND|VGND|VSS A|B|BUSY|DOUT2|GND|VGND|VSS nfet
+ L=0.15U W=0.42U AS=0.0567P AD=0.1092P PS=0.69U PD=1.36U
* device instance $4 r0 *1 38.465,-142.285 nfet
M$4 \$6 D|X A|B|BUSY|DOUT2|GND|VGND|VSS A|B|BUSY|DOUT2|GND|VGND|VSS nfet
+ L=0.15U W=0.42U AS=0.2205P AD=0.066P PS=1.89U PD=0.745U
* device instance $5 r0 *1 38.94,-142.255 nfet
M$5 \$7 \$3 \$6 A|B|BUSY|DOUT2|GND|VGND|VSS nfet L=0.15U W=0.36U AS=0.066P
+ AD=0.0594P PS=0.745U PD=0.69U
* device instance $6 r0 *1 39.42,-142.255 nfet
M$6 \$7 \$4 \$14 A|B|BUSY|DOUT2|GND|VGND|VSS nfet L=0.15U W=0.36U AS=0.1401P
+ AD=0.0594P PS=1.1U PD=0.69U
* device instance $7 r0 *1 40.25,-142.285 nfet
M$7 \$15 \$10 \$14 A|B|BUSY|DOUT2|GND|VGND|VSS nfet L=0.15U W=0.42U AS=0.1401P
+ AD=0.0441P PS=1.1U PD=0.63U
* device instance $8 r0 *1 40.61,-142.285 nfet
M$8 \$15 RESET_B|RST_B|SAMPLE A|B|BUSY|DOUT2|GND|VGND|VSS
+ A|B|BUSY|DOUT2|GND|VGND|VSS nfet L=0.15U W=0.42U AS=0.1346P AD=0.0441P
+ PS=1.15U PD=0.63U
* device instance $9 r0 *1 41.27,-142.395 nfet
M$9 \$10 \$7 A|B|BUSY|DOUT2|GND|VGND|VSS A|B|BUSY|DOUT2|GND|VGND|VSS nfet
+ L=0.15U W=0.64U AS=0.1346P AD=0.0999P PS=1.15U PD=0.985U
* device instance $10 r0 *1 41.765,-142.255 nfet
M$10 \$11 \$4 \$10 A|B|BUSY|DOUT2|GND|VGND|VSS nfet L=0.15U W=0.36U AS=0.0999P
+ AD=0.0711P PS=0.985U PD=0.755U
* device instance $11 r0 *1 42.31,-142.255 nfet
M$11 \$11 \$3 \$16 A|B|BUSY|DOUT2|GND|VGND|VSS nfet L=0.15U W=0.36U AS=0.0669P
+ AD=0.0711P PS=0.75U PD=0.755U
* device instance $12 r0 *1 42.79,-142.285 nfet
M$12 A|B|BUSY|DOUT2|GND|VGND|VSS \$12 \$16 A|B|BUSY|DOUT2|GND|VGND|VSS nfet
+ L=0.15U W=0.42U AS=0.0669P AD=0.12495P PS=0.75U PD=1.015U
* device instance $13 r0 *1 43.535,-142.285 nfet
M$13 \$18 RESET_B|RST_B|SAMPLE A|B|BUSY|DOUT2|GND|VGND|VSS
+ A|B|BUSY|DOUT2|GND|VGND|VSS nfet L=0.15U W=0.42U AS=0.12495P AD=0.06405P
+ PS=1.015U PD=0.725U
* device instance $14 r0 *1 43.99,-142.285 nfet
M$14 \$12 \$11 \$18 A|B|BUSY|DOUT2|GND|VGND|VSS nfet L=0.15U W=0.42U
+ AS=0.06405P AD=0.1092P PS=0.725U PD=1.36U
* device instance $15 r0 *1 39.53,-141.28 nfet
M$15 A|B|BUSY|DOUT2|GND|VGND|VSS A|X \$20 A|B|BUSY|DOUT2|GND|VGND|VSS nfet
+ L=0.15U W=0.65U AS=0.169P AD=0.08775P PS=1.82U PD=0.92U
* device instance $16 r0 *1 39.95,-141.28 nfet
M$16 A|CLK|X \$20 A|B|BUSY|DOUT2|GND|VGND|VSS A|B|BUSY|DOUT2|GND|VGND|VSS nfet
+ L=0.15U W=0.65U AS=0.08775P AD=0.08775P PS=0.92U PD=0.92U
* device instance $17 r0 *1 40.37,-141.28 nfet
M$17 A|B|BUSY|DOUT2|GND|VGND|VSS \$20 A|CLK|X A|B|BUSY|DOUT2|GND|VGND|VSS nfet
+ L=0.15U W=0.65U AS=0.08775P AD=0.08775P PS=0.92U PD=0.92U
* device instance $18 r0 *1 40.79,-141.28 nfet
M$18 A|CLK|X \$20 A|B|BUSY|DOUT2|GND|VGND|VSS A|B|BUSY|DOUT2|GND|VGND|VSS nfet
+ L=0.15U W=0.65U AS=0.08775P AD=0.08775P PS=0.92U PD=0.92U
* device instance $19 r0 *1 41.21,-141.28 nfet
M$19 A|B|BUSY|DOUT2|GND|VGND|VSS \$20 A|CLK|X A|B|BUSY|DOUT2|GND|VGND|VSS nfet
+ L=0.15U W=0.65U AS=0.08775P AD=0.169P PS=0.92U PD=1.82U
* device instance $20 r0 *1 42.27,-136.96 nfet
M$20 A0|DOUT3|Q \$37 A|B|BUSY|DOUT2|GND|VGND|VSS A|B|BUSY|DOUT2|GND|VGND|VSS
+ nfet L=0.15U W=0.65U AS=0.2087P AD=0.169P PS=2.02U PD=1.82U
* device instance $21 r0 *1 52.13,-141.255 nfet
M$21 \$24 A|X$1 \$22 A|B|BUSY|DOUT2|GND|VGND|VSS nfet L=0.15U W=0.42U
+ AS=0.1176P AD=0.0567P PS=1.4U PD=0.69U
* device instance $22 r0 *1 52.55,-141.255 nfet
M$22 \$24 B|X A|B|BUSY|DOUT2|GND|VGND|VSS A|B|BUSY|DOUT2|GND|VGND|VSS nfet
+ L=0.15U W=0.42U AS=0.1118P AD=0.0567P PS=1.04U PD=0.69U
* device instance $23 r0 *1 53.09,-141.28 nfet
M$23 D|X$1 \$22 A|B|BUSY|DOUT2|GND|VGND|VSS A|B|BUSY|DOUT2|GND|VGND|VSS nfet
+ L=0.15U W=0.65U AS=0.1118P AD=0.182P PS=1.04U PD=1.86U
* device instance $24 r0 *1 60.67,-136.96 nfet
M$24 A0|DOUT6|Q \$49 A|B|BUSY|DOUT2|GND|VGND|VSS A|B|BUSY|DOUT2|GND|VGND|VSS
+ nfet L=0.15U W=0.65U AS=0.2087P AD=0.169P PS=2.02U PD=1.82U
* device instance $25 r0 *1 30.015,-136.845 nfet
M$25 \$25 B|D|PH_B4|Q|S A|B|BUSY|DOUT2|GND|VGND|VSS A|B|BUSY|DOUT2|GND|VGND|VSS
+ nfet L=0.15U W=0.42U AS=0.1092P AD=0.0567P PS=1.36U PD=0.69U
* device instance $26 r0 *1 30.435,-136.845 nfet
M$26 \$25 A|X$2 A|B|BUSY|DOUT2|GND|VGND|VSS A|B|BUSY|DOUT2|GND|VGND|VSS nfet
+ L=0.15U W=0.42U AS=0.10025P AD=0.0567P PS=0.985U PD=0.69U
* device instance $27 r0 *1 30.92,-136.96 nfet
M$27 A|X$3 \$25 A|B|BUSY|DOUT2|GND|VGND|VSS A|B|BUSY|DOUT2|GND|VGND|VSS nfet
+ L=0.15U W=0.65U AS=0.10025P AD=0.169P PS=0.985U PD=1.82U
* device instance $28 r0 *1 34.01,-136.845 nfet
M$28 A|B|BUSY|DOUT2|GND|VGND|VSS A|CLK|X \$29 A|B|BUSY|DOUT2|GND|VGND|VSS nfet
+ L=0.15U W=0.42U AS=0.1092P AD=0.0567P PS=1.36U PD=0.69U
* device instance $29 r0 *1 34.43,-136.845 nfet
M$29 \$30 \$29 A|B|BUSY|DOUT2|GND|VGND|VSS A|B|BUSY|DOUT2|GND|VGND|VSS nfet
+ L=0.15U W=0.42U AS=0.0567P AD=0.1092P PS=0.69U PD=1.36U
* device instance $30 r0 *1 35.705,-136.845 nfet
M$30 \$32 D|X$2 A|B|BUSY|DOUT2|GND|VGND|VSS A|B|BUSY|DOUT2|GND|VGND|VSS nfet
+ L=0.15U W=0.42U AS=0.2205P AD=0.066P PS=1.89U PD=0.745U
* device instance $31 r0 *1 36.18,-136.815 nfet
M$31 \$33 \$29 \$32 A|B|BUSY|DOUT2|GND|VGND|VSS nfet L=0.15U W=0.36U AS=0.066P
+ AD=0.0594P PS=0.745U PD=0.69U
* device instance $32 r0 *1 36.66,-136.815 nfet
M$32 \$33 \$30 \$62 A|B|BUSY|DOUT2|GND|VGND|VSS nfet L=0.15U W=0.36U AS=0.1401P
+ AD=0.0594P PS=1.1U PD=0.69U
* device instance $33 r0 *1 37.49,-136.845 nfet
M$33 \$61 \$35 \$62 A|B|BUSY|DOUT2|GND|VGND|VSS nfet L=0.15U W=0.42U AS=0.1401P
+ AD=0.0441P PS=1.1U PD=0.63U
* device instance $34 r0 *1 37.85,-136.845 nfet
M$34 \$61 RESET_B|RST_B|SAMPLE A|B|BUSY|DOUT2|GND|VGND|VSS
+ A|B|BUSY|DOUT2|GND|VGND|VSS nfet L=0.15U W=0.42U AS=0.1346P AD=0.0441P
+ PS=1.15U PD=0.63U
* device instance $35 r0 *1 38.51,-136.955 nfet
M$35 \$35 \$33 A|B|BUSY|DOUT2|GND|VGND|VSS A|B|BUSY|DOUT2|GND|VGND|VSS nfet
+ L=0.15U W=0.64U AS=0.1346P AD=0.0999P PS=1.15U PD=0.985U
* device instance $36 r0 *1 39.005,-136.815 nfet
M$36 \$36 \$30 \$35 A|B|BUSY|DOUT2|GND|VGND|VSS nfet L=0.15U W=0.36U AS=0.0999P
+ AD=0.0711P PS=0.985U PD=0.755U
* device instance $37 r0 *1 39.55,-136.815 nfet
M$37 \$36 \$29 \$60 A|B|BUSY|DOUT2|GND|VGND|VSS nfet L=0.15U W=0.36U AS=0.0669P
+ AD=0.0711P PS=0.75U PD=0.755U
* device instance $38 r0 *1 40.03,-136.845 nfet
M$38 A|B|BUSY|DOUT2|GND|VGND|VSS \$37 \$60 A|B|BUSY|DOUT2|GND|VGND|VSS nfet
+ L=0.15U W=0.42U AS=0.0669P AD=0.12495P PS=0.75U PD=1.015U
* device instance $39 r0 *1 40.775,-136.845 nfet
M$39 \$59 RESET_B|RST_B|SAMPLE A|B|BUSY|DOUT2|GND|VGND|VSS
+ A|B|BUSY|DOUT2|GND|VGND|VSS nfet L=0.15U W=0.42U AS=0.12495P AD=0.06405P
+ PS=1.015U PD=0.725U
* device instance $40 r0 *1 41.23,-136.845 nfet
M$40 \$37 \$36 \$59 A|B|BUSY|DOUT2|GND|VGND|VSS nfet L=0.15U W=0.42U
+ AS=0.06405P AD=0.1092P PS=0.725U PD=1.36U
* device instance $41 r0 *1 43.39,-136.985 nfet
M$41 \$53 A|X$4 \$39 A|B|BUSY|DOUT2|GND|VGND|VSS nfet L=0.15U W=0.42U
+ AS=0.1176P AD=0.0567P PS=1.4U PD=0.69U
* device instance $42 r0 *1 43.81,-136.985 nfet
M$42 \$53 B|X A|B|BUSY|DOUT2|GND|VGND|VSS A|B|BUSY|DOUT2|GND|VGND|VSS nfet
+ L=0.15U W=0.42U AS=0.1118P AD=0.0567P PS=1.04U PD=0.69U
* device instance $43 r0 *1 44.35,-136.96 nfet
M$43 D|X$3 \$39 A|B|BUSY|DOUT2|GND|VGND|VSS A|B|BUSY|DOUT2|GND|VGND|VSS nfet
+ L=0.15U W=0.65U AS=0.1118P AD=0.182P PS=1.04U PD=1.86U
* device instance $44 r0 *1 52.41,-136.845 nfet
M$44 A|B|BUSY|DOUT2|GND|VGND|VSS A|CLK|X \$42 A|B|BUSY|DOUT2|GND|VGND|VSS nfet
+ L=0.15U W=0.42U AS=0.1092P AD=0.0567P PS=1.36U PD=0.69U
* device instance $45 r0 *1 52.83,-136.845 nfet
M$45 \$43 \$42 A|B|BUSY|DOUT2|GND|VGND|VSS A|B|BUSY|DOUT2|GND|VGND|VSS nfet
+ L=0.15U W=0.42U AS=0.0567P AD=0.1092P PS=0.69U PD=1.36U
* device instance $46 r0 *1 54.105,-136.845 nfet
M$46 \$44 D|X$1 A|B|BUSY|DOUT2|GND|VGND|VSS A|B|BUSY|DOUT2|GND|VGND|VSS nfet
+ L=0.15U W=0.42U AS=0.2205P AD=0.066P PS=1.89U PD=0.745U
* device instance $47 r0 *1 54.58,-136.815 nfet
M$47 \$45 \$42 \$44 A|B|BUSY|DOUT2|GND|VGND|VSS nfet L=0.15U W=0.36U AS=0.066P
+ AD=0.0594P PS=0.745U PD=0.69U
* device instance $48 r0 *1 55.06,-136.815 nfet
M$48 \$45 \$43 \$58 A|B|BUSY|DOUT2|GND|VGND|VSS nfet L=0.15U W=0.36U AS=0.1401P
+ AD=0.0594P PS=1.1U PD=0.69U
* device instance $49 r0 *1 55.89,-136.845 nfet
M$49 \$57 \$47 \$58 A|B|BUSY|DOUT2|GND|VGND|VSS nfet L=0.15U W=0.42U AS=0.1401P
+ AD=0.0441P PS=1.1U PD=0.63U
* device instance $50 r0 *1 56.25,-136.845 nfet
M$50 \$57 RESET_B|RST_B|SAMPLE A|B|BUSY|DOUT2|GND|VGND|VSS
+ A|B|BUSY|DOUT2|GND|VGND|VSS nfet L=0.15U W=0.42U AS=0.1346P AD=0.0441P
+ PS=1.15U PD=0.63U
* device instance $51 r0 *1 56.91,-136.955 nfet
M$51 \$47 \$45 A|B|BUSY|DOUT2|GND|VGND|VSS A|B|BUSY|DOUT2|GND|VGND|VSS nfet
+ L=0.15U W=0.64U AS=0.1346P AD=0.0999P PS=1.15U PD=0.985U
* device instance $52 r0 *1 57.405,-136.815 nfet
M$52 \$48 \$43 \$47 A|B|BUSY|DOUT2|GND|VGND|VSS nfet L=0.15U W=0.36U AS=0.0999P
+ AD=0.0711P PS=0.985U PD=0.755U
* device instance $53 r0 *1 57.95,-136.815 nfet
M$53 \$48 \$42 \$56 A|B|BUSY|DOUT2|GND|VGND|VSS nfet L=0.15U W=0.36U AS=0.0669P
+ AD=0.0711P PS=0.75U PD=0.755U
* device instance $54 r0 *1 58.43,-136.845 nfet
M$54 A|B|BUSY|DOUT2|GND|VGND|VSS \$49 \$56 A|B|BUSY|DOUT2|GND|VGND|VSS nfet
+ L=0.15U W=0.42U AS=0.0669P AD=0.12495P PS=0.75U PD=1.015U
* device instance $55 r0 *1 59.175,-136.845 nfet
M$55 \$55 RESET_B|RST_B|SAMPLE A|B|BUSY|DOUT2|GND|VGND|VSS
+ A|B|BUSY|DOUT2|GND|VGND|VSS nfet L=0.15U W=0.42U AS=0.12495P AD=0.06405P
+ PS=1.015U PD=0.725U
* device instance $56 r0 *1 59.63,-136.845 nfet
M$56 \$49 \$48 \$55 A|B|BUSY|DOUT2|GND|VGND|VSS nfet L=0.15U W=0.42U
+ AS=0.06405P AD=0.1092P PS=0.725U PD=1.36U
* device instance $57 r0 *1 23.89,-135.955 nfet
M$57 A|B|BUSY|DOUT2|GND|VGND|VSS A|CLK|X \$63 A|B|BUSY|DOUT2|GND|VGND|VSS nfet
+ L=0.15U W=0.42U AS=0.1092P AD=0.0567P PS=1.36U PD=0.69U
* device instance $58 r0 *1 24.31,-135.955 nfet
M$58 \$64 \$63 A|B|BUSY|DOUT2|GND|VGND|VSS A|B|BUSY|DOUT2|GND|VGND|VSS nfet
+ L=0.15U W=0.42U AS=0.0567P AD=0.1092P PS=0.69U PD=1.36U
* device instance $59 r0 *1 26.06,-135.985 nfet
M$59 \$67 \$63 \$66 A|B|BUSY|DOUT2|GND|VGND|VSS nfet L=0.15U W=0.36U AS=0.066P
+ AD=0.0594P PS=0.745U PD=0.69U
* device instance $60 r0 *1 26.54,-135.985 nfet
M$60 \$87 \$64 \$67 A|B|BUSY|DOUT2|GND|VGND|VSS nfet L=0.15U W=0.36U AS=0.0594P
+ AD=0.1401P PS=0.69U PD=1.1U
* device instance $61 r0 *1 28.885,-135.985 nfet
M$61 \$69 \$64 \$68 A|B|BUSY|DOUT2|GND|VGND|VSS nfet L=0.15U W=0.36U AS=0.0999P
+ AD=0.0711P PS=0.985U PD=0.755U
* device instance $62 r0 *1 29.43,-135.985 nfet
M$62 \$89 \$63 \$69 A|B|BUSY|DOUT2|GND|VGND|VSS nfet L=0.15U W=0.36U AS=0.0711P
+ AD=0.0669P PS=0.755U PD=0.75U
* device instance $63 r0 *1 25.585,-135.955 nfet
M$63 \$66 B|D|PH_B4|Q|S A|B|BUSY|DOUT2|GND|VGND|VSS A|B|BUSY|DOUT2|GND|VGND|VSS
+ nfet L=0.15U W=0.42U AS=0.2205P AD=0.066P PS=1.89U PD=0.745U
* device instance $64 r0 *1 27.37,-135.955 nfet
M$64 \$88 \$68 \$87 A|B|BUSY|DOUT2|GND|VGND|VSS nfet L=0.15U W=0.42U AS=0.1401P
+ AD=0.0441P PS=1.1U PD=0.63U
* device instance $65 r0 *1 27.73,-135.955 nfet
M$65 A|B|BUSY|DOUT2|GND|VGND|VSS RESET_B|RST_B|SAMPLE \$88
+ A|B|BUSY|DOUT2|GND|VGND|VSS nfet L=0.15U W=0.42U AS=0.0441P AD=0.1346P
+ PS=0.63U PD=1.15U
* device instance $66 r0 *1 29.91,-135.955 nfet
M$66 A|B|BUSY|DOUT2|GND|VGND|VSS \$70 \$89 A|B|BUSY|DOUT2|GND|VGND|VSS nfet
+ L=0.15U W=0.42U AS=0.0669P AD=0.12495P PS=0.75U PD=1.015U
* device instance $67 r0 *1 30.655,-135.955 nfet
M$67 \$90 RESET_B|RST_B|SAMPLE A|B|BUSY|DOUT2|GND|VGND|VSS
+ A|B|BUSY|DOUT2|GND|VGND|VSS nfet L=0.15U W=0.42U AS=0.12495P AD=0.06405P
+ PS=1.015U PD=0.725U
* device instance $68 r0 *1 31.11,-135.955 nfet
M$68 \$70 \$69 \$90 A|B|BUSY|DOUT2|GND|VGND|VSS nfet L=0.15U W=0.42U
+ AS=0.06405P AD=0.1092P PS=0.725U PD=1.36U
* device instance $69 r0 *1 28.39,-135.845 nfet
M$69 \$68 \$67 A|B|BUSY|DOUT2|GND|VGND|VSS A|B|BUSY|DOUT2|GND|VGND|VSS nfet
+ L=0.15U W=0.64U AS=0.1346P AD=0.0999P PS=1.15U PD=0.985U
* device instance $70 r0 *1 32.15,-135.84 nfet
M$70 B|C|D|PH_B3|Q|S \$70 A|B|BUSY|DOUT2|GND|VGND|VSS
+ A|B|BUSY|DOUT2|GND|VGND|VSS nfet L=0.15U W=0.65U AS=0.2087P AD=0.169P
+ PS=2.02U PD=1.82U
* device instance $71 r0 *1 44.13,-135.955 nfet
M$71 A|B|BUSY|DOUT2|GND|VGND|VSS A|CLK|X \$74 A|B|BUSY|DOUT2|GND|VGND|VSS nfet
+ L=0.15U W=0.42U AS=0.1092P AD=0.0567P PS=1.36U PD=0.69U
* device instance $72 r0 *1 44.55,-135.955 nfet
M$72 \$75 \$74 A|B|BUSY|DOUT2|GND|VGND|VSS A|B|BUSY|DOUT2|GND|VGND|VSS nfet
+ L=0.15U W=0.42U AS=0.0567P AD=0.1092P PS=0.69U PD=1.36U
* device instance $73 r0 *1 46.3,-135.985 nfet
M$73 \$77 \$74 \$76 A|B|BUSY|DOUT2|GND|VGND|VSS nfet L=0.15U W=0.36U AS=0.066P
+ AD=0.0594P PS=0.745U PD=0.69U
* device instance $74 r0 *1 46.78,-135.985 nfet
M$74 \$93 \$75 \$77 A|B|BUSY|DOUT2|GND|VGND|VSS nfet L=0.15U W=0.36U AS=0.0594P
+ AD=0.1401P PS=0.69U PD=1.1U
* device instance $75 r0 *1 49.125,-135.985 nfet
M$75 \$79 \$75 \$78 A|B|BUSY|DOUT2|GND|VGND|VSS nfet L=0.15U W=0.36U AS=0.0999P
+ AD=0.0711P PS=0.985U PD=0.755U
* device instance $76 r0 *1 49.67,-135.985 nfet
M$76 \$95 \$74 \$79 A|B|BUSY|DOUT2|GND|VGND|VSS nfet L=0.15U W=0.36U AS=0.0711P
+ AD=0.0669P PS=0.755U PD=0.75U
* device instance $77 r0 *1 45.825,-135.955 nfet
M$77 \$76 D|X$3 A|B|BUSY|DOUT2|GND|VGND|VSS A|B|BUSY|DOUT2|GND|VGND|VSS nfet
+ L=0.15U W=0.42U AS=0.2205P AD=0.066P PS=1.89U PD=0.745U
* device instance $78 r0 *1 47.61,-135.955 nfet
M$78 \$94 \$78 \$93 A|B|BUSY|DOUT2|GND|VGND|VSS nfet L=0.15U W=0.42U AS=0.1401P
+ AD=0.0441P PS=1.1U PD=0.63U
* device instance $79 r0 *1 47.97,-135.955 nfet
M$79 A|B|BUSY|DOUT2|GND|VGND|VSS RESET_B|RST_B|SAMPLE \$94
+ A|B|BUSY|DOUT2|GND|VGND|VSS nfet L=0.15U W=0.42U AS=0.0441P AD=0.1346P
+ PS=0.63U PD=1.15U
* device instance $80 r0 *1 50.15,-135.955 nfet
M$80 A|B|BUSY|DOUT2|GND|VGND|VSS \$80 \$95 A|B|BUSY|DOUT2|GND|VGND|VSS nfet
+ L=0.15U W=0.42U AS=0.0669P AD=0.12495P PS=0.75U PD=1.015U
* device instance $81 r0 *1 50.895,-135.955 nfet
M$81 \$96 RESET_B|RST_B|SAMPLE A|B|BUSY|DOUT2|GND|VGND|VSS
+ A|B|BUSY|DOUT2|GND|VGND|VSS nfet L=0.15U W=0.42U AS=0.12495P AD=0.06405P
+ PS=1.015U PD=0.725U
* device instance $82 r0 *1 51.35,-135.955 nfet
M$82 \$80 \$79 \$96 A|B|BUSY|DOUT2|GND|VGND|VSS nfet L=0.15U W=0.42U
+ AS=0.06405P AD=0.1092P PS=0.725U PD=1.36U
* device instance $83 r0 *1 48.63,-135.845 nfet
M$83 \$78 \$77 A|B|BUSY|DOUT2|GND|VGND|VSS A|B|BUSY|DOUT2|GND|VGND|VSS nfet
+ L=0.15U W=0.64U AS=0.1346P AD=0.0999P PS=1.15U PD=0.985U
* device instance $84 r0 *1 52.39,-135.84 nfet
M$84 A0|DOUT4|Q \$80 A|B|BUSY|DOUT2|GND|VGND|VSS A|B|BUSY|DOUT2|GND|VGND|VSS
+ nfet L=0.15U W=0.65U AS=0.2087P AD=0.169P PS=2.02U PD=1.82U
* device instance $85 r0 *1 55.315,-135.955 nfet
M$85 \$83 B|C|D|PH_B7|Q|S A|B|BUSY|DOUT2|GND|VGND|VSS
+ A|B|BUSY|DOUT2|GND|VGND|VSS nfet L=0.15U W=0.42U AS=0.1092P AD=0.0567P
+ PS=1.36U PD=0.69U
* device instance $86 r0 *1 55.735,-135.955 nfet
M$86 A|B|BUSY|DOUT2|GND|VGND|VSS A|X$5 \$83 A|B|BUSY|DOUT2|GND|VGND|VSS nfet
+ L=0.15U W=0.42U AS=0.0567P AD=0.10025P PS=0.69U PD=0.985U
* device instance $87 r0 *1 56.22,-135.84 nfet
M$87 A|X$1 \$83 A|B|BUSY|DOUT2|GND|VGND|VSS A|B|BUSY|DOUT2|GND|VGND|VSS nfet
+ L=0.15U W=0.65U AS=0.10025P AD=0.169P PS=0.985U PD=1.82U
* device instance $88 r0 *1 58.475,-135.955 nfet
M$88 \$97 A|A_N|B|D|DOUT0|DOUT7|PH_B6|PH_B9|Q|S|VPB|VPWR
+ A|B|BUSY|DOUT2|GND|VGND|VSS A|B|BUSY|DOUT2|GND|VGND|VSS nfet L=0.15U W=0.42U
+ AS=0.11285P AD=0.0693P PS=1.045U PD=0.75U
* device instance $89 r0 *1 58.955,-135.955 nfet
M$89 \$85 A1|Y \$97 A|B|BUSY|DOUT2|GND|VGND|VSS nfet L=0.15U W=0.42U AS=0.0693P
+ AD=0.09975P PS=0.75U PD=0.895U
* device instance $90 r0 *1 59.58,-135.955 nfet
M$90 \$98 A0|DOUT6|Q \$85 A|B|BUSY|DOUT2|GND|VGND|VSS nfet L=0.15U W=0.42U
+ AS=0.09975P AD=0.0693P PS=0.895U PD=0.75U
* device instance $91 r0 *1 60.06,-135.955 nfet
M$91 A|B|BUSY|DOUT2|GND|VGND|VSS \$86 \$98 A|B|BUSY|DOUT2|GND|VGND|VSS nfet
+ L=0.15U W=0.42U AS=0.0693P AD=0.1449P PS=0.75U PD=1.11U
* device instance $92 r0 *1 60.9,-135.955 nfet
M$92 \$86 A|A_N|B|D|DOUT0|DOUT7|PH_B6|PH_B9|Q|S|VPB|VPWR
+ A|B|BUSY|DOUT2|GND|VGND|VSS A|B|BUSY|DOUT2|GND|VGND|VSS nfet L=0.15U W=0.42U
+ AS=0.1449P AD=0.1092P PS=1.11U PD=1.36U
* device instance $93 r0 *1 57.93,-135.84 nfet
M$93 A|B|BUSY|DOUT2|GND|VGND|VSS \$85 A|X$5 A|B|BUSY|DOUT2|GND|VGND|VSS nfet
+ L=0.15U W=0.65U AS=0.169P AD=0.11285P PS=1.82U PD=1.045U
* device instance $94 r0 *1 23.89,-130.515 nfet
M$94 A|B|BUSY|DOUT2|GND|VGND|VSS A|CLK|X \$132 A|B|BUSY|DOUT2|GND|VGND|VSS nfet
+ L=0.15U W=0.42U AS=0.1092P AD=0.0567P PS=1.36U PD=0.69U
* device instance $95 r0 *1 24.31,-130.515 nfet
M$95 \$133 \$132 A|B|BUSY|DOUT2|GND|VGND|VSS A|B|BUSY|DOUT2|GND|VGND|VSS nfet
+ L=0.15U W=0.42U AS=0.0567P AD=0.1092P PS=0.69U PD=1.36U
* device instance $96 r0 *1 26.06,-130.545 nfet
M$96 \$135 \$132 \$134 A|B|BUSY|DOUT2|GND|VGND|VSS nfet L=0.15U W=0.36U
+ AS=0.066P AD=0.0594P PS=0.745U PD=0.69U
* device instance $97 r0 *1 26.54,-130.545 nfet
M$97 \$157 \$133 \$135 A|B|BUSY|DOUT2|GND|VGND|VSS nfet L=0.15U W=0.36U
+ AS=0.0594P AD=0.1401P PS=0.69U PD=1.1U
* device instance $98 r0 *1 28.885,-130.545 nfet
M$98 \$137 \$133 \$136 A|B|BUSY|DOUT2|GND|VGND|VSS nfet L=0.15U W=0.36U
+ AS=0.0999P AD=0.0711P PS=0.985U PD=0.755U
* device instance $99 r0 *1 29.43,-130.545 nfet
M$99 \$159 \$132 \$137 A|B|BUSY|DOUT2|GND|VGND|VSS nfet L=0.15U W=0.36U
+ AS=0.0711P AD=0.0669P PS=0.755U PD=0.75U
* device instance $100 r0 *1 25.585,-130.515 nfet
M$100 \$134 B|C|D|PH_B3|Q|S A|B|BUSY|DOUT2|GND|VGND|VSS
+ A|B|BUSY|DOUT2|GND|VGND|VSS nfet L=0.15U W=0.42U AS=0.2205P AD=0.066P
+ PS=1.89U PD=0.745U
* device instance $101 r0 *1 27.37,-130.515 nfet
M$101 \$158 \$136 \$157 A|B|BUSY|DOUT2|GND|VGND|VSS nfet L=0.15U W=0.42U
+ AS=0.1401P AD=0.0441P PS=1.1U PD=0.63U
* device instance $102 r0 *1 27.73,-130.515 nfet
M$102 A|B|BUSY|DOUT2|GND|VGND|VSS RESET_B|RST_B|SAMPLE \$158
+ A|B|BUSY|DOUT2|GND|VGND|VSS nfet L=0.15U W=0.42U AS=0.0441P AD=0.1346P
+ PS=0.63U PD=1.15U
* device instance $103 r0 *1 29.91,-130.515 nfet
M$103 A|B|BUSY|DOUT2|GND|VGND|VSS \$138 \$159 A|B|BUSY|DOUT2|GND|VGND|VSS nfet
+ L=0.15U W=0.42U AS=0.0669P AD=0.12495P PS=0.75U PD=1.015U
* device instance $104 r0 *1 30.655,-130.515 nfet
M$104 \$160 RESET_B|RST_B|SAMPLE A|B|BUSY|DOUT2|GND|VGND|VSS
+ A|B|BUSY|DOUT2|GND|VGND|VSS nfet L=0.15U W=0.42U AS=0.12495P AD=0.06405P
+ PS=1.015U PD=0.725U
* device instance $105 r0 *1 31.11,-130.515 nfet
M$105 \$138 \$137 \$160 A|B|BUSY|DOUT2|GND|VGND|VSS nfet L=0.15U W=0.42U
+ AS=0.06405P AD=0.1092P PS=0.725U PD=1.36U
* device instance $106 r0 *1 28.39,-130.405 nfet
M$106 \$136 \$135 A|B|BUSY|DOUT2|GND|VGND|VSS A|B|BUSY|DOUT2|GND|VGND|VSS nfet
+ L=0.15U W=0.64U AS=0.1346P AD=0.0999P PS=1.15U PD=0.985U
* device instance $107 r0 *1 30.33,-131.52 nfet
M$107 A|B|BUSY|DOUT2|GND|VGND|VSS \$106 A|X$2 A|B|BUSY|DOUT2|GND|VGND|VSS nfet
+ L=0.15U W=0.65U AS=0.169P AD=0.11285P PS=1.82U PD=1.045U
* device instance $108 r0 *1 30.875,-131.405 nfet
M$108 \$123 B|C|D|PH_B3|Q|S A|B|BUSY|DOUT2|GND|VGND|VSS
+ A|B|BUSY|DOUT2|GND|VGND|VSS nfet L=0.15U W=0.42U AS=0.11285P AD=0.0693P
+ PS=1.045U PD=0.75U
* device instance $109 r0 *1 31.355,-131.405 nfet
M$109 \$106 A1|Y \$123 A|B|BUSY|DOUT2|GND|VGND|VSS nfet L=0.15U W=0.42U
+ AS=0.0693P AD=0.09975P PS=0.75U PD=0.895U
* device instance $110 r0 *1 31.98,-131.405 nfet
M$110 \$124 A0|DOUT3|Q \$106 A|B|BUSY|DOUT2|GND|VGND|VSS nfet L=0.15U W=0.42U
+ AS=0.09975P AD=0.0693P PS=0.895U PD=0.75U
* device instance $111 r0 *1 32.46,-131.405 nfet
M$111 A|B|BUSY|DOUT2|GND|VGND|VSS \$109 \$124 A|B|BUSY|DOUT2|GND|VGND|VSS nfet
+ L=0.15U W=0.42U AS=0.0693P AD=0.1449P PS=0.75U PD=1.11U
* device instance $112 r0 *1 33.3,-131.405 nfet
M$112 \$109 B|C|D|PH_B3|Q|S A|B|BUSY|DOUT2|GND|VGND|VSS
+ A|B|BUSY|DOUT2|GND|VGND|VSS nfet L=0.15U W=0.42U AS=0.1449P AD=0.1092P
+ PS=1.11U PD=1.36U
* device instance $113 r0 *1 32.15,-130.4 nfet
M$113 B|D|PH_B2|Q|S \$138 A|B|BUSY|DOUT2|GND|VGND|VSS
+ A|B|BUSY|DOUT2|GND|VGND|VSS nfet L=0.15U W=0.65U AS=0.2087P AD=0.169P
+ PS=2.02U PD=1.82U
* device instance $114 r0 *1 35.11,-135.815 nfet
M$114 \$91 A|X$3 \$72 A|B|BUSY|DOUT2|GND|VGND|VSS nfet L=0.15U W=0.42U
+ AS=0.1176P AD=0.0567P PS=1.4U PD=0.69U
* device instance $115 r0 *1 35.53,-135.815 nfet
M$115 \$91 B|X A|B|BUSY|DOUT2|GND|VGND|VSS A|B|BUSY|DOUT2|GND|VGND|VSS nfet
+ L=0.15U W=0.42U AS=0.1118P AD=0.0567P PS=1.04U PD=0.69U
* device instance $116 r0 *1 36.07,-135.84 nfet
M$116 D|X$2 \$72 A|B|BUSY|DOUT2|GND|VGND|VSS A|B|BUSY|DOUT2|GND|VGND|VSS nfet
+ L=0.15U W=0.65U AS=0.1118P AD=0.182P PS=1.04U PD=1.86U
* device instance $117 r0 *1 35.995,-131.405 nfet
M$117 \$110 A|A_N|B|D|DOUT0|DOUT7|PH_B6|PH_B9|Q|S|VPB|VPWR
+ A|B|BUSY|DOUT2|GND|VGND|VSS A|B|BUSY|DOUT2|GND|VGND|VSS nfet L=0.15U W=0.42U
+ AS=0.1092P AD=0.0567P PS=1.36U PD=0.69U
* device instance $118 r0 *1 36.415,-131.405 nfet
M$118 \$110 A|X$6 A|B|BUSY|DOUT2|GND|VGND|VSS A|B|BUSY|DOUT2|GND|VGND|VSS nfet
+ L=0.15U W=0.42U AS=0.10025P AD=0.0567P PS=0.985U PD=0.69U
* device instance $119 r0 *1 36.9,-131.52 nfet
M$119 A|X$7 \$110 A|B|BUSY|DOUT2|GND|VGND|VSS A|B|BUSY|DOUT2|GND|VGND|VSS nfet
+ L=0.15U W=0.65U AS=0.10025P AD=0.169P PS=0.985U PD=1.82U
* device instance $120 r0 *1 38.33,-135.815 nfet
M$120 \$92 A|X$7 \$73 A|B|BUSY|DOUT2|GND|VGND|VSS nfet L=0.15U W=0.42U
+ AS=0.1176P AD=0.0567P PS=1.4U PD=0.69U
* device instance $121 r0 *1 38.75,-135.815 nfet
M$121 \$92 B|X A|B|BUSY|DOUT2|GND|VGND|VSS A|B|BUSY|DOUT2|GND|VGND|VSS nfet
+ L=0.15U W=0.42U AS=0.1118P AD=0.0567P PS=1.04U PD=0.69U
* device instance $122 r0 *1 39.29,-135.84 nfet
M$122 D|X \$73 A|B|BUSY|DOUT2|GND|VGND|VSS A|B|BUSY|DOUT2|GND|VGND|VSS nfet
+ L=0.15U W=0.65U AS=0.1118P AD=0.182P PS=1.04U PD=1.86U
* device instance $123 r0 *1 40,-131.405 nfet
M$123 Y A|CLK|X A|B|BUSY|DOUT2|GND|VGND|VSS A|B|BUSY|DOUT2|GND|VGND|VSS nfet
+ L=0.15U W=0.42U AS=0.1113P AD=0.0588P PS=1.37U PD=0.7U
* device instance $124 r0 *1 40.43,-131.405 nfet
M$124 A|B|BUSY|DOUT2|GND|VGND|VSS A|CLK|X Y A|B|BUSY|DOUT2|GND|VGND|VSS nfet
+ L=0.15U W=0.42U AS=0.0588P AD=0.1092P PS=0.7U PD=1.36U
* device instance $125 r0 *1 40.45,-130.4 nfet
M$125 A|B|BUSY|DOUT2|GND|VGND|VSS A|CLK \$141 A|B|BUSY|DOUT2|GND|VGND|VSS nfet
+ L=0.15U W=0.65U AS=0.169P AD=0.08775P PS=1.82U PD=0.92U
* device instance $126 r0 *1 40.87,-130.4 nfet
M$126 A|X \$141 A|B|BUSY|DOUT2|GND|VGND|VSS A|B|BUSY|DOUT2|GND|VGND|VSS nfet
+ L=0.15U W=0.65U AS=0.08775P AD=0.08775P PS=0.92U PD=0.92U
* device instance $127 r0 *1 41.29,-130.4 nfet
M$127 A|B|BUSY|DOUT2|GND|VGND|VSS \$141 A|X A|B|BUSY|DOUT2|GND|VGND|VSS nfet
+ L=0.15U W=0.65U AS=0.08775P AD=0.08775P PS=0.92U PD=0.92U
* device instance $128 r0 *1 41.71,-130.4 nfet
M$128 A|X \$141 A|B|BUSY|DOUT2|GND|VGND|VSS A|B|BUSY|DOUT2|GND|VGND|VSS nfet
+ L=0.15U W=0.65U AS=0.08775P AD=0.08775P PS=0.92U PD=0.92U
* device instance $129 r0 *1 42.13,-130.4 nfet
M$129 A|B|BUSY|DOUT2|GND|VGND|VSS \$141 A|X A|B|BUSY|DOUT2|GND|VGND|VSS nfet
+ L=0.15U W=0.65U AS=0.08775P AD=0.169P PS=0.92U PD=1.82U
* device instance $130 r0 *1 44.675,-130.515 nfet
M$130 \$161 B|D|PH_B4|Q|S A|B|BUSY|DOUT2|GND|VGND|VSS
+ A|B|BUSY|DOUT2|GND|VGND|VSS nfet L=0.15U W=0.42U AS=0.11285P AD=0.0693P
+ PS=1.045U PD=0.75U
* device instance $131 r0 *1 45.155,-130.515 nfet
M$131 \$142 A1|Y \$161 A|B|BUSY|DOUT2|GND|VGND|VSS nfet L=0.15U W=0.42U
+ AS=0.0693P AD=0.09975P PS=0.75U PD=0.895U
* device instance $132 r0 *1 45.78,-130.515 nfet
M$132 \$162 A0|DOUT4|Q \$142 A|B|BUSY|DOUT2|GND|VGND|VSS nfet L=0.15U W=0.42U
+ AS=0.09975P AD=0.0693P PS=0.895U PD=0.75U
* device instance $133 r0 *1 46.26,-130.515 nfet
M$133 A|B|BUSY|DOUT2|GND|VGND|VSS \$143 \$162 A|B|BUSY|DOUT2|GND|VGND|VSS nfet
+ L=0.15U W=0.42U AS=0.0693P AD=0.1449P PS=0.75U PD=1.11U
* device instance $134 r0 *1 47.1,-130.515 nfet
M$134 \$143 B|D|PH_B4|Q|S A|B|BUSY|DOUT2|GND|VGND|VSS
+ A|B|BUSY|DOUT2|GND|VGND|VSS nfet L=0.15U W=0.42U AS=0.1449P AD=0.1092P
+ PS=1.11U PD=1.36U
* device instance $135 r0 *1 44.13,-130.4 nfet
M$135 A|B|BUSY|DOUT2|GND|VGND|VSS \$142 A|X$10 A|B|BUSY|DOUT2|GND|VGND|VSS nfet
+ L=0.15U W=0.65U AS=0.169P AD=0.11285P PS=1.82U PD=1.045U
* device instance $136 r0 *1 49.335,-130.515 nfet
M$136 \$144 B|C|D|PH_B3|Q|S A|B|BUSY|DOUT2|GND|VGND|VSS
+ A|B|BUSY|DOUT2|GND|VGND|VSS nfet L=0.15U W=0.42U AS=0.1092P AD=0.0567P
+ PS=1.36U PD=0.69U
* device instance $137 r0 *1 49.755,-130.515 nfet
M$137 A|B|BUSY|DOUT2|GND|VGND|VSS A|X$8 \$144 A|B|BUSY|DOUT2|GND|VGND|VSS nfet
+ L=0.15U W=0.42U AS=0.0567P AD=0.10025P PS=0.69U PD=0.985U
* device instance $138 r0 *1 50.24,-130.4 nfet
M$138 A|X$9 \$144 A|B|BUSY|DOUT2|GND|VGND|VSS A|B|BUSY|DOUT2|GND|VGND|VSS nfet
+ L=0.15U W=0.65U AS=0.10025P AD=0.169P PS=0.985U PD=1.82U
* device instance $139 r0 *1 54.25,-130.515 nfet
M$139 A|B|BUSY|DOUT2|GND|VGND|VSS A|CLK|X \$149 A|B|BUSY|DOUT2|GND|VGND|VSS
+ nfet L=0.15U W=0.42U AS=0.1092P AD=0.0567P PS=1.36U PD=0.69U
* device instance $140 r0 *1 54.67,-130.515 nfet
M$140 \$150 \$149 A|B|BUSY|DOUT2|GND|VGND|VSS A|B|BUSY|DOUT2|GND|VGND|VSS nfet
+ L=0.15U W=0.42U AS=0.0567P AD=0.1092P PS=0.69U PD=1.36U
* device instance $141 r0 *1 56.42,-130.545 nfet
M$141 \$152 \$149 \$151 A|B|BUSY|DOUT2|GND|VGND|VSS nfet L=0.15U W=0.36U
+ AS=0.066P AD=0.0594P PS=0.745U PD=0.69U
* device instance $142 r0 *1 56.9,-130.545 nfet
M$142 \$164 \$150 \$152 A|B|BUSY|DOUT2|GND|VGND|VSS nfet L=0.15U W=0.36U
+ AS=0.0594P AD=0.1401P PS=0.69U PD=1.1U
* device instance $143 r0 *1 59.245,-130.545 nfet
M$143 \$154 \$150 \$153 A|B|BUSY|DOUT2|GND|VGND|VSS nfet L=0.15U W=0.36U
+ AS=0.0999P AD=0.0711P PS=0.985U PD=0.755U
* device instance $144 r0 *1 59.79,-130.545 nfet
M$144 \$166 \$149 \$154 A|B|BUSY|DOUT2|GND|VGND|VSS nfet L=0.15U W=0.36U
+ AS=0.0711P AD=0.0669P PS=0.755U PD=0.75U
* device instance $145 r0 *1 55.945,-130.515 nfet
M$145 \$151 D|X$4 A|B|BUSY|DOUT2|GND|VGND|VSS A|B|BUSY|DOUT2|GND|VGND|VSS nfet
+ L=0.15U W=0.42U AS=0.2205P AD=0.066P PS=1.89U PD=0.745U
* device instance $146 r0 *1 57.73,-130.515 nfet
M$146 \$165 \$153 \$164 A|B|BUSY|DOUT2|GND|VGND|VSS nfet L=0.15U W=0.42U
+ AS=0.1401P AD=0.0441P PS=1.1U PD=0.63U
* device instance $147 r0 *1 58.09,-130.515 nfet
M$147 A|B|BUSY|DOUT2|GND|VGND|VSS RESET_B|RST_B|SAMPLE \$165
+ A|B|BUSY|DOUT2|GND|VGND|VSS nfet L=0.15U W=0.42U AS=0.0441P AD=0.1346P
+ PS=0.63U PD=1.15U
* device instance $148 r0 *1 60.27,-130.515 nfet
M$148 A|B|BUSY|DOUT2|GND|VGND|VSS \$155 \$166 A|B|BUSY|DOUT2|GND|VGND|VSS nfet
+ L=0.15U W=0.42U AS=0.0669P AD=0.12495P PS=0.75U PD=1.015U
* device instance $149 r0 *1 61.015,-130.515 nfet
M$149 \$167 RESET_B|RST_B|SAMPLE A|B|BUSY|DOUT2|GND|VGND|VSS
+ A|B|BUSY|DOUT2|GND|VGND|VSS nfet L=0.15U W=0.42U AS=0.12495P AD=0.06405P
+ PS=1.015U PD=0.725U
* device instance $150 r0 *1 61.47,-130.515 nfet
M$150 \$155 \$154 \$167 A|B|BUSY|DOUT2|GND|VGND|VSS nfet L=0.15U W=0.42U
+ AS=0.06405P AD=0.1092P PS=0.725U PD=1.36U
* device instance $151 r0 *1 58.75,-130.405 nfet
M$151 \$153 \$152 A|B|BUSY|DOUT2|GND|VGND|VSS A|B|BUSY|DOUT2|GND|VGND|VSS nfet
+ L=0.15U W=0.64U AS=0.1346P AD=0.0999P PS=1.15U PD=0.985U
* device instance $152 r0 *1 56.55,-131.405 nfet
M$152 A|B|BUSY|DOUT2|GND|VGND|VSS A|CLK|X \$114 A|B|BUSY|DOUT2|GND|VGND|VSS
+ nfet L=0.15U W=0.42U AS=0.1092P AD=0.0567P PS=1.36U PD=0.69U
* device instance $153 r0 *1 56.97,-131.405 nfet
M$153 \$115 \$114 A|B|BUSY|DOUT2|GND|VGND|VSS A|B|BUSY|DOUT2|GND|VGND|VSS nfet
+ L=0.15U W=0.42U AS=0.0567P AD=0.1092P PS=0.69U PD=1.36U
* device instance $154 r0 *1 58.245,-131.405 nfet
M$154 \$116 B|C|D|PH_B7|Q|S A|B|BUSY|DOUT2|GND|VGND|VSS
+ A|B|BUSY|DOUT2|GND|VGND|VSS nfet L=0.15U W=0.42U AS=0.2205P AD=0.066P
+ PS=1.89U PD=0.745U
* device instance $155 r0 *1 58.72,-131.375 nfet
M$155 \$117 \$114 \$116 A|B|BUSY|DOUT2|GND|VGND|VSS nfet L=0.15U W=0.36U
+ AS=0.066P AD=0.0594P PS=0.745U PD=0.69U
* device instance $156 r0 *1 59.2,-131.375 nfet
M$156 \$117 \$115 \$127 A|B|BUSY|DOUT2|GND|VGND|VSS nfet L=0.15U W=0.36U
+ AS=0.1401P AD=0.0594P PS=1.1U PD=0.69U
* device instance $157 r0 *1 60.03,-131.405 nfet
M$157 \$128 \$119 \$127 A|B|BUSY|DOUT2|GND|VGND|VSS nfet L=0.15U W=0.42U
+ AS=0.1401P AD=0.0441P PS=1.1U PD=0.63U
* device instance $158 r0 *1 60.39,-131.405 nfet
M$158 \$128 RESET_B|RST_B|SAMPLE A|B|BUSY|DOUT2|GND|VGND|VSS
+ A|B|BUSY|DOUT2|GND|VGND|VSS nfet L=0.15U W=0.42U AS=0.1346P AD=0.0441P
+ PS=1.15U PD=0.63U
* device instance $159 r0 *1 61.05,-131.515 nfet
M$159 \$119 \$117 A|B|BUSY|DOUT2|GND|VGND|VSS A|B|BUSY|DOUT2|GND|VGND|VSS nfet
+ L=0.15U W=0.64U AS=0.1346P AD=0.0999P PS=1.15U PD=0.985U
* device instance $160 r0 *1 61.545,-131.375 nfet
M$160 \$120 \$115 \$119 A|B|BUSY|DOUT2|GND|VGND|VSS nfet L=0.15U W=0.36U
+ AS=0.0999P AD=0.0711P PS=0.985U PD=0.755U
* device instance $161 r0 *1 62.09,-131.375 nfet
M$161 \$120 \$114 \$130 A|B|BUSY|DOUT2|GND|VGND|VSS nfet L=0.15U W=0.36U
+ AS=0.0669P AD=0.0711P PS=0.75U PD=0.755U
* device instance $162 r0 *1 62.57,-131.405 nfet
M$162 A|B|BUSY|DOUT2|GND|VGND|VSS \$121 \$130 A|B|BUSY|DOUT2|GND|VGND|VSS nfet
+ L=0.15U W=0.42U AS=0.0669P AD=0.12495P PS=0.75U PD=1.015U
* device instance $163 r0 *1 63.315,-131.405 nfet
M$163 \$131 RESET_B|RST_B|SAMPLE A|B|BUSY|DOUT2|GND|VGND|VSS
+ A|B|BUSY|DOUT2|GND|VGND|VSS nfet L=0.15U W=0.42U AS=0.12495P AD=0.06405P
+ PS=1.015U PD=0.725U
* device instance $164 r0 *1 63.77,-131.405 nfet
M$164 \$121 \$120 \$131 A|B|BUSY|DOUT2|GND|VGND|VSS nfet L=0.15U W=0.42U
+ AS=0.06405P AD=0.1092P PS=0.725U PD=1.36U
* device instance $165 r0 *1 62.51,-130.4 nfet
M$165 A0|DOUT2|Q \$155 A|B|BUSY|DOUT2|GND|VGND|VSS A|B|BUSY|DOUT2|GND|VGND|VSS
+ nfet L=0.15U W=0.65U AS=0.2087P AD=0.169P PS=2.02U PD=1.82U
* device instance $166 r0 *1 64.81,-131.52 nfet
M$166 A|A_N|B|D|DOUT0|DOUT7|PH_B6|PH_B9|Q|S|VPB|VPWR \$121
+ A|B|BUSY|DOUT2|GND|VGND|VSS A|B|BUSY|DOUT2|GND|VGND|VSS nfet L=0.15U W=0.65U
+ AS=0.2087P AD=0.169P PS=2.02U PD=1.82U
* device instance $167 r0 *1 23.89,-125.075 nfet
M$167 A|B|BUSY|DOUT2|GND|VGND|VSS CLK|X \$193 A|B|BUSY|DOUT2|GND|VGND|VSS nfet
+ L=0.15U W=0.42U AS=0.1092P AD=0.0567P PS=1.36U PD=0.69U
* device instance $168 r0 *1 24.31,-125.075 nfet
M$168 \$194 \$193 A|B|BUSY|DOUT2|GND|VGND|VSS A|B|BUSY|DOUT2|GND|VGND|VSS nfet
+ L=0.15U W=0.42U AS=0.0567P AD=0.1092P PS=0.69U PD=1.36U
* device instance $169 r0 *1 26.06,-125.105 nfet
M$169 \$196 \$193 \$195 A|B|BUSY|DOUT2|GND|VGND|VSS nfet L=0.15U W=0.36U
+ AS=0.066P AD=0.0594P PS=0.745U PD=0.69U
* device instance $170 r0 *1 26.54,-125.105 nfet
M$170 \$222 \$194 \$196 A|B|BUSY|DOUT2|GND|VGND|VSS nfet L=0.15U W=0.36U
+ AS=0.0594P AD=0.1401P PS=0.69U PD=1.1U
* device instance $171 r0 *1 28.885,-125.105 nfet
M$171 \$198 \$194 \$197 A|B|BUSY|DOUT2|GND|VGND|VSS nfet L=0.15U W=0.36U
+ AS=0.0999P AD=0.0711P PS=0.985U PD=0.755U
* device instance $172 r0 *1 29.43,-125.105 nfet
M$172 \$224 \$193 \$198 A|B|BUSY|DOUT2|GND|VGND|VSS nfet L=0.15U W=0.36U
+ AS=0.0711P AD=0.0669P PS=0.755U PD=0.75U
* device instance $173 r0 *1 25.585,-125.075 nfet
M$173 \$195 B|D|PH_B2|Q|S A|B|BUSY|DOUT2|GND|VGND|VSS
+ A|B|BUSY|DOUT2|GND|VGND|VSS nfet L=0.15U W=0.42U AS=0.2205P AD=0.066P
+ PS=1.89U PD=0.745U
* device instance $174 r0 *1 27.37,-125.075 nfet
M$174 \$223 \$197 \$222 A|B|BUSY|DOUT2|GND|VGND|VSS nfet L=0.15U W=0.42U
+ AS=0.1401P AD=0.0441P PS=1.1U PD=0.63U
* device instance $175 r0 *1 27.73,-125.075 nfet
M$175 A|B|BUSY|DOUT2|GND|VGND|VSS RESET_B|RST_B|SAMPLE \$223
+ A|B|BUSY|DOUT2|GND|VGND|VSS nfet L=0.15U W=0.42U AS=0.0441P AD=0.1346P
+ PS=0.63U PD=1.15U
* device instance $176 r0 *1 29.91,-125.075 nfet
M$176 A|B|BUSY|DOUT2|GND|VGND|VSS \$199 \$224 A|B|BUSY|DOUT2|GND|VGND|VSS nfet
+ L=0.15U W=0.42U AS=0.0669P AD=0.12495P PS=0.75U PD=1.015U
* device instance $177 r0 *1 30.655,-125.075 nfet
M$177 \$225 RESET_B|RST_B|SAMPLE A|B|BUSY|DOUT2|GND|VGND|VSS
+ A|B|BUSY|DOUT2|GND|VGND|VSS nfet L=0.15U W=0.42U AS=0.12495P AD=0.06405P
+ PS=1.015U PD=0.725U
* device instance $178 r0 *1 31.11,-125.075 nfet
M$178 \$199 \$198 \$225 A|B|BUSY|DOUT2|GND|VGND|VSS nfet L=0.15U W=0.42U
+ AS=0.06405P AD=0.1092P PS=0.725U PD=1.36U
* device instance $179 r0 *1 28.39,-124.965 nfet
M$179 \$197 \$196 A|B|BUSY|DOUT2|GND|VGND|VSS A|B|BUSY|DOUT2|GND|VGND|VSS nfet
+ L=0.15U W=0.64U AS=0.1346P AD=0.0999P PS=1.15U PD=0.985U
* device instance $180 r0 *1 31.25,-125.965 nfet
M$180 A|B|BUSY|DOUT2|GND|VGND|VSS A|CLK|X \$176 A|B|BUSY|DOUT2|GND|VGND|VSS
+ nfet L=0.15U W=0.42U AS=0.1092P AD=0.0567P PS=1.36U PD=0.69U
* device instance $181 r0 *1 31.67,-125.965 nfet
M$181 \$177 \$176 A|B|BUSY|DOUT2|GND|VGND|VSS A|B|BUSY|DOUT2|GND|VGND|VSS nfet
+ L=0.15U W=0.42U AS=0.0567P AD=0.1092P PS=0.69U PD=1.36U
* device instance $182 r0 *1 32.15,-124.96 nfet
M$182 A|B|D|PH_B1|Q|S \$199 A|B|BUSY|DOUT2|GND|VGND|VSS
+ A|B|BUSY|DOUT2|GND|VGND|VSS nfet L=0.15U W=0.65U AS=0.2087P AD=0.169P
+ PS=2.02U PD=1.82U
* device instance $183 r0 *1 32.945,-125.965 nfet
M$183 \$178 A|A_N|B|D|DOUT0|DOUT7|PH_B6|PH_B9|Q|S|VPB|VPWR
+ A|B|BUSY|DOUT2|GND|VGND|VSS A|B|BUSY|DOUT2|GND|VGND|VSS nfet L=0.15U W=0.42U
+ AS=0.2205P AD=0.066P PS=1.89U PD=0.745U
* device instance $184 r0 *1 33.42,-125.935 nfet
M$184 \$179 \$176 \$178 A|B|BUSY|DOUT2|GND|VGND|VSS nfet L=0.15U W=0.36U
+ AS=0.066P AD=0.0594P PS=0.745U PD=0.69U
* device instance $185 r0 *1 33.9,-125.935 nfet
M$185 \$179 \$177 \$187 A|B|BUSY|DOUT2|GND|VGND|VSS nfet L=0.15U W=0.36U
+ AS=0.1401P AD=0.0594P PS=1.1U PD=0.69U
* device instance $186 r0 *1 34.73,-125.965 nfet
M$186 \$188 \$181 \$187 A|B|BUSY|DOUT2|GND|VGND|VSS nfet L=0.15U W=0.42U
+ AS=0.1401P AD=0.0441P PS=1.1U PD=0.63U
* device instance $187 r0 *1 35.09,-125.965 nfet
M$187 \$188 RESET_B|RST_B|SAMPLE A|B|BUSY|DOUT2|GND|VGND|VSS
+ A|B|BUSY|DOUT2|GND|VGND|VSS nfet L=0.15U W=0.42U AS=0.1346P AD=0.0441P
+ PS=1.15U PD=0.63U
* device instance $188 r0 *1 35.75,-126.075 nfet
M$188 \$181 \$179 A|B|BUSY|DOUT2|GND|VGND|VSS A|B|BUSY|DOUT2|GND|VGND|VSS nfet
+ L=0.15U W=0.64U AS=0.1346P AD=0.0999P PS=1.15U PD=0.985U
* device instance $189 r0 *1 36.245,-125.935 nfet
M$189 \$182 \$177 \$181 A|B|BUSY|DOUT2|GND|VGND|VSS nfet L=0.15U W=0.36U
+ AS=0.0999P AD=0.0711P PS=0.985U PD=0.755U
* device instance $190 r0 *1 36.79,-125.935 nfet
M$190 \$182 \$176 \$189 A|B|BUSY|DOUT2|GND|VGND|VSS nfet L=0.15U W=0.36U
+ AS=0.0669P AD=0.0711P PS=0.75U PD=0.755U
* device instance $191 r0 *1 37.27,-125.965 nfet
M$191 A|B|BUSY|DOUT2|GND|VGND|VSS \$183 \$189 A|B|BUSY|DOUT2|GND|VGND|VSS nfet
+ L=0.15U W=0.42U AS=0.0669P AD=0.12495P PS=0.75U PD=1.015U
* device instance $192 r0 *1 38.015,-125.965 nfet
M$192 \$191 RESET_B|RST_B|SAMPLE A|B|BUSY|DOUT2|GND|VGND|VSS
+ A|B|BUSY|DOUT2|GND|VGND|VSS nfet L=0.15U W=0.42U AS=0.12495P AD=0.06405P
+ PS=1.015U PD=0.725U
* device instance $193 r0 *1 38.47,-125.965 nfet
M$193 \$183 \$182 \$191 A|B|BUSY|DOUT2|GND|VGND|VSS nfet L=0.15U W=0.42U
+ AS=0.06405P AD=0.1092P PS=0.725U PD=1.36U
* device instance $194 r0 *1 38.61,-125.075 nfet
M$194 A|B|BUSY|DOUT2|GND|VGND|VSS CLK|X \$202 A|B|BUSY|DOUT2|GND|VGND|VSS nfet
+ L=0.15U W=0.42U AS=0.1092P AD=0.0567P PS=1.36U PD=0.69U
* device instance $195 r0 *1 39.03,-125.075 nfet
M$195 \$203 \$202 A|B|BUSY|DOUT2|GND|VGND|VSS A|B|BUSY|DOUT2|GND|VGND|VSS nfet
+ L=0.15U W=0.42U AS=0.0567P AD=0.1092P PS=0.69U PD=1.36U
* device instance $196 r0 *1 39.51,-126.08 nfet
M$196 A|B|D|PH_B5|Q|S \$183 A|B|BUSY|DOUT2|GND|VGND|VSS
+ A|B|BUSY|DOUT2|GND|VGND|VSS nfet L=0.15U W=0.65U AS=0.2087P AD=0.169P
+ PS=2.02U PD=1.82U
* device instance $197 r0 *1 40.78,-125.105 nfet
M$197 \$205 \$202 \$204 A|B|BUSY|DOUT2|GND|VGND|VSS nfet L=0.15U W=0.36U
+ AS=0.066P AD=0.0594P PS=0.745U PD=0.69U
* device instance $198 r0 *1 41.26,-125.105 nfet
M$198 \$226 \$203 \$205 A|B|BUSY|DOUT2|GND|VGND|VSS nfet L=0.15U W=0.36U
+ AS=0.0594P AD=0.1401P PS=0.69U PD=1.1U
* device instance $199 r0 *1 43.605,-125.105 nfet
M$199 \$207 \$203 \$206 A|B|BUSY|DOUT2|GND|VGND|VSS nfet L=0.15U W=0.36U
+ AS=0.0999P AD=0.0711P PS=0.985U PD=0.755U
* device instance $200 r0 *1 44.15,-125.105 nfet
M$200 \$228 \$202 \$207 A|B|BUSY|DOUT2|GND|VGND|VSS nfet L=0.15U W=0.36U
+ AS=0.0711P AD=0.0669P PS=0.755U PD=0.75U
* device instance $201 r0 *1 40.305,-125.075 nfet
M$201 \$204 A|B|D|PH_B5|Q|S A|B|BUSY|DOUT2|GND|VGND|VSS
+ A|B|BUSY|DOUT2|GND|VGND|VSS nfet L=0.15U W=0.42U AS=0.2205P AD=0.066P
+ PS=1.89U PD=0.745U
* device instance $202 r0 *1 42.09,-125.075 nfet
M$202 \$227 \$206 \$226 A|B|BUSY|DOUT2|GND|VGND|VSS nfet L=0.15U W=0.42U
+ AS=0.1401P AD=0.0441P PS=1.1U PD=0.63U
* device instance $203 r0 *1 42.45,-125.075 nfet
M$203 A|B|BUSY|DOUT2|GND|VGND|VSS RESET_B|RST_B|SAMPLE \$227
+ A|B|BUSY|DOUT2|GND|VGND|VSS nfet L=0.15U W=0.42U AS=0.0441P AD=0.1346P
+ PS=0.63U PD=1.15U
* device instance $204 r0 *1 44.63,-125.075 nfet
M$204 A|B|BUSY|DOUT2|GND|VGND|VSS \$208 \$228 A|B|BUSY|DOUT2|GND|VGND|VSS nfet
+ L=0.15U W=0.42U AS=0.0669P AD=0.12495P PS=0.75U PD=1.015U
* device instance $205 r0 *1 45.375,-125.075 nfet
M$205 \$229 RESET_B|RST_B|SAMPLE A|B|BUSY|DOUT2|GND|VGND|VSS
+ A|B|BUSY|DOUT2|GND|VGND|VSS nfet L=0.15U W=0.42U AS=0.12495P AD=0.06405P
+ PS=1.015U PD=0.725U
* device instance $206 r0 *1 45.83,-125.075 nfet
M$206 \$208 \$207 \$229 A|B|BUSY|DOUT2|GND|VGND|VSS nfet L=0.15U W=0.42U
+ AS=0.06405P AD=0.1092P PS=0.725U PD=1.36U
* device instance $207 r0 *1 43.11,-124.965 nfet
M$207 \$206 \$205 A|B|BUSY|DOUT2|GND|VGND|VSS A|B|BUSY|DOUT2|GND|VGND|VSS nfet
+ L=0.15U W=0.64U AS=0.1346P AD=0.0999P PS=1.15U PD=0.985U
* device instance $208 r0 *1 41.055,-125.965 nfet
M$208 \$185 A|B|D|PH_B5|Q|S A|B|BUSY|DOUT2|GND|VGND|VSS
+ A|B|BUSY|DOUT2|GND|VGND|VSS nfet L=0.15U W=0.42U AS=0.1092P AD=0.0567P
+ PS=1.36U PD=0.69U
* device instance $209 r0 *1 41.475,-125.965 nfet
M$209 \$185 A|X$10 A|B|BUSY|DOUT2|GND|VGND|VSS A|B|BUSY|DOUT2|GND|VGND|VSS nfet
+ L=0.15U W=0.42U AS=0.10025P AD=0.0567P PS=0.985U PD=0.69U
* device instance $210 r0 *1 41.96,-126.08 nfet
M$210 A|X$4 \$185 A|B|BUSY|DOUT2|GND|VGND|VSS A|B|BUSY|DOUT2|GND|VGND|VSS nfet
+ L=0.15U W=0.65U AS=0.10025P AD=0.169P PS=0.985U PD=1.82U
* device instance $211 r0 *1 46.87,-124.96 nfet
M$211 B|D|PH_B4|Q|S \$208 A|B|BUSY|DOUT2|GND|VGND|VSS
+ A|B|BUSY|DOUT2|GND|VGND|VSS nfet L=0.15U W=0.65U AS=0.2087P AD=0.169P
+ PS=2.02U PD=1.82U
* device instance $212 r0 *1 48.815,-125.075 nfet
M$212 \$230 B|D|PH_B2|Q|S A|B|BUSY|DOUT2|GND|VGND|VSS
+ A|B|BUSY|DOUT2|GND|VGND|VSS nfet L=0.15U W=0.42U AS=0.11285P AD=0.0693P
+ PS=1.045U PD=0.75U
* device instance $213 r0 *1 49.295,-125.075 nfet
M$213 \$209 A1|Y \$230 A|B|BUSY|DOUT2|GND|VGND|VSS nfet L=0.15U W=0.42U
+ AS=0.0693P AD=0.09975P PS=0.75U PD=0.895U
* device instance $214 r0 *1 49.92,-125.075 nfet
M$214 \$231 A0|DOUT2|Q \$209 A|B|BUSY|DOUT2|GND|VGND|VSS nfet L=0.15U W=0.42U
+ AS=0.09975P AD=0.0693P PS=0.895U PD=0.75U
* device instance $215 r0 *1 50.4,-125.075 nfet
M$215 A|B|BUSY|DOUT2|GND|VGND|VSS \$210 \$231 A|B|BUSY|DOUT2|GND|VGND|VSS nfet
+ L=0.15U W=0.42U AS=0.0693P AD=0.1449P PS=0.75U PD=1.11U
* device instance $216 r0 *1 51.24,-125.075 nfet
M$216 \$210 B|D|PH_B2|Q|S A|B|BUSY|DOUT2|GND|VGND|VSS
+ A|B|BUSY|DOUT2|GND|VGND|VSS nfet L=0.15U W=0.42U AS=0.1449P AD=0.1092P
+ PS=1.11U PD=1.36U
* device instance $217 r0 *1 48.27,-124.96 nfet
M$217 A|B|BUSY|DOUT2|GND|VGND|VSS \$209 A|X$8 A|B|BUSY|DOUT2|GND|VGND|VSS nfet
+ L=0.15U W=0.65U AS=0.169P AD=0.11285P PS=1.82U PD=1.045U
* device instance $218 r0 *1 51.67,-130.375 nfet
M$218 \$163 A|X$9 \$147 A|B|BUSY|DOUT2|GND|VGND|VSS nfet L=0.15U W=0.42U
+ AS=0.1176P AD=0.0567P PS=1.4U PD=0.69U
* device instance $219 r0 *1 52.09,-130.375 nfet
M$219 \$163 B|X A|B|BUSY|DOUT2|GND|VGND|VSS A|B|BUSY|DOUT2|GND|VGND|VSS nfet
+ L=0.15U W=0.42U AS=0.1118P AD=0.0567P PS=1.04U PD=0.69U
* device instance $220 r0 *1 52.63,-130.4 nfet
M$220 D|X$4 \$147 A|B|BUSY|DOUT2|GND|VGND|VSS A|B|BUSY|DOUT2|GND|VGND|VSS nfet
+ L=0.15U W=0.65U AS=0.1118P AD=0.182P PS=1.04U PD=1.86U
* device instance $221 r0 *1 55.17,-125.075 nfet
M$221 A|B|BUSY|DOUT2|GND|VGND|VSS CLK|X \$214 A|B|BUSY|DOUT2|GND|VGND|VSS nfet
+ L=0.15U W=0.42U AS=0.1092P AD=0.0567P PS=1.36U PD=0.69U
* device instance $222 r0 *1 55.59,-125.075 nfet
M$222 \$215 \$214 A|B|BUSY|DOUT2|GND|VGND|VSS A|B|BUSY|DOUT2|GND|VGND|VSS nfet
+ L=0.15U W=0.42U AS=0.0567P AD=0.1092P PS=0.69U PD=1.36U
* device instance $223 r0 *1 57.34,-125.105 nfet
M$223 \$217 \$214 \$216 A|B|BUSY|DOUT2|GND|VGND|VSS nfet L=0.15U W=0.36U
+ AS=0.066P AD=0.0594P PS=0.745U PD=0.69U
* device instance $224 r0 *1 57.82,-125.105 nfet
M$224 \$233 \$215 \$217 A|B|BUSY|DOUT2|GND|VGND|VSS nfet L=0.15U W=0.36U
+ AS=0.0594P AD=0.1401P PS=0.69U PD=1.1U
* device instance $225 r0 *1 60.165,-125.105 nfet
M$225 \$219 \$215 \$218 A|B|BUSY|DOUT2|GND|VGND|VSS nfet L=0.15U W=0.36U
+ AS=0.0999P AD=0.0711P PS=0.985U PD=0.755U
* device instance $226 r0 *1 60.71,-125.105 nfet
M$226 \$235 \$214 \$219 A|B|BUSY|DOUT2|GND|VGND|VSS nfet L=0.15U W=0.36U
+ AS=0.0711P AD=0.0669P PS=0.755U PD=0.75U
* device instance $227 r0 *1 56.865,-125.075 nfet
M$227 \$216 D|X$5 A|B|BUSY|DOUT2|GND|VGND|VSS A|B|BUSY|DOUT2|GND|VGND|VSS nfet
+ L=0.15U W=0.42U AS=0.2205P AD=0.066P PS=1.89U PD=0.745U
* device instance $228 r0 *1 58.65,-125.075 nfet
M$228 \$234 \$218 \$233 A|B|BUSY|DOUT2|GND|VGND|VSS nfet L=0.15U W=0.42U
+ AS=0.1401P AD=0.0441P PS=1.1U PD=0.63U
* device instance $229 r0 *1 59.01,-125.075 nfet
M$229 A|B|BUSY|DOUT2|GND|VGND|VSS RESET_B|RST_B|SAMPLE \$234
+ A|B|BUSY|DOUT2|GND|VGND|VSS nfet L=0.15U W=0.42U AS=0.0441P AD=0.1346P
+ PS=0.63U PD=1.15U
* device instance $230 r0 *1 61.19,-125.075 nfet
M$230 A|B|BUSY|DOUT2|GND|VGND|VSS \$221 \$235 A|B|BUSY|DOUT2|GND|VGND|VSS nfet
+ L=0.15U W=0.42U AS=0.0669P AD=0.12495P PS=0.75U PD=1.015U
* device instance $231 r0 *1 61.935,-125.075 nfet
M$231 \$236 RESET_B|RST_B|SAMPLE A|B|BUSY|DOUT2|GND|VGND|VSS
+ A|B|BUSY|DOUT2|GND|VGND|VSS nfet L=0.15U W=0.42U AS=0.12495P AD=0.06405P
+ PS=1.015U PD=0.725U
* device instance $232 r0 *1 62.39,-125.075 nfet
M$232 \$221 \$219 \$236 A|B|BUSY|DOUT2|GND|VGND|VSS nfet L=0.15U W=0.42U
+ AS=0.06405P AD=0.1092P PS=0.725U PD=1.36U
* device instance $233 r0 *1 59.67,-124.965 nfet
M$233 \$218 \$217 A|B|BUSY|DOUT2|GND|VGND|VSS A|B|BUSY|DOUT2|GND|VGND|VSS nfet
+ L=0.15U W=0.64U AS=0.1346P AD=0.0999P PS=1.15U PD=0.985U
* device instance $234 r0 *1 63.43,-124.96 nfet
M$234 A0|DOUT7|Q \$221 A|B|BUSY|DOUT2|GND|VGND|VSS A|B|BUSY|DOUT2|GND|VGND|VSS
+ nfet L=0.15U W=0.65U AS=0.2087P AD=0.169P PS=2.02U PD=1.82U
* device instance $235 r0 *1 23.89,-120.525 nfet
M$235 A|B|BUSY|DOUT2|GND|VGND|VSS CLK|X \$245 A|B|BUSY|DOUT2|GND|VGND|VSS nfet
+ L=0.15U W=0.42U AS=0.1092P AD=0.0567P PS=1.36U PD=0.69U
* device instance $236 r0 *1 24.31,-120.525 nfet
M$236 \$246 \$245 A|B|BUSY|DOUT2|GND|VGND|VSS A|B|BUSY|DOUT2|GND|VGND|VSS nfet
+ L=0.15U W=0.42U AS=0.0567P AD=0.1092P PS=0.69U PD=1.36U
* device instance $237 r0 *1 25.585,-120.525 nfet
M$237 \$247 A|B|D|PH_B1|Q|S A|B|BUSY|DOUT2|GND|VGND|VSS
+ A|B|BUSY|DOUT2|GND|VGND|VSS nfet L=0.15U W=0.42U AS=0.2205P AD=0.066P
+ PS=1.89U PD=0.745U
* device instance $238 r0 *1 26.06,-120.495 nfet
M$238 \$248 \$245 \$247 A|B|BUSY|DOUT2|GND|VGND|VSS nfet L=0.15U W=0.36U
+ AS=0.066P AD=0.0594P PS=0.745U PD=0.69U
* device instance $239 r0 *1 26.54,-120.495 nfet
M$239 \$248 \$246 \$280 A|B|BUSY|DOUT2|GND|VGND|VSS nfet L=0.15U W=0.36U
+ AS=0.1401P AD=0.0594P PS=1.1U PD=0.69U
* device instance $240 r0 *1 27.37,-120.525 nfet
M$240 \$281 \$250 \$280 A|B|BUSY|DOUT2|GND|VGND|VSS nfet L=0.15U W=0.42U
+ AS=0.1401P AD=0.0441P PS=1.1U PD=0.63U
* device instance $241 r0 *1 27.73,-120.525 nfet
M$241 \$281 RESET_B|RST_B|SAMPLE A|B|BUSY|DOUT2|GND|VGND|VSS
+ A|B|BUSY|DOUT2|GND|VGND|VSS nfet L=0.15U W=0.42U AS=0.1346P AD=0.0441P
+ PS=1.15U PD=0.63U
* device instance $242 r0 *1 28.39,-120.635 nfet
M$242 \$250 \$248 A|B|BUSY|DOUT2|GND|VGND|VSS A|B|BUSY|DOUT2|GND|VGND|VSS nfet
+ L=0.15U W=0.64U AS=0.1346P AD=0.0999P PS=1.15U PD=0.985U
* device instance $243 r0 *1 28.885,-120.495 nfet
M$243 \$251 \$246 \$250 A|B|BUSY|DOUT2|GND|VGND|VSS nfet L=0.15U W=0.36U
+ AS=0.0999P AD=0.0711P PS=0.985U PD=0.755U
* device instance $244 r0 *1 29.43,-120.495 nfet
M$244 \$251 \$245 \$282 A|B|BUSY|DOUT2|GND|VGND|VSS nfet L=0.15U W=0.36U
+ AS=0.0669P AD=0.0711P PS=0.75U PD=0.755U
* device instance $245 r0 *1 29.91,-120.525 nfet
M$245 A|B|BUSY|DOUT2|GND|VGND|VSS \$252 \$282 A|B|BUSY|DOUT2|GND|VGND|VSS nfet
+ L=0.15U W=0.42U AS=0.0669P AD=0.12495P PS=0.75U PD=1.015U
* device instance $246 r0 *1 30.655,-120.525 nfet
M$246 \$283 RESET_B|RST_B|SAMPLE A|B|BUSY|DOUT2|GND|VGND|VSS
+ A|B|BUSY|DOUT2|GND|VGND|VSS nfet L=0.15U W=0.42U AS=0.12495P AD=0.06405P
+ PS=1.015U PD=0.725U
* device instance $247 r0 *1 31.11,-120.525 nfet
M$247 \$252 \$251 \$283 A|B|BUSY|DOUT2|GND|VGND|VSS nfet L=0.15U W=0.42U
+ AS=0.06405P AD=0.1092P PS=0.725U PD=1.36U
* device instance $248 r0 *1 32.15,-120.64 nfet
M$248 B|D|PH_B0|Q|S \$252 A|B|BUSY|DOUT2|GND|VGND|VSS
+ A|B|BUSY|DOUT2|GND|VGND|VSS nfet L=0.15U W=0.65U AS=0.2087P AD=0.169P
+ PS=2.02U PD=1.82U
* device instance $249 r0 *1 32.775,-119.635 nfet
M$249 \$291 A|B|D|PH_B1|Q|S A|B|BUSY|DOUT2|GND|VGND|VSS
+ A|B|BUSY|DOUT2|GND|VGND|VSS nfet L=0.15U W=0.42U AS=0.1092P AD=0.0567P
+ PS=1.36U PD=0.69U
* device instance $250 r0 *1 33.195,-119.635 nfet
M$250 A|B|BUSY|DOUT2|GND|VGND|VSS A|X$12 \$291 A|B|BUSY|DOUT2|GND|VGND|VSS nfet
+ L=0.15U W=0.42U AS=0.0567P AD=0.10025P PS=0.69U PD=0.985U
* device instance $251 r0 *1 33.68,-119.52 nfet
M$251 A|X$16 \$291 A|B|BUSY|DOUT2|GND|VGND|VSS A|B|BUSY|DOUT2|GND|VGND|VSS nfet
+ L=0.15U W=0.65U AS=0.10025P AD=0.169P PS=0.985U PD=1.82U
* device instance $252 r0 *1 33.09,-120.64 nfet
M$252 A|B|BUSY|DOUT2|GND|VGND|VSS \$255 A|X$12 A|B|BUSY|DOUT2|GND|VGND|VSS nfet
+ L=0.15U W=0.65U AS=0.169P AD=0.11285P PS=1.82U PD=1.045U
* device instance $253 r0 *1 33.635,-120.525 nfet
M$253 \$284 B|D|PH_B0|Q|S A|B|BUSY|DOUT2|GND|VGND|VSS
+ A|B|BUSY|DOUT2|GND|VGND|VSS nfet L=0.15U W=0.42U AS=0.11285P AD=0.0693P
+ PS=1.045U PD=0.75U
* device instance $254 r0 *1 34.115,-120.525 nfet
M$254 \$255 A1|Y \$284 A|B|BUSY|DOUT2|GND|VGND|VSS nfet L=0.15U W=0.42U
+ AS=0.0693P AD=0.09975P PS=0.75U PD=0.895U
* device instance $255 r0 *1 34.74,-120.525 nfet
M$255 \$285 A0|DOUT0|Q \$255 A|B|BUSY|DOUT2|GND|VGND|VSS nfet L=0.15U W=0.42U
+ AS=0.09975P AD=0.0693P PS=0.895U PD=0.75U
* device instance $256 r0 *1 35.22,-120.525 nfet
M$256 A|B|BUSY|DOUT2|GND|VGND|VSS \$257 \$285 A|B|BUSY|DOUT2|GND|VGND|VSS nfet
+ L=0.15U W=0.42U AS=0.0693P AD=0.1449P PS=0.75U PD=1.11U
* device instance $257 r0 *1 36.06,-120.525 nfet
M$257 \$257 B|D|PH_B0|Q|S A|B|BUSY|DOUT2|GND|VGND|VSS
+ A|B|BUSY|DOUT2|GND|VGND|VSS nfet L=0.15U W=0.42U AS=0.1449P AD=0.1092P
+ PS=1.11U PD=1.36U
* device instance $258 r0 *1 37.69,-120.64 nfet
M$258 A|B|BUSY|DOUT2|GND|VGND|VSS \$258 A|X$6 A|B|BUSY|DOUT2|GND|VGND|VSS nfet
+ L=0.15U W=0.65U AS=0.169P AD=0.11285P PS=1.82U PD=1.045U
* device instance $259 r0 *1 38.235,-120.525 nfet
M$259 \$287 A|B|D|PH_B5|Q|S A|B|BUSY|DOUT2|GND|VGND|VSS
+ A|B|BUSY|DOUT2|GND|VGND|VSS nfet L=0.15U W=0.42U AS=0.11285P AD=0.0693P
+ PS=1.045U PD=0.75U
* device instance $260 r0 *1 38.715,-120.525 nfet
M$260 \$258 A1|Y \$287 A|B|BUSY|DOUT2|GND|VGND|VSS nfet L=0.15U W=0.42U
+ AS=0.0693P AD=0.09975P PS=0.75U PD=0.895U
* device instance $261 r0 *1 39.34,-120.525 nfet
M$261 \$288 A0|DOUT5|Q \$258 A|B|BUSY|DOUT2|GND|VGND|VSS nfet L=0.15U W=0.42U
+ AS=0.09975P AD=0.0693P PS=0.895U PD=0.75U
* device instance $262 r0 *1 39.82,-120.525 nfet
M$262 A|B|BUSY|DOUT2|GND|VGND|VSS \$259 \$288 A|B|BUSY|DOUT2|GND|VGND|VSS nfet
+ L=0.15U W=0.42U AS=0.0693P AD=0.1449P PS=0.75U PD=1.11U
* device instance $263 r0 *1 40.66,-120.525 nfet
M$263 \$259 A|B|D|PH_B5|Q|S A|B|BUSY|DOUT2|GND|VGND|VSS
+ A|B|BUSY|DOUT2|GND|VGND|VSS nfet L=0.15U W=0.42U AS=0.1449P AD=0.1092P
+ PS=1.11U PD=1.36U
* device instance $264 r0 *1 41.975,-119.635 nfet
M$264 \$293 B|D|PH_B2|Q|S A|B|BUSY|DOUT2|GND|VGND|VSS
+ A|B|BUSY|DOUT2|GND|VGND|VSS nfet L=0.15U W=0.42U AS=0.1092P AD=0.0567P
+ PS=1.36U PD=0.69U
* device instance $265 r0 *1 42.395,-119.635 nfet
M$265 A|B|BUSY|DOUT2|GND|VGND|VSS A|X$17 \$293 A|B|BUSY|DOUT2|GND|VGND|VSS nfet
+ L=0.15U W=0.42U AS=0.0567P AD=0.10025P PS=0.69U PD=0.985U
* device instance $266 r0 *1 42.88,-119.52 nfet
M$266 A|X$13 \$293 A|B|BUSY|DOUT2|GND|VGND|VSS A|B|BUSY|DOUT2|GND|VGND|VSS nfet
+ L=0.15U W=0.65U AS=0.10025P AD=0.169P PS=0.985U PD=1.82U
* device instance $267 r0 *1 42.93,-120.665 nfet
M$267 \$289 A|X$13 \$261 A|B|BUSY|DOUT2|GND|VGND|VSS nfet L=0.15U W=0.42U
+ AS=0.1176P AD=0.0567P PS=1.4U PD=0.69U
* device instance $268 r0 *1 43.35,-120.665 nfet
M$268 \$289 B|X A|B|BUSY|DOUT2|GND|VGND|VSS A|B|BUSY|DOUT2|GND|VGND|VSS nfet
+ L=0.15U W=0.42U AS=0.1118P AD=0.0567P PS=1.04U PD=0.69U
* device instance $269 r0 *1 43.89,-120.64 nfet
M$269 D|X$6 \$261 A|B|BUSY|DOUT2|GND|VGND|VSS A|B|BUSY|DOUT2|GND|VGND|VSS nfet
+ L=0.15U W=0.65U AS=0.1118P AD=0.182P PS=1.04U PD=1.86U
* device instance $270 r0 *1 44.13,-119.635 nfet
M$270 A|B|BUSY|DOUT2|GND|VGND|VSS CLK|X \$295 A|B|BUSY|DOUT2|GND|VGND|VSS nfet
+ L=0.15U W=0.42U AS=0.1092P AD=0.0567P PS=1.36U PD=0.69U
* device instance $271 r0 *1 44.55,-119.635 nfet
M$271 \$296 \$295 A|B|BUSY|DOUT2|GND|VGND|VSS A|B|BUSY|DOUT2|GND|VGND|VSS nfet
+ L=0.15U W=0.42U AS=0.0567P AD=0.1092P PS=0.69U PD=1.36U
* device instance $272 r0 *1 46.3,-119.665 nfet
M$272 \$298 \$295 \$297 A|B|BUSY|DOUT2|GND|VGND|VSS nfet L=0.15U W=0.36U
+ AS=0.066P AD=0.0594P PS=0.745U PD=0.69U
* device instance $273 r0 *1 46.78,-119.665 nfet
M$273 \$306 \$296 \$298 A|B|BUSY|DOUT2|GND|VGND|VSS nfet L=0.15U W=0.36U
+ AS=0.0594P AD=0.1401P PS=0.69U PD=1.1U
* device instance $274 r0 *1 49.125,-119.665 nfet
M$274 \$301 \$296 \$300 A|B|BUSY|DOUT2|GND|VGND|VSS nfet L=0.15U W=0.36U
+ AS=0.0999P AD=0.0711P PS=0.985U PD=0.755U
* device instance $275 r0 *1 49.67,-119.665 nfet
M$275 \$308 \$295 \$301 A|B|BUSY|DOUT2|GND|VGND|VSS nfet L=0.15U W=0.36U
+ AS=0.0711P AD=0.0669P PS=0.755U PD=0.75U
* device instance $276 r0 *1 45.825,-119.635 nfet
M$276 \$297 D|PH_SAMPLE|Y A|B|BUSY|DOUT2|GND|VGND|VSS
+ A|B|BUSY|DOUT2|GND|VGND|VSS nfet L=0.15U W=0.42U AS=0.2205P AD=0.066P
+ PS=1.89U PD=0.745U
* device instance $277 r0 *1 47.61,-119.635 nfet
M$277 \$307 \$300 \$306 A|B|BUSY|DOUT2|GND|VGND|VSS nfet L=0.15U W=0.42U
+ AS=0.1401P AD=0.0441P PS=1.1U PD=0.63U
* device instance $278 r0 *1 47.97,-119.635 nfet
M$278 A|B|BUSY|DOUT2|GND|VGND|VSS RESET_B|RST_B|SAMPLE \$307
+ A|B|BUSY|DOUT2|GND|VGND|VSS nfet L=0.15U W=0.42U AS=0.0441P AD=0.1346P
+ PS=0.63U PD=1.15U
* device instance $279 r0 *1 50.15,-119.635 nfet
M$279 A|B|BUSY|DOUT2|GND|VGND|VSS \$302 \$308 A|B|BUSY|DOUT2|GND|VGND|VSS nfet
+ L=0.15U W=0.42U AS=0.0669P AD=0.12495P PS=0.75U PD=1.015U
* device instance $280 r0 *1 50.895,-119.635 nfet
M$280 \$310 RESET_B|RST_B|SAMPLE A|B|BUSY|DOUT2|GND|VGND|VSS
+ A|B|BUSY|DOUT2|GND|VGND|VSS nfet L=0.15U W=0.42U AS=0.12495P AD=0.06405P
+ PS=1.015U PD=0.725U
* device instance $281 r0 *1 51.35,-119.635 nfet
M$281 \$302 \$301 \$310 A|B|BUSY|DOUT2|GND|VGND|VSS nfet L=0.15U W=0.42U
+ AS=0.06405P AD=0.1092P PS=0.725U PD=1.36U
* device instance $282 r0 *1 48.63,-119.525 nfet
M$282 \$300 \$298 A|B|BUSY|DOUT2|GND|VGND|VSS A|B|BUSY|DOUT2|GND|VGND|VSS nfet
+ L=0.15U W=0.64U AS=0.1346P AD=0.0999P PS=1.15U PD=0.985U
* device instance $283 r0 *1 52.13,-120.665 nfet
M$283 \$290 A|X$14 \$264 A|B|BUSY|DOUT2|GND|VGND|VSS nfet L=0.15U W=0.42U
+ AS=0.1176P AD=0.0567P PS=1.4U PD=0.69U
* device instance $284 r0 *1 52.55,-120.665 nfet
M$284 \$290 B|X A|B|BUSY|DOUT2|GND|VGND|VSS A|B|BUSY|DOUT2|GND|VGND|VSS nfet
+ L=0.15U W=0.42U AS=0.1118P AD=0.0567P PS=1.04U PD=0.69U
* device instance $285 r0 *1 53.09,-120.64 nfet
M$285 D|X$7 \$264 A|B|BUSY|DOUT2|GND|VGND|VSS A|B|BUSY|DOUT2|GND|VGND|VSS nfet
+ L=0.15U W=0.65U AS=0.1118P AD=0.182P PS=1.04U PD=1.86U
* device instance $286 r0 *1 52.39,-119.52 nfet
M$286 A|B|D|PH_B9|Q|S \$302 A|B|BUSY|DOUT2|GND|VGND|VSS
+ A|B|BUSY|DOUT2|GND|VGND|VSS nfet L=0.15U W=0.65U AS=0.2087P AD=0.169P
+ PS=2.02U PD=1.82U
* device instance $287 r0 *1 52.59,-124.935 nfet
M$287 \$232 A|X$11 \$212 A|B|BUSY|DOUT2|GND|VGND|VSS nfet L=0.15U W=0.42U
+ AS=0.1176P AD=0.0567P PS=1.4U PD=0.69U
* device instance $288 r0 *1 53.01,-124.935 nfet
M$288 \$232 B|X A|B|BUSY|DOUT2|GND|VGND|VSS A|B|BUSY|DOUT2|GND|VGND|VSS nfet
+ L=0.15U W=0.42U AS=0.1118P AD=0.0567P PS=1.04U PD=0.69U
* device instance $289 r0 *1 53.55,-124.96 nfet
M$289 D|X$5 \$212 A|B|BUSY|DOUT2|GND|VGND|VSS A|B|BUSY|DOUT2|GND|VGND|VSS nfet
+ L=0.15U W=0.65U AS=0.1118P AD=0.182P PS=1.04U PD=1.86U
* device instance $290 r0 *1 55.775,-120.525 nfet
M$290 \$267 B|D|PH_B8|Q|S A|B|BUSY|DOUT2|GND|VGND|VSS
+ A|B|BUSY|DOUT2|GND|VGND|VSS nfet L=0.15U W=0.42U AS=0.1092P AD=0.0567P
+ PS=1.36U PD=0.69U
* device instance $291 r0 *1 56.195,-120.525 nfet
M$291 \$267 A|X$15 A|B|BUSY|DOUT2|GND|VGND|VSS A|B|BUSY|DOUT2|GND|VGND|VSS nfet
+ L=0.15U W=0.42U AS=0.10025P AD=0.0567P PS=0.985U PD=0.69U
* device instance $292 r0 *1 56.68,-120.64 nfet
M$292 A|X$11 \$267 A|B|BUSY|DOUT2|GND|VGND|VSS A|B|BUSY|DOUT2|GND|VGND|VSS nfet
+ L=0.15U W=0.65U AS=0.10025P AD=0.169P PS=0.985U PD=1.82U
* device instance $293 r0 *1 58.85,-120.64 nfet
M$293 A|B|BUSY|DOUT2|GND|VGND|VSS \$269 A|X$15 A|B|BUSY|DOUT2|GND|VGND|VSS nfet
+ L=0.15U W=0.65U AS=0.169P AD=0.11285P PS=1.82U PD=1.045U
* device instance $294 r0 *1 59.395,-120.525 nfet
M$294 \$286 B|C|D|PH_B7|Q|S A|B|BUSY|DOUT2|GND|VGND|VSS
+ A|B|BUSY|DOUT2|GND|VGND|VSS nfet L=0.15U W=0.42U AS=0.11285P AD=0.0693P
+ PS=1.045U PD=0.75U
* device instance $295 r0 *1 59.875,-120.525 nfet
M$295 \$269 A1|Y \$286 A|B|BUSY|DOUT2|GND|VGND|VSS nfet L=0.15U W=0.42U
+ AS=0.0693P AD=0.09975P PS=0.75U PD=0.895U
* device instance $296 r0 *1 60.5,-120.525 nfet
M$296 \$279 A0|DOUT7|Q \$269 A|B|BUSY|DOUT2|GND|VGND|VSS nfet L=0.15U W=0.42U
+ AS=0.09975P AD=0.0693P PS=0.895U PD=0.75U
* device instance $297 r0 *1 60.98,-120.525 nfet
M$297 A|B|BUSY|DOUT2|GND|VGND|VSS \$270 \$279 A|B|BUSY|DOUT2|GND|VGND|VSS nfet
+ L=0.15U W=0.42U AS=0.0693P AD=0.1449P PS=0.75U PD=1.11U
* device instance $298 r0 *1 61.82,-120.525 nfet
M$298 \$270 B|C|D|PH_B7|Q|S A|B|BUSY|DOUT2|GND|VGND|VSS
+ A|B|BUSY|DOUT2|GND|VGND|VSS nfet L=0.15U W=0.42U AS=0.1449P AD=0.1092P
+ PS=1.11U PD=1.36U
* device instance $299 r0 *1 26.19,-115.085 nfet
M$299 A|B|BUSY|DOUT2|GND|VGND|VSS CLK|X \$311 A|B|BUSY|DOUT2|GND|VGND|VSS nfet
+ L=0.15U W=0.42U AS=0.1092P AD=0.0567P PS=1.36U PD=0.69U
* device instance $300 r0 *1 26.61,-115.085 nfet
M$300 \$312 \$311 A|B|BUSY|DOUT2|GND|VGND|VSS A|B|BUSY|DOUT2|GND|VGND|VSS nfet
+ L=0.15U W=0.42U AS=0.0567P AD=0.1092P PS=0.69U PD=1.36U
* device instance $301 r0 *1 27.885,-115.085 nfet
M$301 \$314 D|X$8 A|B|BUSY|DOUT2|GND|VGND|VSS A|B|BUSY|DOUT2|GND|VGND|VSS nfet
+ L=0.15U W=0.42U AS=0.2205P AD=0.066P PS=1.89U PD=0.745U
* device instance $302 r0 *1 28.36,-115.055 nfet
M$302 \$315 \$311 \$314 A|B|BUSY|DOUT2|GND|VGND|VSS nfet L=0.15U W=0.36U
+ AS=0.066P AD=0.0594P PS=0.745U PD=0.69U
* device instance $303 r0 *1 28.84,-115.055 nfet
M$303 \$315 \$312 \$343 A|B|BUSY|DOUT2|GND|VGND|VSS nfet L=0.15U W=0.36U
+ AS=0.1401P AD=0.0594P PS=1.1U PD=0.69U
* device instance $304 r0 *1 29.67,-115.085 nfet
M$304 \$344 \$317 \$343 A|B|BUSY|DOUT2|GND|VGND|VSS nfet L=0.15U W=0.42U
+ AS=0.1401P AD=0.0441P PS=1.1U PD=0.63U
* device instance $305 r0 *1 30.03,-115.085 nfet
M$305 \$344 RESET_B|RST_B|SAMPLE A|B|BUSY|DOUT2|GND|VGND|VSS
+ A|B|BUSY|DOUT2|GND|VGND|VSS nfet L=0.15U W=0.42U AS=0.1346P AD=0.0441P
+ PS=1.15U PD=0.63U
* device instance $306 r0 *1 30.69,-115.195 nfet
M$306 \$317 \$315 A|B|BUSY|DOUT2|GND|VGND|VSS A|B|BUSY|DOUT2|GND|VGND|VSS nfet
+ L=0.15U W=0.64U AS=0.1346P AD=0.0999P PS=1.15U PD=0.985U
* device instance $307 r0 *1 31.185,-115.055 nfet
M$307 \$318 \$312 \$317 A|B|BUSY|DOUT2|GND|VGND|VSS nfet L=0.15U W=0.36U
+ AS=0.0999P AD=0.0711P PS=0.985U PD=0.755U
* device instance $308 r0 *1 31.73,-115.055 nfet
M$308 \$318 \$311 \$345 A|B|BUSY|DOUT2|GND|VGND|VSS nfet L=0.15U W=0.36U
+ AS=0.0669P AD=0.0711P PS=0.75U PD=0.755U
* device instance $309 r0 *1 32.21,-115.085 nfet
M$309 A|B|BUSY|DOUT2|GND|VGND|VSS \$319 \$345 A|B|BUSY|DOUT2|GND|VGND|VSS nfet
+ L=0.15U W=0.42U AS=0.0669P AD=0.12495P PS=0.75U PD=1.015U
* device instance $310 r0 *1 32.955,-115.085 nfet
M$310 \$346 RESET_B|RST_B|SAMPLE A|B|BUSY|DOUT2|GND|VGND|VSS
+ A|B|BUSY|DOUT2|GND|VGND|VSS nfet L=0.15U W=0.42U AS=0.12495P AD=0.06405P
+ PS=1.015U PD=0.725U
* device instance $311 r0 *1 33.41,-115.085 nfet
M$311 \$319 \$318 \$346 A|B|BUSY|DOUT2|GND|VGND|VSS nfet L=0.15U W=0.42U
+ AS=0.06405P AD=0.1092P PS=0.725U PD=1.36U
* device instance $312 r0 *1 34.45,-115.2 nfet
M$312 A0|DOUT0|Q \$319 A|B|BUSY|DOUT2|GND|VGND|VSS A|B|BUSY|DOUT2|GND|VGND|VSS
+ nfet L=0.15U W=0.65U AS=0.2087P AD=0.169P PS=2.02U PD=1.82U
* device instance $313 r0 *1 36.49,-115.225 nfet
M$313 \$348 A|X$16 \$320 A|B|BUSY|DOUT2|GND|VGND|VSS nfet L=0.15U W=0.42U
+ AS=0.1176P AD=0.0567P PS=1.4U PD=0.69U
* device instance $314 r0 *1 36.91,-115.225 nfet
M$314 \$348 B|X A|B|BUSY|DOUT2|GND|VGND|VSS A|B|BUSY|DOUT2|GND|VGND|VSS nfet
+ L=0.15U W=0.42U AS=0.1118P AD=0.0567P PS=1.04U PD=0.69U
* device instance $315 r0 *1 37.45,-115.2 nfet
M$315 D|X$8 \$320 A|B|BUSY|DOUT2|GND|VGND|VSS A|B|BUSY|DOUT2|GND|VGND|VSS nfet
+ L=0.15U W=0.65U AS=0.1118P AD=0.182P PS=1.04U PD=1.86U
* device instance $316 r0 *1 40.595,-115.085 nfet
M$316 \$321 B|D|PH_B0|Q|S A|B|BUSY|DOUT2|GND|VGND|VSS
+ A|B|BUSY|DOUT2|GND|VGND|VSS nfet L=0.15U W=0.42U AS=0.1092P AD=0.0567P
+ PS=1.36U PD=0.69U
* device instance $317 r0 *1 41.015,-115.085 nfet
M$317 \$321 A|B|D|PH_B1|Q|S A|B|BUSY|DOUT2|GND|VGND|VSS
+ A|B|BUSY|DOUT2|GND|VGND|VSS nfet L=0.15U W=0.42U AS=0.10025P AD=0.0567P
+ PS=0.985U PD=0.69U
* device instance $318 r0 *1 41.5,-115.2 nfet
M$318 C|X \$321 A|B|BUSY|DOUT2|GND|VGND|VSS A|B|BUSY|DOUT2|GND|VGND|VSS nfet
+ L=0.15U W=0.65U AS=0.10025P AD=0.169P PS=0.985U PD=1.82U
* device instance $319 r0 *1 43.21,-115.2 nfet
M$319 A|B|BUSY|DOUT2|GND|VGND|VSS \$323 A|X$17 A|B|BUSY|DOUT2|GND|VGND|VSS nfet
+ L=0.15U W=0.65U AS=0.169P AD=0.11285P PS=1.82U PD=1.045U
* device instance $320 r0 *1 43.755,-115.085 nfet
M$320 \$352 A|B|D|PH_B1|Q|S A|B|BUSY|DOUT2|GND|VGND|VSS
+ A|B|BUSY|DOUT2|GND|VGND|VSS nfet L=0.15U W=0.42U AS=0.11285P AD=0.0693P
+ PS=1.045U PD=0.75U
* device instance $321 r0 *1 44.235,-115.085 nfet
M$321 \$323 A1|Y \$352 A|B|BUSY|DOUT2|GND|VGND|VSS nfet L=0.15U W=0.42U
+ AS=0.0693P AD=0.09975P PS=0.75U PD=0.895U
* device instance $322 r0 *1 44.86,-115.085 nfet
M$322 \$353 A0|DOUT1|Q \$323 A|B|BUSY|DOUT2|GND|VGND|VSS nfet L=0.15U W=0.42U
+ AS=0.09975P AD=0.0693P PS=0.895U PD=0.75U
* device instance $323 r0 *1 45.34,-115.085 nfet
M$323 A|B|BUSY|DOUT2|GND|VGND|VSS \$325 \$353 A|B|BUSY|DOUT2|GND|VGND|VSS nfet
+ L=0.15U W=0.42U AS=0.0693P AD=0.1449P PS=0.75U PD=1.11U
* device instance $324 r0 *1 46.18,-115.085 nfet
M$324 \$325 A|B|D|PH_B1|Q|S A|B|BUSY|DOUT2|GND|VGND|VSS
+ A|B|BUSY|DOUT2|GND|VGND|VSS nfet L=0.15U W=0.42U AS=0.1449P AD=0.1092P
+ PS=1.11U PD=1.36U
* device instance $325 r0 *1 52.095,-115.085 nfet
M$325 \$326 A|B|D|PH_B9|Q|S A|B|BUSY|DOUT2|GND|VGND|VSS
+ A|B|BUSY|DOUT2|GND|VGND|VSS nfet L=0.15U W=0.42U AS=0.1092P AD=0.0567P
+ PS=1.36U PD=0.69U
* device instance $326 r0 *1 52.515,-115.085 nfet
M$326 \$326 A|X$18 A|B|BUSY|DOUT2|GND|VGND|VSS A|B|BUSY|DOUT2|GND|VGND|VSS nfet
+ L=0.15U W=0.42U AS=0.10025P AD=0.0567P PS=0.985U PD=0.69U
* device instance $327 r0 *1 53,-115.2 nfet
M$327 A|X$14 \$326 A|B|BUSY|DOUT2|GND|VGND|VSS A|B|BUSY|DOUT2|GND|VGND|VSS nfet
+ L=0.15U W=0.65U AS=0.10025P AD=0.169P PS=0.985U PD=1.82U
* device instance $328 r0 *1 54.71,-115.085 nfet
M$328 A|B|BUSY|DOUT2|GND|VGND|VSS CLK|X \$328 A|B|BUSY|DOUT2|GND|VGND|VSS nfet
+ L=0.15U W=0.42U AS=0.1092P AD=0.0567P PS=1.36U PD=0.69U
* device instance $329 r0 *1 55.13,-115.085 nfet
M$329 \$329 \$328 A|B|BUSY|DOUT2|GND|VGND|VSS A|B|BUSY|DOUT2|GND|VGND|VSS nfet
+ L=0.15U W=0.42U AS=0.0567P AD=0.1092P PS=0.69U PD=1.36U
* device instance $330 r0 *1 56.405,-115.085 nfet
M$330 \$330 D|X$7 A|B|BUSY|DOUT2|GND|VGND|VSS A|B|BUSY|DOUT2|GND|VGND|VSS nfet
+ L=0.15U W=0.42U AS=0.2205P AD=0.066P PS=1.89U PD=0.745U
* device instance $331 r0 *1 56.88,-115.055 nfet
M$331 \$331 \$328 \$330 A|B|BUSY|DOUT2|GND|VGND|VSS nfet L=0.15U W=0.36U
+ AS=0.066P AD=0.0594P PS=0.745U PD=0.69U
* device instance $332 r0 *1 57.36,-115.055 nfet
M$332 \$331 \$329 \$351 A|B|BUSY|DOUT2|GND|VGND|VSS nfet L=0.15U W=0.36U
+ AS=0.1401P AD=0.0594P PS=1.1U PD=0.69U
* device instance $333 r0 *1 58.19,-115.085 nfet
M$333 \$350 \$333 \$351 A|B|BUSY|DOUT2|GND|VGND|VSS nfet L=0.15U W=0.42U
+ AS=0.1401P AD=0.0441P PS=1.1U PD=0.63U
* device instance $334 r0 *1 58.55,-115.085 nfet
M$334 \$350 RESET_B|RST_B|SAMPLE A|B|BUSY|DOUT2|GND|VGND|VSS
+ A|B|BUSY|DOUT2|GND|VGND|VSS nfet L=0.15U W=0.42U AS=0.1346P AD=0.0441P
+ PS=1.15U PD=0.63U
* device instance $335 r0 *1 59.21,-115.195 nfet
M$335 \$333 \$331 A|B|BUSY|DOUT2|GND|VGND|VSS A|B|BUSY|DOUT2|GND|VGND|VSS nfet
+ L=0.15U W=0.64U AS=0.1346P AD=0.0999P PS=1.15U PD=0.985U
* device instance $336 r0 *1 59.705,-115.055 nfet
M$336 \$334 \$329 \$333 A|B|BUSY|DOUT2|GND|VGND|VSS nfet L=0.15U W=0.36U
+ AS=0.0999P AD=0.0711P PS=0.985U PD=0.755U
* device instance $337 r0 *1 60.25,-115.055 nfet
M$337 \$334 \$328 \$349 A|B|BUSY|DOUT2|GND|VGND|VSS nfet L=0.15U W=0.36U
+ AS=0.0669P AD=0.0711P PS=0.75U PD=0.755U
* device instance $338 r0 *1 60.73,-115.085 nfet
M$338 A|B|BUSY|DOUT2|GND|VGND|VSS \$335 \$349 A|B|BUSY|DOUT2|GND|VGND|VSS nfet
+ L=0.15U W=0.42U AS=0.0669P AD=0.12495P PS=0.75U PD=1.015U
* device instance $339 r0 *1 61.475,-115.085 nfet
M$339 \$347 RESET_B|RST_B|SAMPLE A|B|BUSY|DOUT2|GND|VGND|VSS
+ A|B|BUSY|DOUT2|GND|VGND|VSS nfet L=0.15U W=0.42U AS=0.12495P AD=0.06405P
+ PS=1.015U PD=0.725U
* device instance $340 r0 *1 61.93,-115.085 nfet
M$340 \$335 \$334 \$347 A|B|BUSY|DOUT2|GND|VGND|VSS nfet L=0.15U W=0.42U
+ AS=0.06405P AD=0.1092P PS=0.725U PD=1.36U
* device instance $341 r0 *1 62.97,-115.2 nfet
M$341 A0|DOUT8|Q \$335 A|B|BUSY|DOUT2|GND|VGND|VSS A|B|BUSY|DOUT2|GND|VGND|VSS
+ nfet L=0.15U W=0.65U AS=0.2087P AD=0.169P PS=2.02U PD=1.82U
* device instance $342 r0 *1 23.89,-114.195 nfet
M$342 A|B|BUSY|DOUT2|GND|VGND|VSS CLK|X \$354 A|B|BUSY|DOUT2|GND|VGND|VSS nfet
+ L=0.15U W=0.42U AS=0.1092P AD=0.0567P PS=1.36U PD=0.69U
* device instance $343 r0 *1 24.31,-114.195 nfet
M$343 \$355 \$354 A|B|BUSY|DOUT2|GND|VGND|VSS A|B|BUSY|DOUT2|GND|VGND|VSS nfet
+ L=0.15U W=0.42U AS=0.0567P AD=0.1092P PS=0.69U PD=1.36U
* device instance $344 r0 *1 26.06,-114.225 nfet
M$344 \$358 \$354 \$357 A|B|BUSY|DOUT2|GND|VGND|VSS nfet L=0.15U W=0.36U
+ AS=0.066P AD=0.0594P PS=0.745U PD=0.69U
* device instance $345 r0 *1 26.54,-114.225 nfet
M$345 \$378 \$355 \$358 A|B|BUSY|DOUT2|GND|VGND|VSS nfet L=0.15U W=0.36U
+ AS=0.0594P AD=0.1401P PS=0.69U PD=1.1U
* device instance $346 r0 *1 28.885,-114.225 nfet
M$346 \$360 \$355 \$359 A|B|BUSY|DOUT2|GND|VGND|VSS nfet L=0.15U W=0.36U
+ AS=0.0999P AD=0.0711P PS=0.985U PD=0.755U
* device instance $347 r0 *1 29.43,-114.225 nfet
M$347 \$380 \$354 \$360 A|B|BUSY|DOUT2|GND|VGND|VSS nfet L=0.15U W=0.36U
+ AS=0.0711P AD=0.0669P PS=0.755U PD=0.75U
* device instance $348 r0 *1 25.585,-114.195 nfet
M$348 \$357 D|X$9 A|B|BUSY|DOUT2|GND|VGND|VSS A|B|BUSY|DOUT2|GND|VGND|VSS nfet
+ L=0.15U W=0.42U AS=0.2205P AD=0.066P PS=1.89U PD=0.745U
* device instance $349 r0 *1 27.37,-114.195 nfet
M$349 \$379 \$359 \$378 A|B|BUSY|DOUT2|GND|VGND|VSS nfet L=0.15U W=0.42U
+ AS=0.1401P AD=0.0441P PS=1.1U PD=0.63U
* device instance $350 r0 *1 27.73,-114.195 nfet
M$350 A|B|BUSY|DOUT2|GND|VGND|VSS RESET_B|RST_B|SAMPLE \$379
+ A|B|BUSY|DOUT2|GND|VGND|VSS nfet L=0.15U W=0.42U AS=0.0441P AD=0.1346P
+ PS=0.63U PD=1.15U
* device instance $351 r0 *1 29.91,-114.195 nfet
M$351 A|B|BUSY|DOUT2|GND|VGND|VSS \$361 \$380 A|B|BUSY|DOUT2|GND|VGND|VSS nfet
+ L=0.15U W=0.42U AS=0.0669P AD=0.12495P PS=0.75U PD=1.015U
* device instance $352 r0 *1 30.655,-114.195 nfet
M$352 \$381 RESET_B|RST_B|SAMPLE A|B|BUSY|DOUT2|GND|VGND|VSS
+ A|B|BUSY|DOUT2|GND|VGND|VSS nfet L=0.15U W=0.42U AS=0.12495P AD=0.06405P
+ PS=1.015U PD=0.725U
* device instance $353 r0 *1 31.11,-114.195 nfet
M$353 \$361 \$360 \$381 A|B|BUSY|DOUT2|GND|VGND|VSS nfet L=0.15U W=0.42U
+ AS=0.06405P AD=0.1092P PS=0.725U PD=1.36U
* device instance $354 r0 *1 28.39,-114.085 nfet
M$354 \$359 \$358 A|B|BUSY|DOUT2|GND|VGND|VSS A|B|BUSY|DOUT2|GND|VGND|VSS nfet
+ L=0.15U W=0.64U AS=0.1346P AD=0.0999P PS=1.15U PD=0.985U
* device instance $355 r0 *1 32.15,-114.08 nfet
M$355 A0|B|DOUT9|Q \$361 A|B|BUSY|DOUT2|GND|VGND|VSS
+ A|B|BUSY|DOUT2|GND|VGND|VSS nfet L=0.15U W=0.65U AS=0.2087P AD=0.169P
+ PS=2.02U PD=1.82U
* device instance $356 r0 *1 33.635,-114.195 nfet
M$356 \$382 A|B|D|PH_B9|Q|S A|B|BUSY|DOUT2|GND|VGND|VSS
+ A|B|BUSY|DOUT2|GND|VGND|VSS nfet L=0.15U W=0.42U AS=0.11285P AD=0.0693P
+ PS=1.045U PD=0.75U
* device instance $357 r0 *1 34.115,-114.195 nfet
M$357 \$363 A|A1|COMP_OUT \$382 A|B|BUSY|DOUT2|GND|VGND|VSS nfet L=0.15U
+ W=0.42U AS=0.0693P AD=0.09975P PS=0.75U PD=0.895U
* device instance $358 r0 *1 34.74,-114.195 nfet
M$358 \$383 A0|B|DOUT9|Q \$363 A|B|BUSY|DOUT2|GND|VGND|VSS nfet L=0.15U W=0.42U
+ AS=0.09975P AD=0.0693P PS=0.895U PD=0.75U
* device instance $359 r0 *1 35.22,-114.195 nfet
M$359 A|B|BUSY|DOUT2|GND|VGND|VSS \$365 \$383 A|B|BUSY|DOUT2|GND|VGND|VSS nfet
+ L=0.15U W=0.42U AS=0.0693P AD=0.1449P PS=0.75U PD=1.11U
* device instance $360 r0 *1 36.06,-114.195 nfet
M$360 \$365 A|B|D|PH_B9|Q|S A|B|BUSY|DOUT2|GND|VGND|VSS
+ A|B|BUSY|DOUT2|GND|VGND|VSS nfet L=0.15U W=0.42U AS=0.1449P AD=0.1092P
+ PS=1.11U PD=1.36U
* device instance $361 r0 *1 33.09,-114.08 nfet
M$361 A|B|BUSY|DOUT2|GND|VGND|VSS \$363 D|X$9 A|B|BUSY|DOUT2|GND|VGND|VSS nfet
+ L=0.15U W=0.65U AS=0.169P AD=0.11285P PS=1.82U PD=1.045U
* device instance $362 r0 *1 38.61,-114.08 nfet
M$362 A|B|BUSY|DOUT2|GND|VGND|VSS A|X \$366 A|B|BUSY|DOUT2|GND|VGND|VSS nfet
+ L=0.15U W=0.65U AS=0.169P AD=0.08775P PS=1.82U PD=0.92U
* device instance $363 r0 *1 39.03,-114.08 nfet
M$363 CLK|X \$366 A|B|BUSY|DOUT2|GND|VGND|VSS A|B|BUSY|DOUT2|GND|VGND|VSS nfet
+ L=0.15U W=0.65U AS=0.08775P AD=0.08775P PS=0.92U PD=0.92U
* device instance $364 r0 *1 39.45,-114.08 nfet
M$364 A|B|BUSY|DOUT2|GND|VGND|VSS \$366 CLK|X A|B|BUSY|DOUT2|GND|VGND|VSS nfet
+ L=0.15U W=0.65U AS=0.08775P AD=0.08775P PS=0.92U PD=0.92U
* device instance $365 r0 *1 39.87,-114.08 nfet
M$365 CLK|X \$366 A|B|BUSY|DOUT2|GND|VGND|VSS A|B|BUSY|DOUT2|GND|VGND|VSS nfet
+ L=0.15U W=0.65U AS=0.08775P AD=0.08775P PS=0.92U PD=0.92U
* device instance $366 r0 *1 40.29,-114.08 nfet
M$366 A|B|BUSY|DOUT2|GND|VGND|VSS \$366 CLK|X A|B|BUSY|DOUT2|GND|VGND|VSS nfet
+ L=0.15U W=0.65U AS=0.08775P AD=0.169P PS=0.92U PD=1.82U
* device instance $367 r0 *1 43.67,-114.195 nfet
M$367 A|B|BUSY|DOUT2|GND|VGND|VSS CLK|X \$369 A|B|BUSY|DOUT2|GND|VGND|VSS nfet
+ L=0.15U W=0.42U AS=0.1092P AD=0.0567P PS=1.36U PD=0.69U
* device instance $368 r0 *1 44.09,-114.195 nfet
M$368 \$370 \$369 A|B|BUSY|DOUT2|GND|VGND|VSS A|B|BUSY|DOUT2|GND|VGND|VSS nfet
+ L=0.15U W=0.42U AS=0.0567P AD=0.1092P PS=0.69U PD=1.36U
* device instance $369 r0 *1 45.84,-114.225 nfet
M$369 \$372 \$369 \$371 A|B|BUSY|DOUT2|GND|VGND|VSS nfet L=0.15U W=0.36U
+ AS=0.066P AD=0.0594P PS=0.745U PD=0.69U
* device instance $370 r0 *1 46.32,-114.225 nfet
M$370 \$384 \$370 \$372 A|B|BUSY|DOUT2|GND|VGND|VSS nfet L=0.15U W=0.36U
+ AS=0.0594P AD=0.1401P PS=0.69U PD=1.1U
* device instance $371 r0 *1 48.665,-114.225 nfet
M$371 \$374 \$370 \$373 A|B|BUSY|DOUT2|GND|VGND|VSS nfet L=0.15U W=0.36U
+ AS=0.0999P AD=0.0711P PS=0.985U PD=0.755U
* device instance $372 r0 *1 49.21,-114.225 nfet
M$372 \$386 \$369 \$374 A|B|BUSY|DOUT2|GND|VGND|VSS nfet L=0.15U W=0.36U
+ AS=0.0711P AD=0.0669P PS=0.755U PD=0.75U
* device instance $373 r0 *1 45.365,-114.195 nfet
M$373 \$371 D|X$6 A|B|BUSY|DOUT2|GND|VGND|VSS A|B|BUSY|DOUT2|GND|VGND|VSS nfet
+ L=0.15U W=0.42U AS=0.2205P AD=0.066P PS=1.89U PD=0.745U
* device instance $374 r0 *1 47.15,-114.195 nfet
M$374 \$385 \$373 \$384 A|B|BUSY|DOUT2|GND|VGND|VSS nfet L=0.15U W=0.42U
+ AS=0.1401P AD=0.0441P PS=1.1U PD=0.63U
* device instance $375 r0 *1 47.51,-114.195 nfet
M$375 A|B|BUSY|DOUT2|GND|VGND|VSS RESET_B|RST_B|SAMPLE \$385
+ A|B|BUSY|DOUT2|GND|VGND|VSS nfet L=0.15U W=0.42U AS=0.0441P AD=0.1346P
+ PS=0.63U PD=1.15U
* device instance $376 r0 *1 49.69,-114.195 nfet
M$376 A|B|BUSY|DOUT2|GND|VGND|VSS \$375 \$386 A|B|BUSY|DOUT2|GND|VGND|VSS nfet
+ L=0.15U W=0.42U AS=0.0669P AD=0.12495P PS=0.75U PD=1.015U
* device instance $377 r0 *1 50.435,-114.195 nfet
M$377 \$387 RESET_B|RST_B|SAMPLE A|B|BUSY|DOUT2|GND|VGND|VSS
+ A|B|BUSY|DOUT2|GND|VGND|VSS nfet L=0.15U W=0.42U AS=0.12495P AD=0.06405P
+ PS=1.015U PD=0.725U
* device instance $378 r0 *1 50.89,-114.195 nfet
M$378 \$375 \$374 \$387 A|B|BUSY|DOUT2|GND|VGND|VSS nfet L=0.15U W=0.42U
+ AS=0.06405P AD=0.1092P PS=0.725U PD=1.36U
* device instance $379 r0 *1 48.17,-114.085 nfet
M$379 \$373 \$372 A|B|BUSY|DOUT2|GND|VGND|VSS A|B|BUSY|DOUT2|GND|VGND|VSS nfet
+ L=0.15U W=0.64U AS=0.1346P AD=0.0999P PS=1.15U PD=0.985U
* device instance $380 r0 *1 51.93,-114.08 nfet
M$380 A0|DOUT1|Q \$375 A|B|BUSY|DOUT2|GND|VGND|VSS A|B|BUSY|DOUT2|GND|VGND|VSS
+ nfet L=0.15U W=0.65U AS=0.2087P AD=0.169P PS=2.02U PD=1.82U
* device instance $381 r0 *1 57.095,-114.195 nfet
M$381 \$388 B|D|PH_B8|Q|S A|B|BUSY|DOUT2|GND|VGND|VSS
+ A|B|BUSY|DOUT2|GND|VGND|VSS nfet L=0.15U W=0.42U AS=0.11285P AD=0.0693P
+ PS=1.045U PD=0.75U
* device instance $382 r0 *1 57.575,-114.195 nfet
M$382 \$376 A1|Y \$388 A|B|BUSY|DOUT2|GND|VGND|VSS nfet L=0.15U W=0.42U
+ AS=0.0693P AD=0.09975P PS=0.75U PD=0.895U
* device instance $383 r0 *1 58.2,-114.195 nfet
M$383 \$389 A0|DOUT8|Q \$376 A|B|BUSY|DOUT2|GND|VGND|VSS nfet L=0.15U W=0.42U
+ AS=0.09975P AD=0.0693P PS=0.895U PD=0.75U
* device instance $384 r0 *1 58.68,-114.195 nfet
M$384 A|B|BUSY|DOUT2|GND|VGND|VSS \$377 \$389 A|B|BUSY|DOUT2|GND|VGND|VSS nfet
+ L=0.15U W=0.42U AS=0.0693P AD=0.1449P PS=0.75U PD=1.11U
* device instance $385 r0 *1 59.52,-114.195 nfet
M$385 \$377 B|D|PH_B8|Q|S A|B|BUSY|DOUT2|GND|VGND|VSS
+ A|B|BUSY|DOUT2|GND|VGND|VSS nfet L=0.15U W=0.42U AS=0.1449P AD=0.1092P
+ PS=1.11U PD=1.36U
* device instance $386 r0 *1 56.55,-114.08 nfet
M$386 A|B|BUSY|DOUT2|GND|VGND|VSS \$376 A|X$18 A|B|BUSY|DOUT2|GND|VGND|VSS nfet
+ L=0.15U W=0.65U AS=0.169P AD=0.11285P PS=1.82U PD=1.045U
* device instance $387 r0 *1 26.19,-108.755 nfet
M$387 A|B|BUSY|DOUT2|GND|VGND|VSS CLK|X \$432 A|B|BUSY|DOUT2|GND|VGND|VSS nfet
+ L=0.15U W=0.42U AS=0.1092P AD=0.0567P PS=1.36U PD=0.69U
* device instance $388 r0 *1 26.61,-108.755 nfet
M$388 \$433 \$432 A|B|BUSY|DOUT2|GND|VGND|VSS A|B|BUSY|DOUT2|GND|VGND|VSS nfet
+ L=0.15U W=0.42U AS=0.0567P AD=0.1092P PS=0.69U PD=1.36U
* device instance $389 r0 *1 28.36,-108.785 nfet
M$389 \$435 \$432 \$434 A|B|BUSY|DOUT2|GND|VGND|VSS nfet L=0.15U W=0.36U
+ AS=0.066P AD=0.0594P PS=0.745U PD=0.69U
* device instance $390 r0 *1 28.84,-108.785 nfet
M$390 \$449 \$433 \$435 A|B|BUSY|DOUT2|GND|VGND|VSS nfet L=0.15U W=0.36U
+ AS=0.0594P AD=0.1401P PS=0.69U PD=1.1U
* device instance $391 r0 *1 31.185,-108.785 nfet
M$391 \$438 \$433 \$437 A|B|BUSY|DOUT2|GND|VGND|VSS nfet L=0.15U W=0.36U
+ AS=0.0999P AD=0.0711P PS=0.985U PD=0.755U
* device instance $392 r0 *1 31.73,-108.785 nfet
M$392 \$451 \$432 \$438 A|B|BUSY|DOUT2|GND|VGND|VSS nfet L=0.15U W=0.36U
+ AS=0.0711P AD=0.0669P PS=0.755U PD=0.75U
* device instance $393 r0 *1 27.885,-108.755 nfet
M$393 \$434 B|D|PH_B0|Q|S A|B|BUSY|DOUT2|GND|VGND|VSS
+ A|B|BUSY|DOUT2|GND|VGND|VSS nfet L=0.15U W=0.42U AS=0.2205P AD=0.066P
+ PS=1.89U PD=0.745U
* device instance $394 r0 *1 29.67,-108.755 nfet
M$394 \$450 \$437 \$449 A|B|BUSY|DOUT2|GND|VGND|VSS nfet L=0.15U W=0.42U
+ AS=0.1401P AD=0.0441P PS=1.1U PD=0.63U
* device instance $395 r0 *1 30.03,-108.755 nfet
M$395 A|B|BUSY|DOUT2|GND|VGND|VSS RESET_B|RST_B|SAMPLE \$450
+ A|B|BUSY|DOUT2|GND|VGND|VSS nfet L=0.15U W=0.42U AS=0.0441P AD=0.1346P
+ PS=0.63U PD=1.15U
* device instance $396 r0 *1 32.21,-108.755 nfet
M$396 A|B|BUSY|DOUT2|GND|VGND|VSS \$439 \$451 A|B|BUSY|DOUT2|GND|VGND|VSS nfet
+ L=0.15U W=0.42U AS=0.0669P AD=0.12495P PS=0.75U PD=1.015U
* device instance $397 r0 *1 32.955,-108.755 nfet
M$397 \$452 RESET_B|RST_B|SAMPLE A|B|BUSY|DOUT2|GND|VGND|VSS
+ A|B|BUSY|DOUT2|GND|VGND|VSS nfet L=0.15U W=0.42U AS=0.12495P AD=0.06405P
+ PS=1.015U PD=0.725U
* device instance $398 r0 *1 33.41,-108.755 nfet
M$398 \$439 \$438 \$452 A|B|BUSY|DOUT2|GND|VGND|VSS nfet L=0.15U W=0.42U
+ AS=0.06405P AD=0.1092P PS=0.725U PD=1.36U
* device instance $399 r0 *1 30.69,-108.645 nfet
M$399 \$437 \$435 A|B|BUSY|DOUT2|GND|VGND|VSS A|B|BUSY|DOUT2|GND|VGND|VSS nfet
+ L=0.15U W=0.64U AS=0.1346P AD=0.0999P PS=1.15U PD=0.985U
* device instance $400 r0 *1 32.73,-109.76 nfet
M$400 \$431 A0|B|DOUT9|Q \$401 A|B|BUSY|DOUT2|GND|VGND|VSS nfet L=0.15U W=0.65U
+ AS=0.169P AD=0.06825P PS=1.82U PD=0.86U
* device instance $401 r0 *1 33.09,-109.76 nfet
M$401 A|B|BUSY|DOUT2|GND|VGND|VSS A|A1|COMP_OUT \$431
+ A|B|BUSY|DOUT2|GND|VGND|VSS nfet L=0.15U W=0.65U AS=0.06825P AD=0.08775P
+ PS=0.86U PD=0.92U
* device instance $402 r0 *1 33.51,-109.76 nfet
M$402 \$402 A|A1|COMP_OUT A|B|BUSY|DOUT2|GND|VGND|VSS
+ A|B|BUSY|DOUT2|GND|VGND|VSS nfet L=0.15U W=0.65U AS=0.08775P AD=0.169P
+ PS=0.92U PD=1.82U
* device instance $403 r0 *1 34.45,-109.76 nfet
M$403 \$402 A0|B|DOUT9|Q A|B|BUSY|DOUT2|GND|VGND|VSS
+ A|B|BUSY|DOUT2|GND|VGND|VSS nfet L=0.15U W=0.65U AS=0.169P AD=0.08775P
+ PS=1.82U PD=0.92U
* device instance $404 r0 *1 34.87,-109.76 nfet
M$404 A1|Y \$401 \$402 A|B|BUSY|DOUT2|GND|VGND|VSS nfet L=0.15U W=0.65U
+ AS=0.08775P AD=0.195P PS=0.92U PD=1.9U
* device instance $405 r0 *1 34.45,-108.64 nfet
M$405 C|PH_EOC|Q \$439 A|B|BUSY|DOUT2|GND|VGND|VSS A|B|BUSY|DOUT2|GND|VGND|VSS
+ nfet L=0.15U W=0.65U AS=0.2087P AD=0.169P PS=2.02U PD=1.82U
* device instance $406 r0 *1 37.7,-109.675 nfet
M$406 A|B|BUSY|DOUT2|GND|VGND|VSS C|PH_EOC|Q \$404 A|B|BUSY|DOUT2|GND|VGND|VSS
+ nfet L=0.15U W=0.42U AS=0.1092P AD=0.0567P PS=1.36U PD=0.69U
* device instance $407 r0 *1 38.12,-109.675 nfet
M$407 \$404 B|D|PH_B0|Q|S A|B|BUSY|DOUT2|GND|VGND|VSS
+ A|B|BUSY|DOUT2|GND|VGND|VSS nfet L=0.15U W=0.42U AS=0.0567P AD=0.0567P
+ PS=0.69U PD=0.69U
* device instance $408 r0 *1 38.54,-109.675 nfet
M$408 \$404 A|B|D|PH_B1|Q|S A|B|BUSY|DOUT2|GND|VGND|VSS
+ A|B|BUSY|DOUT2|GND|VGND|VSS nfet L=0.15U W=0.42U AS=0.101875P AD=0.0567P
+ PS=0.99U PD=0.69U
* device instance $409 r0 *1 39.03,-109.76 nfet
M$409 C|X$1 \$404 A|B|BUSY|DOUT2|GND|VGND|VSS A|B|BUSY|DOUT2|GND|VGND|VSS nfet
+ L=0.15U W=0.65U AS=0.101875P AD=0.182P PS=0.99U PD=1.86U
* device instance $410 r0 *1 40.92,-109.675 nfet
M$410 A|B|BUSY|DOUT2|GND|VGND|VSS C|X$1 \$406 A|B|BUSY|DOUT2|GND|VGND|VSS nfet
+ L=0.15U W=0.42U AS=0.1092P AD=0.0567P PS=1.36U PD=0.69U
* device instance $411 r0 *1 41.34,-109.675 nfet
M$411 \$406 B|X$1 A|B|BUSY|DOUT2|GND|VGND|VSS A|B|BUSY|DOUT2|GND|VGND|VSS nfet
+ L=0.15U W=0.42U AS=0.0567P AD=0.0567P PS=0.69U PD=0.69U
* device instance $412 r0 *1 41.76,-109.675 nfet
M$412 \$406 A|X$19 A|B|BUSY|DOUT2|GND|VGND|VSS A|B|BUSY|DOUT2|GND|VGND|VSS nfet
+ L=0.15U W=0.42U AS=0.101875P AD=0.0567P PS=0.99U PD=0.69U
* device instance $413 r0 *1 42.25,-109.76 nfet
M$413 A|BUSY|X \$406 A|B|BUSY|DOUT2|GND|VGND|VSS A|B|BUSY|DOUT2|GND|VGND|VSS
+ nfet L=0.15U W=0.65U AS=0.101875P AD=0.182P PS=0.99U PD=1.86U
* device instance $414 r0 *1 41.38,-114.165 nfet
M$414 A|B|BUSY|DOUT2|GND|VGND|VSS C|X \$367 A|B|BUSY|DOUT2|GND|VGND|VSS nfet
+ L=0.15U W=0.42U AS=0.1092P AD=0.0567P PS=1.36U PD=0.69U
* device instance $415 r0 *1 41.8,-114.165 nfet
M$415 \$367 B|X$1 A|B|BUSY|DOUT2|GND|VGND|VSS A|B|BUSY|DOUT2|GND|VGND|VSS nfet
+ L=0.15U W=0.42U AS=0.0567P AD=0.0567P PS=0.69U PD=0.69U
* device instance $416 r0 *1 42.22,-114.165 nfet
M$416 \$367 A|X$19 A|B|BUSY|DOUT2|GND|VGND|VSS A|B|BUSY|DOUT2|GND|VGND|VSS nfet
+ L=0.15U W=0.42U AS=0.101875P AD=0.0567P PS=0.99U PD=0.69U
* device instance $417 r0 *1 42.71,-114.08 nfet
M$417 B|X \$367 A|B|BUSY|DOUT2|GND|VGND|VSS A|B|BUSY|DOUT2|GND|VGND|VSS nfet
+ L=0.15U W=0.65U AS=0.101875P AD=0.182P PS=0.99U PD=1.86U
* device instance $418 r0 *1 44.335,-109.76 nfet
M$418 D|PH_SAMPLE|Y A|BUSY|X A|B|BUSY|DOUT2|GND|VGND|VSS
+ A|B|BUSY|DOUT2|GND|VGND|VSS nfet L=0.15U W=0.65U AS=0.169P AD=0.169P PS=1.82U
+ PD=1.82U
* device instance $419 r0 *1 51.95,-109.675 nfet
M$419 \$409 A|A_N|B|D|DOUT0|DOUT7|PH_B6|PH_B9|Q|S|VPB|VPWR
+ A|B|BUSY|DOUT2|GND|VGND|VSS A|B|BUSY|DOUT2|GND|VGND|VSS nfet L=0.15U W=0.42U
+ AS=0.1092P AD=0.0693P PS=1.36U PD=0.75U
* device instance $420 r0 *1 52.43,-109.675 nfet
M$420 A|B|BUSY|DOUT2|GND|VGND|VSS B|C|D|PH_B7|Q|S \$409
+ A|B|BUSY|DOUT2|GND|VGND|VSS nfet L=0.15U W=0.42U AS=0.0693P AD=0.0567P
+ PS=0.75U PD=0.69U
* device instance $421 r0 *1 52.85,-109.675 nfet
M$421 \$409 B|D|PH_B8|Q|S A|B|BUSY|DOUT2|GND|VGND|VSS
+ A|B|BUSY|DOUT2|GND|VGND|VSS nfet L=0.15U W=0.42U AS=0.0567P AD=0.0567P
+ PS=0.69U PD=0.69U
* device instance $422 r0 *1 53.27,-109.675 nfet
M$422 \$409 A|B|D|PH_B9|Q|S A|B|BUSY|DOUT2|GND|VGND|VSS
+ A|B|BUSY|DOUT2|GND|VGND|VSS nfet L=0.15U W=0.42U AS=0.101875P AD=0.0567P
+ PS=0.99U PD=0.69U
* device instance $423 r0 *1 53.76,-109.76 nfet
M$423 A|X$19 \$409 A|B|BUSY|DOUT2|GND|VGND|VSS A|B|BUSY|DOUT2|GND|VGND|VSS nfet
+ L=0.15U W=0.65U AS=0.101875P AD=0.1755P PS=0.99U PD=1.84U
* device instance $424 r0 *1 52.41,-108.755 nfet
M$424 A|B|BUSY|DOUT2|GND|VGND|VSS CLK|X \$441 A|B|BUSY|DOUT2|GND|VGND|VSS nfet
+ L=0.15U W=0.42U AS=0.1092P AD=0.0567P PS=1.36U PD=0.69U
* device instance $425 r0 *1 52.83,-108.755 nfet
M$425 \$442 \$441 A|B|BUSY|DOUT2|GND|VGND|VSS A|B|BUSY|DOUT2|GND|VGND|VSS nfet
+ L=0.15U W=0.42U AS=0.0567P AD=0.1092P PS=0.69U PD=1.36U
* device instance $426 r0 *1 54.58,-108.785 nfet
M$426 \$444 \$441 \$443 A|B|BUSY|DOUT2|GND|VGND|VSS nfet L=0.15U W=0.36U
+ AS=0.066P AD=0.0594P PS=0.745U PD=0.69U
* device instance $427 r0 *1 55.06,-108.785 nfet
M$427 \$456 \$442 \$444 A|B|BUSY|DOUT2|GND|VGND|VSS nfet L=0.15U W=0.36U
+ AS=0.0594P AD=0.1401P PS=0.69U PD=1.1U
* device instance $428 r0 *1 57.405,-108.785 nfet
M$428 \$447 \$442 \$446 A|B|BUSY|DOUT2|GND|VGND|VSS nfet L=0.15U W=0.36U
+ AS=0.0999P AD=0.0711P PS=0.985U PD=0.755U
* device instance $429 r0 *1 57.95,-108.785 nfet
M$429 \$458 \$441 \$447 A|B|BUSY|DOUT2|GND|VGND|VSS nfet L=0.15U W=0.36U
+ AS=0.0711P AD=0.0669P PS=0.755U PD=0.75U
* device instance $430 r0 *1 54.105,-108.755 nfet
M$430 \$443 A|B|D|PH_B9|Q|S A|B|BUSY|DOUT2|GND|VGND|VSS
+ A|B|BUSY|DOUT2|GND|VGND|VSS nfet L=0.15U W=0.42U AS=0.2205P AD=0.066P
+ PS=1.89U PD=0.745U
* device instance $431 r0 *1 55.89,-108.755 nfet
M$431 \$457 \$446 \$456 A|B|BUSY|DOUT2|GND|VGND|VSS nfet L=0.15U W=0.42U
+ AS=0.1401P AD=0.0441P PS=1.1U PD=0.63U
* device instance $432 r0 *1 56.25,-108.755 nfet
M$432 A|B|BUSY|DOUT2|GND|VGND|VSS RESET_B|RST_B|SAMPLE \$457
+ A|B|BUSY|DOUT2|GND|VGND|VSS nfet L=0.15U W=0.42U AS=0.0441P AD=0.1346P
+ PS=0.63U PD=1.15U
* device instance $433 r0 *1 58.43,-108.755 nfet
M$433 A|B|BUSY|DOUT2|GND|VGND|VSS \$448 \$458 A|B|BUSY|DOUT2|GND|VGND|VSS nfet
+ L=0.15U W=0.42U AS=0.0669P AD=0.12495P PS=0.75U PD=1.015U
* device instance $434 r0 *1 59.175,-108.755 nfet
M$434 \$459 RESET_B|RST_B|SAMPLE A|B|BUSY|DOUT2|GND|VGND|VSS
+ A|B|BUSY|DOUT2|GND|VGND|VSS nfet L=0.15U W=0.42U AS=0.12495P AD=0.06405P
+ PS=1.015U PD=0.725U
* device instance $435 r0 *1 59.63,-108.755 nfet
M$435 \$448 \$447 \$459 A|B|BUSY|DOUT2|GND|VGND|VSS nfet L=0.15U W=0.42U
+ AS=0.06405P AD=0.1092P PS=0.725U PD=1.36U
* device instance $436 r0 *1 56.91,-108.645 nfet
M$436 \$446 \$444 A|B|BUSY|DOUT2|GND|VGND|VSS A|B|BUSY|DOUT2|GND|VGND|VSS nfet
+ L=0.15U W=0.64U AS=0.1346P AD=0.0999P PS=1.15U PD=0.985U
* device instance $437 r0 *1 56.55,-109.645 nfet
M$437 A|B|BUSY|DOUT2|GND|VGND|VSS CLK|X \$410 A|B|BUSY|DOUT2|GND|VGND|VSS nfet
+ L=0.15U W=0.42U AS=0.1092P AD=0.0567P PS=1.36U PD=0.69U
* device instance $438 r0 *1 56.97,-109.645 nfet
M$438 \$411 \$410 A|B|BUSY|DOUT2|GND|VGND|VSS A|B|BUSY|DOUT2|GND|VGND|VSS nfet
+ L=0.15U W=0.42U AS=0.0567P AD=0.1092P PS=0.69U PD=1.36U
* device instance $439 r0 *1 58.245,-109.645 nfet
M$439 \$412 B|D|PH_B8|Q|S A|B|BUSY|DOUT2|GND|VGND|VSS
+ A|B|BUSY|DOUT2|GND|VGND|VSS nfet L=0.15U W=0.42U AS=0.2205P AD=0.066P
+ PS=1.89U PD=0.745U
* device instance $440 r0 *1 58.72,-109.615 nfet
M$440 \$413 \$410 \$412 A|B|BUSY|DOUT2|GND|VGND|VSS nfet L=0.15U W=0.36U
+ AS=0.066P AD=0.0594P PS=0.745U PD=0.69U
* device instance $441 r0 *1 59.2,-109.615 nfet
M$441 \$413 \$411 \$430 A|B|BUSY|DOUT2|GND|VGND|VSS nfet L=0.15U W=0.36U
+ AS=0.1401P AD=0.0594P PS=1.1U PD=0.69U
* device instance $442 r0 *1 60.03,-109.645 nfet
M$442 \$429 \$415 \$430 A|B|BUSY|DOUT2|GND|VGND|VSS nfet L=0.15U W=0.42U
+ AS=0.1401P AD=0.0441P PS=1.1U PD=0.63U
* device instance $443 r0 *1 60.39,-109.645 nfet
M$443 \$429 RESET_B|RST_B|SAMPLE A|B|BUSY|DOUT2|GND|VGND|VSS
+ A|B|BUSY|DOUT2|GND|VGND|VSS nfet L=0.15U W=0.42U AS=0.1346P AD=0.0441P
+ PS=1.15U PD=0.63U
* device instance $444 r0 *1 61.05,-109.755 nfet
M$444 \$415 \$413 A|B|BUSY|DOUT2|GND|VGND|VSS A|B|BUSY|DOUT2|GND|VGND|VSS nfet
+ L=0.15U W=0.64U AS=0.1346P AD=0.0999P PS=1.15U PD=0.985U
* device instance $445 r0 *1 61.545,-109.615 nfet
M$445 \$416 \$411 \$415 A|B|BUSY|DOUT2|GND|VGND|VSS nfet L=0.15U W=0.36U
+ AS=0.0999P AD=0.0711P PS=0.985U PD=0.755U
* device instance $446 r0 *1 62.09,-109.615 nfet
M$446 \$416 \$410 \$428 A|B|BUSY|DOUT2|GND|VGND|VSS nfet L=0.15U W=0.36U
+ AS=0.0669P AD=0.0711P PS=0.75U PD=0.755U
* device instance $447 r0 *1 62.57,-109.645 nfet
M$447 A|B|BUSY|DOUT2|GND|VGND|VSS \$417 \$428 A|B|BUSY|DOUT2|GND|VGND|VSS nfet
+ L=0.15U W=0.42U AS=0.0669P AD=0.12495P PS=0.75U PD=1.015U
* device instance $448 r0 *1 63.315,-109.645 nfet
M$448 \$427 RESET_B|RST_B|SAMPLE A|B|BUSY|DOUT2|GND|VGND|VSS
+ A|B|BUSY|DOUT2|GND|VGND|VSS nfet L=0.15U W=0.42U AS=0.12495P AD=0.06405P
+ PS=1.015U PD=0.725U
* device instance $449 r0 *1 63.77,-109.645 nfet
M$449 \$417 \$416 \$427 A|B|BUSY|DOUT2|GND|VGND|VSS nfet L=0.15U W=0.42U
+ AS=0.06405P AD=0.1092P PS=0.725U PD=1.36U
* device instance $450 r0 *1 60.67,-108.64 nfet
M$450 B|D|PH_B8|Q|S \$448 A|B|BUSY|DOUT2|GND|VGND|VSS
+ A|B|BUSY|DOUT2|GND|VGND|VSS nfet L=0.15U W=0.65U AS=0.2087P AD=0.169P
+ PS=2.02U PD=1.82U
* device instance $451 r0 *1 64.81,-109.76 nfet
M$451 B|C|D|PH_B7|Q|S \$417 A|B|BUSY|DOUT2|GND|VGND|VSS
+ A|B|BUSY|DOUT2|GND|VGND|VSS nfet L=0.15U W=0.65U AS=0.2087P AD=0.169P
+ PS=2.02U PD=1.82U
* device instance $452 r0 *1 38.61,-108.725 nfet
M$452 \$440 B|D|PH_B2|Q|S A|B|BUSY|DOUT2|GND|VGND|VSS
+ A|B|BUSY|DOUT2|GND|VGND|VSS nfet L=0.15U W=0.42U AS=0.1092P AD=0.0693P
+ PS=1.36U PD=0.75U
* device instance $453 r0 *1 39.09,-108.725 nfet
M$453 A|B|BUSY|DOUT2|GND|VGND|VSS B|C|D|PH_B3|Q|S \$440
+ A|B|BUSY|DOUT2|GND|VGND|VSS nfet L=0.15U W=0.42U AS=0.0693P AD=0.0567P
+ PS=0.75U PD=0.69U
* device instance $454 r0 *1 39.51,-108.725 nfet
M$454 \$440 B|D|PH_B4|Q|S A|B|BUSY|DOUT2|GND|VGND|VSS
+ A|B|BUSY|DOUT2|GND|VGND|VSS nfet L=0.15U W=0.42U AS=0.0567P AD=0.0567P
+ PS=0.69U PD=0.69U
* device instance $455 r0 *1 39.93,-108.725 nfet
M$455 \$440 A|B|D|PH_B5|Q|S A|B|BUSY|DOUT2|GND|VGND|VSS
+ A|B|BUSY|DOUT2|GND|VGND|VSS nfet L=0.15U W=0.42U AS=0.101875P AD=0.0567P
+ PS=0.99U PD=0.69U
* device instance $456 r0 *1 40.42,-108.64 nfet
M$456 B|X$1 \$440 A|B|BUSY|DOUT2|GND|VGND|VSS A|B|BUSY|DOUT2|GND|VGND|VSS nfet
+ L=0.15U W=0.65U AS=0.101875P AD=0.1755P PS=0.99U PD=1.84U
* device instance $457 r0 *1 98.065,-88 nfet
M$457 \$489 B|Y A|B|BUSY|DOUT2|GND|VGND|VSS A|B|BUSY|DOUT2|GND|VGND|VSS nfet
+ L=0.15U W=0.65U AS=0.169P AD=0.08775P PS=1.82U PD=0.92U
* device instance $458 r0 *1 98.485,-88 nfet
M$458 A|B|BUSY|DOUT2|GND|VGND|VSS A|B|BUSY|DOUT2|GND|VGND|VSS \$489
+ A|B|BUSY|DOUT2|GND|VGND|VSS nfet L=0.15U W=0.65U AS=0.08775P AD=0.08775P
+ PS=0.92U PD=0.92U
* device instance $459 r0 *1 98.905,-88 nfet
M$459 \$518 A|B|BUSY|DOUT2|GND|VGND|VSS A|B|BUSY|DOUT2|GND|VGND|VSS
+ A|B|BUSY|DOUT2|GND|VGND|VSS nfet L=0.15U W=0.65U AS=0.08775P AD=0.08775P
+ PS=0.92U PD=0.92U
* device instance $460 r0 *1 99.325,-88 nfet
M$460 ADCOUT2|X B|Y \$518 A|B|BUSY|DOUT2|GND|VGND|VSS nfet L=0.15U W=0.65U
+ AS=0.08775P AD=0.25025P PS=0.92U PD=1.42U
* device instance $461 r0 *1 100.245,-88 nfet
M$461 A|B|BUSY|DOUT2|GND|VGND|VSS \$489 ADCOUT2|X A|B|BUSY|DOUT2|GND|VGND|VSS
+ nfet L=0.15U W=0.65U AS=0.25025P AD=0.208P PS=1.42U PD=1.94U
* device instance $462 r0 *1 98.985,-93.44 nfet
M$462 \$462 B|Y A|B|BUSY|DOUT2|GND|VGND|VSS A|B|BUSY|DOUT2|GND|VGND|VSS nfet
+ L=0.15U W=0.65U AS=0.169P AD=0.08775P PS=1.82U PD=0.92U
* device instance $463 r0 *1 99.405,-93.44 nfet
M$463 A|B|BUSY|DOUT2|GND|VGND|VSS A|B|DOUT8 \$462 A|B|BUSY|DOUT2|GND|VGND|VSS
+ nfet L=0.15U W=0.65U AS=0.08775P AD=0.08775P PS=0.92U PD=0.92U
* device instance $464 r0 *1 99.825,-93.44 nfet
M$464 \$471 A|B|DOUT8 A|B|BUSY|DOUT2|GND|VGND|VSS A|B|BUSY|DOUT2|GND|VGND|VSS
+ nfet L=0.15U W=0.65U AS=0.08775P AD=0.08775P PS=0.92U PD=0.92U
* device instance $465 r0 *1 100.245,-93.44 nfet
M$465 ADCOUT8|X B|Y \$471 A|B|BUSY|DOUT2|GND|VGND|VSS nfet L=0.15U W=0.65U
+ AS=0.08775P AD=0.25025P PS=0.92U PD=1.42U
* device instance $466 r0 *1 101.165,-93.44 nfet
M$466 A|B|BUSY|DOUT2|GND|VGND|VSS \$462 ADCOUT8|X A|B|BUSY|DOUT2|GND|VGND|VSS
+ nfet L=0.15U W=0.65U AS=0.25025P AD=0.208P PS=1.42U PD=1.94U
* device instance $467 r0 *1 102.205,-88 nfet
M$467 \$492 B|Y A|B|BUSY|DOUT2|GND|VGND|VSS A|B|BUSY|DOUT2|GND|VGND|VSS nfet
+ L=0.15U W=0.65U AS=0.169P AD=0.08775P PS=1.82U PD=0.92U
* device instance $468 r0 *1 102.625,-88 nfet
M$468 A|B|BUSY|DOUT2|GND|VGND|VSS A|B|DOUT3 \$492 A|B|BUSY|DOUT2|GND|VGND|VSS
+ nfet L=0.15U W=0.65U AS=0.08775P AD=0.08775P PS=0.92U PD=0.92U
* device instance $469 r0 *1 103.045,-88 nfet
M$469 \$521 A|B|DOUT3 A|B|BUSY|DOUT2|GND|VGND|VSS A|B|BUSY|DOUT2|GND|VGND|VSS
+ nfet L=0.15U W=0.65U AS=0.08775P AD=0.08775P PS=0.92U PD=0.92U
* device instance $470 r0 *1 103.465,-88 nfet
M$470 ADCOUT3|X B|Y \$521 A|B|BUSY|DOUT2|GND|VGND|VSS nfet L=0.15U W=0.65U
+ AS=0.08775P AD=0.25025P PS=0.92U PD=1.42U
* device instance $471 r0 *1 104.385,-88 nfet
M$471 A|B|BUSY|DOUT2|GND|VGND|VSS \$492 ADCOUT3|X A|B|BUSY|DOUT2|GND|VGND|VSS
+ nfet L=0.15U W=0.65U AS=0.25025P AD=0.208P PS=1.42U PD=1.94U
* device instance $472 r0 *1 107.265,-88 nfet
M$472 \$496 B|Y A|B|BUSY|DOUT2|GND|VGND|VSS A|B|BUSY|DOUT2|GND|VGND|VSS nfet
+ L=0.15U W=0.65U AS=0.169P AD=0.08775P PS=1.82U PD=0.92U
* device instance $473 r0 *1 107.685,-88 nfet
M$473 A|B|BUSY|DOUT2|GND|VGND|VSS
+ A|A_N|B|D|DOUT0|DOUT7|PH_B6|PH_B9|Q|S|VPB|VPWR \$496
+ A|B|BUSY|DOUT2|GND|VGND|VSS nfet L=0.15U W=0.65U AS=0.08775P AD=0.08775P
+ PS=0.92U PD=0.92U
* device instance $474 r0 *1 108.105,-88 nfet
M$474 \$520 A|A_N|B|D|DOUT0|DOUT7|PH_B6|PH_B9|Q|S|VPB|VPWR
+ A|B|BUSY|DOUT2|GND|VGND|VSS A|B|BUSY|DOUT2|GND|VGND|VSS nfet L=0.15U W=0.65U
+ AS=0.08775P AD=0.08775P PS=0.92U PD=0.92U
* device instance $475 r0 *1 108.525,-88 nfet
M$475 ADCOUT7|X B|Y \$520 A|B|BUSY|DOUT2|GND|VGND|VSS nfet L=0.15U W=0.65U
+ AS=0.08775P AD=0.25025P PS=0.92U PD=1.42U
* device instance $476 r0 *1 109.445,-88 nfet
M$476 A|B|BUSY|DOUT2|GND|VGND|VSS \$496 ADCOUT7|X A|B|BUSY|DOUT2|GND|VGND|VSS
+ nfet L=0.15U W=0.65U AS=0.25025P AD=0.208P PS=1.42U PD=1.94U
* device instance $477 r0 *1 108.785,-92.295 nfet
M$477 \$483 A|A0|B|DOUT9 \$474 A|B|BUSY|DOUT2|GND|VGND|VSS nfet L=0.15U W=0.42U
+ AS=0.1176P AD=0.0567P PS=1.4U PD=0.69U
* device instance $478 r0 *1 109.205,-92.295 nfet
M$478 \$483 A|B|DOUT6 A|B|BUSY|DOUT2|GND|VGND|VSS A|B|BUSY|DOUT2|GND|VGND|VSS
+ nfet L=0.15U W=0.42U AS=0.1118P AD=0.0567P PS=1.04U PD=0.69U
* device instance $479 r0 *1 109.745,-92.32 nfet
M$479 SELp6|X \$474 A|B|BUSY|DOUT2|GND|VGND|VSS A|B|BUSY|DOUT2|GND|VGND|VSS
+ nfet L=0.15U W=0.65U AS=0.1118P AD=0.182P PS=1.04U PD=1.86U
* device instance $480 r0 *1 115.13,-92.435 nfet
M$480 \$485 A|A_N|B|D|DOUT0|DOUT7|PH_B6|PH_B9|Q|S|VPB|VPWR
+ A|B|BUSY|DOUT2|GND|VGND|VSS A|B|BUSY|DOUT2|GND|VGND|VSS nfet L=0.15U W=0.42U
+ AS=0.11285P AD=0.0693P PS=1.045U PD=0.75U
* device instance $481 r0 *1 115.61,-92.435 nfet
M$481 \$478 A|A1|OUTN|OUTN_NC \$485 A|B|BUSY|DOUT2|GND|VGND|VSS nfet L=0.15U
+ W=0.42U AS=0.0693P AD=0.09975P PS=0.75U PD=0.895U
* device instance $482 r0 *1 116.235,-92.435 nfet
M$482 \$486 A|A0|B|DOUT9 \$478 A|B|BUSY|DOUT2|GND|VGND|VSS nfet L=0.15U W=0.42U
+ AS=0.09975P AD=0.0693P PS=0.895U PD=0.75U
* device instance $483 r0 *1 116.715,-92.435 nfet
M$483 A|B|BUSY|DOUT2|GND|VGND|VSS \$479 \$486 A|B|BUSY|DOUT2|GND|VGND|VSS nfet
+ L=0.15U W=0.42U AS=0.0693P AD=0.1449P PS=0.75U PD=1.11U
* device instance $484 r0 *1 117.555,-92.435 nfet
M$484 \$479 A|A_N|B|D|DOUT0|DOUT7|PH_B6|PH_B9|Q|S|VPB|VPWR
+ A|B|BUSY|DOUT2|GND|VGND|VSS A|B|BUSY|DOUT2|GND|VGND|VSS nfet L=0.15U W=0.42U
+ AS=0.1449P AD=0.1092P PS=1.11U PD=1.36U
* device instance $485 r0 *1 114.585,-92.32 nfet
M$485 A|B|BUSY|DOUT2|GND|VGND|VSS \$478 DUMLOAD_MUX_NC|X
+ A|B|BUSY|DOUT2|GND|VGND|VSS nfet L=0.15U W=0.65U AS=0.169P AD=0.11285P
+ PS=1.82U PD=1.045U
* device instance $486 r0 *1 120.145,-88 nfet
M$486 \$503 B|Y A|B|BUSY|DOUT2|GND|VGND|VSS A|B|BUSY|DOUT2|GND|VGND|VSS nfet
+ L=0.15U W=0.65U AS=0.169P AD=0.08775P PS=1.82U PD=0.92U
* device instance $487 r0 *1 120.565,-88 nfet
M$487 A|B|BUSY|DOUT2|GND|VGND|VSS A|B|DOUT4 \$503 A|B|BUSY|DOUT2|GND|VGND|VSS
+ nfet L=0.15U W=0.65U AS=0.08775P AD=0.08775P PS=0.92U PD=0.92U
* device instance $488 r0 *1 120.985,-88 nfet
M$488 \$516 A|B|DOUT4 A|B|BUSY|DOUT2|GND|VGND|VSS A|B|BUSY|DOUT2|GND|VGND|VSS
+ nfet L=0.15U W=0.65U AS=0.08775P AD=0.08775P PS=0.92U PD=0.92U
* device instance $489 r0 *1 121.405,-88 nfet
M$489 ADCOUT4|X B|Y \$516 A|B|BUSY|DOUT2|GND|VGND|VSS nfet L=0.15U W=0.65U
+ AS=0.08775P AD=0.25025P PS=0.92U PD=1.42U
* device instance $490 r0 *1 122.325,-88 nfet
M$490 A|B|BUSY|DOUT2|GND|VGND|VSS \$503 ADCOUT4|X A|B|BUSY|DOUT2|GND|VGND|VSS
+ nfet L=0.15U W=0.65U AS=0.25025P AD=0.208P PS=1.42U PD=1.94U
* device instance $491 r0 *1 127.645,-93.465 nfet
M$491 \$472 A|B|DOUT1 \$468 A|B|BUSY|DOUT2|GND|VGND|VSS nfet L=0.15U W=0.42U
+ AS=0.1176P AD=0.0567P PS=1.4U PD=0.69U
* device instance $492 r0 *1 128.065,-93.465 nfet
M$492 \$472 B|Y A|B|BUSY|DOUT2|GND|VGND|VSS A|B|BUSY|DOUT2|GND|VGND|VSS nfet
+ L=0.15U W=0.42U AS=0.1118P AD=0.0567P PS=1.04U PD=0.69U
* device instance $493 r0 *1 128.605,-93.44 nfet
M$493 SELn1|X \$468 A|B|BUSY|DOUT2|GND|VGND|VSS A|B|BUSY|DOUT2|GND|VGND|VSS
+ nfet L=0.15U W=0.65U AS=0.1118P AD=0.182P PS=1.04U PD=1.86U
* device instance $494 r0 *1 135.03,-88 nfet
M$494 B|Y A|A0|B|DOUT9 A|B|BUSY|DOUT2|GND|VGND|VSS A|B|BUSY|DOUT2|GND|VGND|VSS
+ nfet L=0.15U W=0.65U AS=0.169P AD=0.169P PS=1.82U PD=1.82U
* device instance $495 r0 *1 136.845,-92.295 nfet
M$495 \$488 A|A0|B|DOUT9 \$481 A|B|BUSY|DOUT2|GND|VGND|VSS nfet L=0.15U W=0.42U
+ AS=0.1176P AD=0.0567P PS=1.4U PD=0.69U
* device instance $496 r0 *1 137.265,-92.295 nfet
M$496 \$488 A|B|DOUT4 A|B|BUSY|DOUT2|GND|VGND|VSS A|B|BUSY|DOUT2|GND|VGND|VSS
+ nfet L=0.15U W=0.42U AS=0.1118P AD=0.0567P PS=1.04U PD=0.69U
* device instance $497 r0 *1 137.805,-92.32 nfet
M$497 SELp4|X \$481 A|B|BUSY|DOUT2|GND|VGND|VSS A|B|BUSY|DOUT2|GND|VGND|VSS
+ nfet L=0.15U W=0.65U AS=0.1118P AD=0.182P PS=1.04U PD=1.86U
* device instance $498 r0 *1 97.145,-86.88 nfet
M$498 \$522 B|Y A|B|BUSY|DOUT2|GND|VGND|VSS A|B|BUSY|DOUT2|GND|VGND|VSS nfet
+ L=0.15U W=0.65U AS=0.169P AD=0.08775P PS=1.82U PD=0.92U
* device instance $499 r0 *1 97.565,-86.88 nfet
M$499 A|B|BUSY|DOUT2|GND|VGND|VSS
+ A|A_N|B|D|DOUT0|DOUT7|PH_B6|PH_B9|Q|S|VPB|VPWR \$522
+ A|B|BUSY|DOUT2|GND|VGND|VSS nfet L=0.15U W=0.65U AS=0.08775P AD=0.08775P
+ PS=0.92U PD=0.92U
* device instance $500 r0 *1 97.985,-86.88 nfet
M$500 \$544 A|A_N|B|D|DOUT0|DOUT7|PH_B6|PH_B9|Q|S|VPB|VPWR
+ A|B|BUSY|DOUT2|GND|VGND|VSS A|B|BUSY|DOUT2|GND|VGND|VSS nfet L=0.15U W=0.65U
+ AS=0.08775P AD=0.08775P PS=0.92U PD=0.92U
* device instance $501 r0 *1 98.405,-86.88 nfet
M$501 ADCOUT0|X B|Y \$544 A|B|BUSY|DOUT2|GND|VGND|VSS nfet L=0.15U W=0.65U
+ AS=0.08775P AD=0.25025P PS=0.92U PD=1.42U
* device instance $502 r0 *1 99.325,-86.88 nfet
M$502 A|B|BUSY|DOUT2|GND|VGND|VSS \$522 ADCOUT0|X A|B|BUSY|DOUT2|GND|VGND|VSS
+ nfet L=0.15U W=0.65U AS=0.25025P AD=0.208P PS=1.42U PD=1.94U
* device instance $503 r0 *1 102.83,-86.88 nfet
M$503 HALF_LSB_ENN|Y A|HALF_LSB_EN|X A|B|BUSY|DOUT2|GND|VGND|VSS
+ A|B|BUSY|DOUT2|GND|VGND|VSS nfet L=0.15U W=0.65U AS=0.169P AD=0.169P PS=1.82U
+ PD=1.82U
* device instance $504 r0 *1 110.625,-88.025 nfet
M$504 \$519 A|A_N|B|D|DOUT0|DOUT7|PH_B6|PH_B9|Q|S|VPB|VPWR \$499
+ A|B|BUSY|DOUT2|GND|VGND|VSS nfet L=0.15U W=0.42U AS=0.1176P AD=0.0567P
+ PS=1.4U PD=0.69U
* device instance $505 r0 *1 111.045,-88.025 nfet
M$505 \$519 B|Y A|B|BUSY|DOUT2|GND|VGND|VSS A|B|BUSY|DOUT2|GND|VGND|VSS nfet
+ L=0.15U W=0.42U AS=0.1118P AD=0.0567P PS=1.04U PD=0.69U
* device instance $506 r0 *1 111.585,-88 nfet
M$506 SELn7|X \$499 A|B|BUSY|DOUT2|GND|VGND|VSS A|B|BUSY|DOUT2|GND|VGND|VSS
+ nfet L=0.15U W=0.65U AS=0.1118P AD=0.182P PS=1.04U PD=1.86U
* device instance $507 r0 *1 113.765,-86.88 nfet
M$507 \$547 A|A0|B|DOUT9 \$531 A|B|BUSY|DOUT2|GND|VGND|VSS nfet L=0.15U W=0.65U
+ AS=0.169P AD=0.06825P PS=1.82U PD=0.86U
* device instance $508 r0 *1 114.125,-86.88 nfet
M$508 A|B|BUSY|DOUT2|GND|VGND|VSS A|A1|OUTN|OUTN_NC \$547
+ A|B|BUSY|DOUT2|GND|VGND|VSS nfet L=0.15U W=0.65U AS=0.06825P AD=0.08775P
+ PS=0.86U PD=0.92U
* device instance $509 r0 *1 114.545,-86.88 nfet
M$509 \$530 A|A1|OUTN|OUTN_NC A|B|BUSY|DOUT2|GND|VGND|VSS
+ A|B|BUSY|DOUT2|GND|VGND|VSS nfet L=0.15U W=0.65U AS=0.08775P AD=0.169P
+ PS=0.92U PD=1.82U
* device instance $510 r0 *1 115.485,-86.88 nfet
M$510 \$530 A|A0|B|DOUT9 A|B|BUSY|DOUT2|GND|VGND|VSS
+ A|B|BUSY|DOUT2|GND|VGND|VSS nfet L=0.15U W=0.65U AS=0.169P AD=0.08775P
+ PS=1.82U PD=0.92U
* device instance $511 r0 *1 115.905,-86.88 nfet
M$511 DUMLOAD_XNOR_NC|Y \$531 \$530 A|B|BUSY|DOUT2|GND|VGND|VSS nfet L=0.15U
+ W=0.65U AS=0.08775P AD=0.195P PS=0.92U PD=1.9U
* device instance $512 r0 *1 117.525,-88.025 nfet
M$512 \$517 A|A0|B|DOUT9 \$501 A|B|BUSY|DOUT2|GND|VGND|VSS nfet L=0.15U W=0.42U
+ AS=0.1176P AD=0.0567P PS=1.4U PD=0.69U
* device instance $513 r0 *1 117.945,-88.025 nfet
M$513 \$517 A|B|DOUT1 A|B|BUSY|DOUT2|GND|VGND|VSS A|B|BUSY|DOUT2|GND|VGND|VSS
+ nfet L=0.15U W=0.42U AS=0.1118P AD=0.0567P PS=1.04U PD=0.69U
* device instance $514 r0 *1 118.485,-88 nfet
M$514 SELp1|X \$501 A|B|BUSY|DOUT2|GND|VGND|VSS A|B|BUSY|DOUT2|GND|VGND|VSS
+ nfet L=0.15U W=0.65U AS=0.1118P AD=0.182P PS=1.04U PD=1.86U
* device instance $515 r0 *1 121.525,-86.88 nfet
M$515 \$534 B|Y A|B|BUSY|DOUT2|GND|VGND|VSS A|B|BUSY|DOUT2|GND|VGND|VSS nfet
+ L=0.15U W=0.65U AS=0.169P AD=0.08775P PS=1.82U PD=0.92U
* device instance $516 r0 *1 121.945,-86.88 nfet
M$516 A|B|BUSY|DOUT2|GND|VGND|VSS A|B|DOUT5 \$534 A|B|BUSY|DOUT2|GND|VGND|VSS
+ nfet L=0.15U W=0.65U AS=0.08775P AD=0.08775P PS=0.92U PD=0.92U
* device instance $517 r0 *1 122.365,-86.88 nfet
M$517 \$549 A|B|DOUT5 A|B|BUSY|DOUT2|GND|VGND|VSS A|B|BUSY|DOUT2|GND|VGND|VSS
+ nfet L=0.15U W=0.65U AS=0.08775P AD=0.08775P PS=0.92U PD=0.92U
* device instance $518 r0 *1 122.785,-86.88 nfet
M$518 ADCOUT5|X B|Y \$549 A|B|BUSY|DOUT2|GND|VGND|VSS nfet L=0.15U W=0.65U
+ AS=0.08775P AD=0.25025P PS=0.92U PD=1.42U
* device instance $519 r0 *1 123.705,-86.88 nfet
M$519 A|B|BUSY|DOUT2|GND|VGND|VSS \$534 ADCOUT5|X A|B|BUSY|DOUT2|GND|VGND|VSS
+ nfet L=0.15U W=0.65U AS=0.25025P AD=0.208P PS=1.42U PD=1.94U
* device instance $520 r0 *1 124.91,-86.88 nfet
M$520 CLK|CLKN|Y A|CLK$1 A|B|BUSY|DOUT2|GND|VGND|VSS
+ A|B|BUSY|DOUT2|GND|VGND|VSS nfet L=0.15U W=0.65U AS=0.169P AD=0.169P PS=1.82U
+ PD=1.82U
* device instance $521 r0 *1 127.185,-88.025 nfet
M$521 \$515 A|A0|B|DOUT9 \$506 A|B|BUSY|DOUT2|GND|VGND|VSS nfet L=0.15U W=0.42U
+ AS=0.1176P AD=0.0567P PS=1.4U PD=0.69U
* device instance $522 r0 *1 127.605,-88.025 nfet
M$522 \$515 A|A_N|B|D|DOUT0|DOUT7|PH_B6|PH_B9|Q|S|VPB|VPWR
+ A|B|BUSY|DOUT2|GND|VGND|VSS A|B|BUSY|DOUT2|GND|VGND|VSS nfet L=0.15U W=0.42U
+ AS=0.1118P AD=0.0567P PS=1.04U PD=0.69U
* device instance $523 r0 *1 128.145,-88 nfet
M$523 SELp7|X \$506 A|B|BUSY|DOUT2|GND|VGND|VSS A|B|BUSY|DOUT2|GND|VGND|VSS
+ nfet L=0.15U W=0.65U AS=0.1118P AD=0.182P PS=1.04U PD=1.86U
* device instance $524 r0 *1 136.845,-88.025 nfet
M$524 \$514 A|B|DOUT6 \$508 A|B|BUSY|DOUT2|GND|VGND|VSS nfet L=0.15U W=0.42U
+ AS=0.1176P AD=0.0567P PS=1.4U PD=0.69U
* device instance $525 r0 *1 137.265,-88.025 nfet
M$525 \$514 B|Y A|B|BUSY|DOUT2|GND|VGND|VSS A|B|BUSY|DOUT2|GND|VGND|VSS nfet
+ L=0.15U W=0.42U AS=0.1118P AD=0.0567P PS=1.04U PD=0.69U
* device instance $526 r0 *1 137.805,-88 nfet
M$526 SELn6|X \$508 A|B|BUSY|DOUT2|GND|VGND|VSS A|B|BUSY|DOUT2|GND|VGND|VSS
+ nfet L=0.15U W=0.65U AS=0.1118P AD=0.182P PS=1.04U PD=1.86U
* device instance $527 r0 *1 107.405,-86.855 nfet
M$527 \$545 A|A0|B|DOUT9 \$525 A|B|BUSY|DOUT2|GND|VGND|VSS nfet L=0.15U W=0.42U
+ AS=0.1176P AD=0.0567P PS=1.4U PD=0.69U
* device instance $528 r0 *1 107.825,-86.855 nfet
M$528 \$545 A|A_N|B|D|DOUT0|DOUT7|PH_B6|PH_B9|Q|S|VPB|VPWR
+ A|B|BUSY|DOUT2|GND|VGND|VSS A|B|BUSY|DOUT2|GND|VGND|VSS nfet L=0.15U W=0.42U
+ AS=0.1118P AD=0.0567P PS=1.04U PD=0.69U
* device instance $529 r0 *1 108.365,-86.88 nfet
M$529 SELp0|X \$525 A|B|BUSY|DOUT2|GND|VGND|VSS A|B|BUSY|DOUT2|GND|VGND|VSS
+ nfet L=0.15U W=0.65U AS=0.1118P AD=0.182P PS=1.04U PD=1.86U
* device instance $530 r0 *1 110.165,-86.855 nfet
M$530 \$546 A|B|DOUT3 \$527 A|B|BUSY|DOUT2|GND|VGND|VSS nfet L=0.15U W=0.42U
+ AS=0.1176P AD=0.0567P PS=1.4U PD=0.69U
* device instance $531 r0 *1 110.585,-86.855 nfet
M$531 \$546 B|Y A|B|BUSY|DOUT2|GND|VGND|VSS A|B|BUSY|DOUT2|GND|VGND|VSS nfet
+ L=0.15U W=0.42U AS=0.1118P AD=0.0567P PS=1.04U PD=0.69U
* device instance $532 r0 *1 111.125,-86.88 nfet
M$532 SELn3|X \$527 A|B|BUSY|DOUT2|GND|VGND|VSS A|B|BUSY|DOUT2|GND|VGND|VSS
+ nfet L=0.15U W=0.65U AS=0.1118P AD=0.182P PS=1.04U PD=1.86U
* device instance $533 r0 *1 118.305,-82.56 nfet
M$533 \$564 B|Y A|B|BUSY|DOUT2|GND|VGND|VSS A|B|BUSY|DOUT2|GND|VGND|VSS nfet
+ L=0.15U W=0.65U AS=0.169P AD=0.08775P PS=1.82U PD=0.92U
* device instance $534 r0 *1 118.725,-82.56 nfet
M$534 A|B|BUSY|DOUT2|GND|VGND|VSS A|B|DOUT1 \$564 A|B|BUSY|DOUT2|GND|VGND|VSS
+ nfet L=0.15U W=0.65U AS=0.08775P AD=0.08775P PS=0.92U PD=0.92U
* device instance $535 r0 *1 119.145,-82.56 nfet
M$535 \$584 A|B|DOUT1 A|B|BUSY|DOUT2|GND|VGND|VSS A|B|BUSY|DOUT2|GND|VGND|VSS
+ nfet L=0.15U W=0.65U AS=0.08775P AD=0.08775P PS=0.92U PD=0.92U
* device instance $536 r0 *1 119.565,-82.56 nfet
M$536 ADCOUT1|X B|Y \$584 A|B|BUSY|DOUT2|GND|VGND|VSS nfet L=0.15U W=0.65U
+ AS=0.08775P AD=0.25025P PS=0.92U PD=1.42U
* device instance $537 r0 *1 120.485,-82.56 nfet
M$537 A|B|BUSY|DOUT2|GND|VGND|VSS \$564 ADCOUT1|X A|B|BUSY|DOUT2|GND|VGND|VSS
+ nfet L=0.15U W=0.65U AS=0.25025P AD=0.208P PS=1.42U PD=1.94U
* device instance $538 r0 *1 119.365,-86.855 nfet
M$538 \$548 A|B|BUSY|DOUT2|GND|VGND|VSS \$532 A|B|BUSY|DOUT2|GND|VGND|VSS nfet
+ L=0.15U W=0.42U AS=0.1176P AD=0.0567P PS=1.4U PD=0.69U
* device instance $539 r0 *1 119.785,-86.855 nfet
M$539 \$548 B|Y A|B|BUSY|DOUT2|GND|VGND|VSS A|B|BUSY|DOUT2|GND|VGND|VSS nfet
+ L=0.15U W=0.42U AS=0.1118P AD=0.0567P PS=1.04U PD=0.69U
* device instance $540 r0 *1 120.325,-86.88 nfet
M$540 SELn2|X \$532 A|B|BUSY|DOUT2|GND|VGND|VSS A|B|BUSY|DOUT2|GND|VGND|VSS
+ nfet L=0.15U W=0.65U AS=0.1118P AD=0.182P PS=1.04U PD=1.86U
* device instance $541 r0 *1 122.445,-82.56 nfet
M$541 \$567 B|Y A|B|BUSY|DOUT2|GND|VGND|VSS A|B|BUSY|DOUT2|GND|VGND|VSS nfet
+ L=0.15U W=0.65U AS=0.169P AD=0.08775P PS=1.82U PD=0.92U
* device instance $542 r0 *1 122.865,-82.56 nfet
M$542 A|B|BUSY|DOUT2|GND|VGND|VSS A|B|DOUT6 \$567 A|B|BUSY|DOUT2|GND|VGND|VSS
+ nfet L=0.15U W=0.65U AS=0.08775P AD=0.08775P PS=0.92U PD=0.92U
* device instance $543 r0 *1 123.285,-82.56 nfet
M$543 \$583 A|B|DOUT6 A|B|BUSY|DOUT2|GND|VGND|VSS A|B|BUSY|DOUT2|GND|VGND|VSS
+ nfet L=0.15U W=0.65U AS=0.08775P AD=0.08775P PS=0.92U PD=0.92U
* device instance $544 r0 *1 123.705,-82.56 nfet
M$544 ADCOUT6|X B|Y \$583 A|B|BUSY|DOUT2|GND|VGND|VSS nfet L=0.15U W=0.65U
+ AS=0.08775P AD=0.25025P PS=0.92U PD=1.42U
* device instance $545 r0 *1 124.625,-82.56 nfet
M$545 A|B|BUSY|DOUT2|GND|VGND|VSS \$567 ADCOUT6|X A|B|BUSY|DOUT2|GND|VGND|VSS
+ nfet L=0.15U W=0.65U AS=0.25025P AD=0.208P PS=1.42U PD=1.94U
* device instance $546 r0 *1 128.565,-86.855 nfet
M$546 \$550 A|A0|B|DOUT9 \$538 A|B|BUSY|DOUT2|GND|VGND|VSS nfet L=0.15U W=0.42U
+ AS=0.1176P AD=0.0567P PS=1.4U PD=0.69U
* device instance $547 r0 *1 128.985,-86.855 nfet
M$547 \$550 A|B|DOUT8 A|B|BUSY|DOUT2|GND|VGND|VSS A|B|BUSY|DOUT2|GND|VGND|VSS
+ nfet L=0.15U W=0.42U AS=0.1118P AD=0.0567P PS=1.04U PD=0.69U
* device instance $548 r0 *1 129.525,-86.88 nfet
M$548 SELp8|X \$538 A|B|BUSY|DOUT2|GND|VGND|VSS A|B|BUSY|DOUT2|GND|VGND|VSS
+ nfet L=0.15U W=0.65U AS=0.1118P AD=0.182P PS=1.04U PD=1.86U
* device instance $549 r0 *1 132.245,-86.855 nfet
M$549 \$552 A|A0|B|DOUT9 \$540 A|B|BUSY|DOUT2|GND|VGND|VSS nfet L=0.15U W=0.42U
+ AS=0.1176P AD=0.0567P PS=1.4U PD=0.69U
* device instance $550 r0 *1 132.665,-86.855 nfet
M$550 \$552 A|B|DOUT3 A|B|BUSY|DOUT2|GND|VGND|VSS A|B|BUSY|DOUT2|GND|VGND|VSS
+ nfet L=0.15U W=0.42U AS=0.1118P AD=0.0567P PS=1.04U PD=0.69U
* device instance $551 r0 *1 133.205,-86.88 nfet
M$551 SELp3|X \$540 A|B|BUSY|DOUT2|GND|VGND|VSS A|B|BUSY|DOUT2|GND|VGND|VSS
+ nfet L=0.15U W=0.65U AS=0.1118P AD=0.182P PS=1.04U PD=1.86U
* device instance $552 r0 *1 135.925,-86.855 nfet
M$552 \$551 A|B|DOUT5 \$542 A|B|BUSY|DOUT2|GND|VGND|VSS nfet L=0.15U W=0.42U
+ AS=0.1176P AD=0.0567P PS=1.4U PD=0.69U
* device instance $553 r0 *1 136.345,-86.855 nfet
M$553 \$551 B|Y A|B|BUSY|DOUT2|GND|VGND|VSS A|B|BUSY|DOUT2|GND|VGND|VSS nfet
+ L=0.15U W=0.42U AS=0.1118P AD=0.0567P PS=1.04U PD=0.69U
* device instance $554 r0 *1 136.885,-86.88 nfet
M$554 SELn5|X \$542 A|B|BUSY|DOUT2|GND|VGND|VSS A|B|BUSY|DOUT2|GND|VGND|VSS
+ nfet L=0.15U W=0.65U AS=0.1118P AD=0.182P PS=1.04U PD=1.86U
* device instance $555 r0 *1 4.545,-29.5 nfet
M$555 \$589 SELp0|X VREFN A|B|BUSY|DOUT2|GND|VGND|VSS nfet L=0.15U W=1U
+ AS=0.47P AD=0.47P PS=2.94U PD=2.94U
* device instance $556 r0 *1 15.545,-29.5 nfet
M$556 \$590 SELp1|X VREFN A|B|BUSY|DOUT2|GND|VGND|VSS nfet L=0.15U W=1U
+ AS=0.47P AD=0.47P PS=2.94U PD=2.94U
* device instance $557 r0 *1 26.545,-29.5 nfet
M$557 \$591 SELp2|X VREFN A|B|BUSY|DOUT2|GND|VGND|VSS nfet L=0.15U W=1U
+ AS=0.47P AD=0.47P PS=2.94U PD=2.94U
* device instance $558 r0 *1 37.545,-29.5 nfet
M$558 \$592 SELp3|X VREFN A|B|BUSY|DOUT2|GND|VGND|VSS nfet L=0.15U W=1U
+ AS=0.47P AD=0.47P PS=2.94U PD=2.94U
* device instance $559 r0 *1 48.545,-29.5 nfet
M$559 \$593 SELp4|X VREFN A|B|BUSY|DOUT2|GND|VGND|VSS nfet L=0.15U W=1U
+ AS=0.47P AD=0.47P PS=2.94U PD=2.94U
* device instance $560 r0 *1 59.545,-29.5 nfet
M$560 \$594 SELp5|X VREFN A|B|BUSY|DOUT2|GND|VGND|VSS nfet L=0.15U W=1U
+ AS=0.47P AD=0.47P PS=2.94U PD=2.94U
* device instance $561 r0 *1 70.545,-29.5 nfet
M$561 \$607 SELp6|X VREFN A|B|BUSY|DOUT2|GND|VGND|VSS nfet L=0.15U W=1U
+ AS=0.47P AD=0.47P PS=2.94U PD=2.94U
* device instance $562 r0 *1 81.545,-29.5 nfet
M$562 \$606 SELp7|X VREFN A|B|BUSY|DOUT2|GND|VGND|VSS nfet L=0.15U W=1U
+ AS=0.47P AD=0.47P PS=2.94U PD=2.94U
* device instance $563 r0 *1 92.545,-29.5 nfet
M$563 \$605 SELp8|X VREFN A|B|BUSY|DOUT2|GND|VGND|VSS nfet L=0.15U W=1U
+ AS=0.47P AD=0.47P PS=2.94U PD=2.94U
* device instance $564 r0 *1 101.885,-82.585 nfet
M$564 \$579 A|B|DOUT8 \$558 A|B|BUSY|DOUT2|GND|VGND|VSS nfet L=0.15U W=0.42U
+ AS=0.1176P AD=0.0567P PS=1.4U PD=0.69U
* device instance $565 r0 *1 102.305,-82.585 nfet
M$565 \$579 B|Y A|B|BUSY|DOUT2|GND|VGND|VSS A|B|BUSY|DOUT2|GND|VGND|VSS nfet
+ L=0.15U W=0.42U AS=0.1118P AD=0.0567P PS=1.04U PD=0.69U
* device instance $566 r0 *1 102.845,-82.56 nfet
M$566 SELn8|X \$558 A|B|BUSY|DOUT2|GND|VGND|VSS A|B|BUSY|DOUT2|GND|VGND|VSS
+ nfet L=0.15U W=0.65U AS=0.1118P AD=0.182P PS=1.04U PD=1.86U
* device instance $567 r0 *1 103.545,-29.5 nfet
M$567 \$595 SELn0|X VREFN A|B|BUSY|DOUT2|GND|VGND|VSS nfet L=0.15U W=1U
+ AS=0.47P AD=0.47P PS=2.94U PD=2.94U
* device instance $568 r0 *1 108.325,-82.585 nfet
M$568 \$581 A|A0|B|DOUT9 \$560 A|B|BUSY|DOUT2|GND|VGND|VSS nfet L=0.15U W=0.42U
+ AS=0.1176P AD=0.0567P PS=1.4U PD=0.69U
* device instance $569 r0 *1 108.745,-82.585 nfet
M$569 \$581 A|B|BUSY|DOUT2|GND|VGND|VSS A|B|BUSY|DOUT2|GND|VGND|VSS
+ A|B|BUSY|DOUT2|GND|VGND|VSS nfet L=0.15U W=0.42U AS=0.1118P AD=0.0567P
+ PS=1.04U PD=0.69U
* device instance $570 r0 *1 109.285,-82.56 nfet
M$570 SELp2|X \$560 A|B|BUSY|DOUT2|GND|VGND|VSS A|B|BUSY|DOUT2|GND|VGND|VSS
+ nfet L=0.15U W=0.65U AS=0.1118P AD=0.182P PS=1.04U PD=1.86U
* device instance $571 r0 *1 114.545,-29.5 nfet
M$571 \$596 SELn1|X VREFN A|B|BUSY|DOUT2|GND|VGND|VSS nfet L=0.15U W=1U
+ AS=0.47P AD=0.47P PS=2.94U PD=2.94U
* device instance $572 r0 *1 114.585,-82.445 nfet
M$572 \$562 A|A_N|B|D|DOUT0|DOUT7|PH_B6|PH_B9|Q|S|VPB|VPWR
+ A|B|BUSY|DOUT2|GND|VGND|VSS A|B|BUSY|DOUT2|GND|VGND|VSS nfet L=0.15U W=0.42U
+ AS=0.1092P AD=0.1092P PS=1.36U PD=1.36U
* device instance $573 r0 *1 115.525,-82.445 nfet
M$573 \$585 \$562 \$563 A|B|BUSY|DOUT2|GND|VGND|VSS nfet L=0.15U W=0.42U
+ AS=0.1092P AD=0.0504P PS=1.36U PD=0.66U
* device instance $574 r0 *1 115.915,-82.445 nfet
M$574 \$585 A|B|BUSY|DOUT2|GND|VGND|VSS A|B|BUSY|DOUT2|GND|VGND|VSS
+ A|B|BUSY|DOUT2|GND|VGND|VSS nfet L=0.15U W=0.42U AS=0.1013P AD=0.0504P
+ PS=0.99U PD=0.66U
* device instance $575 r0 *1 116.405,-82.56 nfet
M$575 A|HALF_LSB_EN|X \$563 A|B|BUSY|DOUT2|GND|VGND|VSS
+ A|B|BUSY|DOUT2|GND|VGND|VSS nfet L=0.15U W=0.65U AS=0.1013P AD=0.169P
+ PS=0.99U PD=1.82U
* device instance $576 r0 *1 125.545,-29.5 nfet
M$576 \$597 SELn2|X VREFN A|B|BUSY|DOUT2|GND|VGND|VSS nfet L=0.15U W=1U
+ AS=0.47P AD=0.47P PS=2.94U PD=2.94U
* device instance $577 r0 *1 128.565,-82.585 nfet
M$577 \$582 A|A0|B|DOUT9 \$570 A|B|BUSY|DOUT2|GND|VGND|VSS nfet L=0.15U W=0.42U
+ AS=0.1176P AD=0.0567P PS=1.4U PD=0.69U
* device instance $578 r0 *1 128.985,-82.585 nfet
M$578 \$582 A|B|DOUT5 A|B|BUSY|DOUT2|GND|VGND|VSS A|B|BUSY|DOUT2|GND|VGND|VSS
+ nfet L=0.15U W=0.42U AS=0.1118P AD=0.0567P PS=1.04U PD=0.69U
* device instance $579 r0 *1 129.525,-82.56 nfet
M$579 SELp5|X \$570 A|B|BUSY|DOUT2|GND|VGND|VSS A|B|BUSY|DOUT2|GND|VGND|VSS
+ nfet L=0.15U W=0.65U AS=0.1118P AD=0.182P PS=1.04U PD=1.86U
* device instance $580 r0 *1 132.245,-82.585 nfet
M$580 \$580 A|A_N|B|D|DOUT0|DOUT7|PH_B6|PH_B9|Q|S|VPB|VPWR \$572
+ A|B|BUSY|DOUT2|GND|VGND|VSS nfet L=0.15U W=0.42U AS=0.1176P AD=0.0567P
+ PS=1.4U PD=0.69U
* device instance $581 r0 *1 132.665,-82.585 nfet
M$581 \$580 B|Y A|B|BUSY|DOUT2|GND|VGND|VSS A|B|BUSY|DOUT2|GND|VGND|VSS nfet
+ L=0.15U W=0.42U AS=0.1118P AD=0.0567P PS=1.04U PD=0.69U
* device instance $582 r0 *1 133.205,-82.56 nfet
M$582 SELn0|X \$572 A|B|BUSY|DOUT2|GND|VGND|VSS A|B|BUSY|DOUT2|GND|VGND|VSS
+ nfet L=0.15U W=0.65U AS=0.1118P AD=0.182P PS=1.04U PD=1.86U
* device instance $583 r0 *1 136.385,-82.585 nfet
M$583 \$578 A|B|DOUT4 \$574 A|B|BUSY|DOUT2|GND|VGND|VSS nfet L=0.15U W=0.42U
+ AS=0.1176P AD=0.0567P PS=1.4U PD=0.69U
* device instance $584 r0 *1 136.805,-82.585 nfet
M$584 \$578 B|Y A|B|BUSY|DOUT2|GND|VGND|VSS A|B|BUSY|DOUT2|GND|VGND|VSS nfet
+ L=0.15U W=0.42U AS=0.1118P AD=0.0567P PS=1.04U PD=0.69U
* device instance $585 r0 *1 137.345,-82.56 nfet
M$585 SELn4|X \$574 A|B|BUSY|DOUT2|GND|VGND|VSS A|B|BUSY|DOUT2|GND|VGND|VSS
+ nfet L=0.15U W=0.65U AS=0.1118P AD=0.182P PS=1.04U PD=1.86U
* device instance $586 r0 *1 136.545,-29.5 nfet
M$586 \$598 SELn3|X VREFN A|B|BUSY|DOUT2|GND|VGND|VSS nfet L=0.15U W=1U
+ AS=0.47P AD=0.47P PS=2.94U PD=2.94U
* device instance $587 r0 *1 147.545,-29.5 nfet
M$587 \$599 SELn4|X VREFN A|B|BUSY|DOUT2|GND|VGND|VSS nfet L=0.15U W=1U
+ AS=0.47P AD=0.47P PS=2.94U PD=2.94U
* device instance $588 r0 *1 158.545,-29.5 nfet
M$588 \$604 SELn5|X VREFN A|B|BUSY|DOUT2|GND|VGND|VSS nfet L=0.15U W=1U
+ AS=0.47P AD=0.47P PS=2.94U PD=2.94U
* device instance $589 r0 *1 169.545,-29.5 nfet
M$589 \$603 SELn6|X VREFN A|B|BUSY|DOUT2|GND|VGND|VSS nfet L=0.15U W=1U
+ AS=0.47P AD=0.47P PS=2.94U PD=2.94U
* device instance $590 r0 *1 180.545,-29.5 nfet
M$590 \$602 SELn7|X VREFN A|B|BUSY|DOUT2|GND|VGND|VSS nfet L=0.15U W=1U
+ AS=0.47P AD=0.47P PS=2.94U PD=2.94U
* device instance $591 r0 *1 191.545,-29.5 nfet
M$591 \$601 SELn8|X VREFN A|B|BUSY|DOUT2|GND|VGND|VSS nfet L=0.15U W=1U
+ AS=0.47P AD=0.47P PS=2.94U PD=2.94U
* device instance $592 r0 *1 102.87,193.8 nfet
M$592 \$628 CLK|CLKN|Y A|B|BUSY|DOUT2|GND|VGND|VSS A|B|BUSY|DOUT2|GND|VGND|VSS
+ nfet L=0.5U W=8U AS=3.36P AD=3.36P PS=16.84U PD=16.84U
* device instance $593 r0 *1 106.37,195.41 nfet
M$593 \$625 TOP_P|VINP \$628 A|B|BUSY|DOUT2|GND|VGND|VSS nfet L=0.5U W=2U
+ AS=0.84P AD=0.84P PS=4.84U PD=4.84U
* device instance $594 r0 *1 106.37,192.19 nfet
M$594 \$624 TOP_N|VINN \$628 A|B|BUSY|DOUT2|GND|VGND|VSS nfet L=0.5U W=2U
+ AS=0.84P AD=0.84P PS=4.84U PD=4.84U
* device instance $595 r0 *1 106.84,89.25 nfet
M$595 VINP \$615 TOP_P|VINP A|B|BUSY|DOUT2|GND|VGND|VSS nfet L=0.15U W=2U
+ AS=0.94P AD=0.94P PS=4.94U PD=4.94U
* device instance $596 r0 *1 108.11,192.19 nfet
M$596 \$625 TOP_P|VINP \$628 A|B|BUSY|DOUT2|GND|VGND|VSS nfet L=0.5U W=2U
+ AS=0.84P AD=0.84P PS=4.84U PD=4.84U
* device instance $597 r0 *1 108.11,195.41 nfet
M$597 \$624 TOP_N|VINN \$628 A|B|BUSY|DOUT2|GND|VGND|VSS nfet L=0.5U W=2U
+ AS=0.84P AD=0.84P PS=4.84U PD=4.84U
* device instance $598 r0 *1 109.13,89.25 nfet
M$598 VINN \$621 TOP_N|VINN A|B|BUSY|DOUT2|GND|VGND|VSS nfet L=0.15U W=2U
+ AS=0.94P AD=0.94P PS=4.94U PD=4.94U
* device instance $599 r0 *1 111.57,196.41 nfet
M$599 A|A1|OUTN|OUTN_NC OUTP \$625 A|B|BUSY|DOUT2|GND|VGND|VSS nfet L=0.5U W=4U
+ AS=1.68P AD=1.68P PS=8.84U PD=8.84U
* device instance $600 r0 *1 111.57,191.19 nfet
M$600 OUTP A|A1|OUTN|OUTN_NC \$624 A|B|BUSY|DOUT2|GND|VGND|VSS nfet L=0.5U W=4U
+ AS=1.68P AD=1.68P PS=8.84U PD=8.84U
* device instance $601 r0 *1 111.42,88.75 nfet
M$601 \$618 \$616 A|B|BUSY|DOUT2|GND|VGND|VSS A|B|BUSY|DOUT2|GND|VGND|VSS nfet
+ L=0.15U W=1U AS=0.47P AD=0.47P PS=2.94U PD=2.94U
* device instance $602 r0 *1 113.71,88.75 nfet
M$602 \$618 RESET_B|RST_B|SAMPLE VINP A|B|BUSY|DOUT2|GND|VGND|VSS nfet L=0.15U
+ W=1U AS=0.47P AD=0.47P PS=2.94U PD=2.94U
* device instance $603 r0 *1 116.125,88.75 nfet
M$603 \$615 \$616 A|B|BUSY|DOUT2|GND|VGND|VSS A|B|BUSY|DOUT2|GND|VGND|VSS nfet
+ L=0.5U W=1U AS=0.42P AD=0.42P PS=2.84U PD=2.84U
* device instance $604 r0 *1 118.54,96.25 nfet
M$604 BPREF_P RESET_B|RST_B|SAMPLE VCM A|B|BUSY|DOUT2|GND|VGND|VSS nfet L=0.15U
+ W=16U AS=7.52P AD=7.52P PS=32.94U PD=32.94U
* device instance $605 r0 *1 120.83,96.25 nfet
M$605 BPREF_N RESET_B|RST_B|SAMPLE VCM A|B|BUSY|DOUT2|GND|VGND|VSS nfet L=0.15U
+ W=16U AS=7.52P AD=7.52P PS=32.94U PD=32.94U
* device instance $606 r0 *1 123.245,88.75 nfet
M$606 \$621 \$616 A|B|BUSY|DOUT2|GND|VGND|VSS A|B|BUSY|DOUT2|GND|VGND|VSS nfet
+ L=0.5U W=1U AS=0.42P AD=0.42P PS=2.84U PD=2.84U
* device instance $607 r0 *1 125.195,67.5 nfet
M$607 BOT_OFF_N A|HALF_LSB_EN|X VCM A|B|BUSY|DOUT2|GND|VGND|VSS nfet L=0.15U
+ W=1U AS=0.47P AD=0.47P PS=2.94U PD=2.94U
* device instance $608 r0 *1 125.66,88.75 nfet
M$608 \$620 RESET_B|RST_B|SAMPLE VINN A|B|BUSY|DOUT2|GND|VGND|VSS nfet L=0.15U
+ W=1U AS=0.47P AD=0.47P PS=2.94U PD=2.94U
* device instance $609 r0 *1 127.95,88.75 nfet
M$609 \$620 \$616 A|B|BUSY|DOUT2|GND|VGND|VSS A|B|BUSY|DOUT2|GND|VGND|VSS nfet
+ L=0.15U W=1U AS=0.47P AD=0.47P PS=2.94U PD=2.94U
* device instance $610 r0 *1 130.24,88.75 nfet
M$610 \$616 RESET_B|RST_B|SAMPLE A|B|BUSY|DOUT2|GND|VGND|VSS
+ A|B|BUSY|DOUT2|GND|VGND|VSS nfet L=0.15U W=1U AS=0.47P AD=0.47P PS=2.94U
+ PD=2.94U
* device instance $611 r0 *1 141.195,67.5 nfet
M$611 BOT_OFF_P A|B|BUSY|DOUT2|GND|VGND|VSS VCM A|B|BUSY|DOUT2|GND|VGND|VSS
+ nfet L=0.15U W=1U AS=0.47P AD=0.47P PS=2.94U PD=2.94U
* device instance $612 r0 *1 38.525,-144.115 pfet
M$612 \$6 D|X A|A_N|B|D|DOUT0|DOUT7|PH_B6|PH_B9|Q|S|VPB|VPWR
+ A|A_N|B|D|DOUT0|DOUT7|PH_B6|PH_B9|Q|S|VPB|VPWR pfet L=0.15U W=0.42U
+ AS=0.1092P AD=0.0651P PS=1.36U PD=0.73U
* device instance $613 r0 *1 38.985,-144.115 pfet
M$613 \$7 \$4 \$6 A|A_N|B|D|DOUT0|DOUT7|PH_B6|PH_B9|Q|S|VPB|VPWR pfet L=0.15U
+ W=0.42U AS=0.0651P AD=0.07245P PS=0.73U PD=0.765U
* device instance $614 r0 *1 39.48,-144.115 pfet
M$614 \$8 \$3 \$7 A|A_N|B|D|DOUT0|DOUT7|PH_B6|PH_B9|Q|S|VPB|VPWR pfet L=0.15U
+ W=0.42U AS=0.07245P AD=0.1155P PS=0.765U PD=0.97U
* device instance $615 r0 *1 40.18,-144.115 pfet
M$615 A|A_N|B|D|DOUT0|DOUT7|PH_B6|PH_B9|Q|S|VPB|VPWR \$10 \$8
+ A|A_N|B|D|DOUT0|DOUT7|PH_B6|PH_B9|Q|S|VPB|VPWR pfet L=0.15U W=0.42U
+ AS=0.1155P AD=0.07035P PS=0.97U PD=0.755U
* device instance $616 r0 *1 40.665,-144.115 pfet
M$616 \$8 RESET_B|RST_B|SAMPLE A|A_N|B|D|DOUT0|DOUT7|PH_B6|PH_B9|Q|S|VPB|VPWR
+ A|A_N|B|D|DOUT0|DOUT7|PH_B6|PH_B9|Q|S|VPB|VPWR pfet L=0.15U W=0.42U
+ AS=0.07035P AD=0.1092P PS=0.755U PD=1.36U
* device instance $617 r0 *1 42.145,-144.115 pfet
M$617 \$11 \$3 \$10 A|A_N|B|D|DOUT0|DOUT7|PH_B6|PH_B9|Q|S|VPB|VPWR pfet L=0.15U
+ W=0.42U AS=0.12915P AD=0.0588P PS=1.185U PD=0.7U
* device instance $618 r0 *1 42.575,-144.115 pfet
M$618 \$17 \$4 \$11 A|A_N|B|D|DOUT0|DOUT7|PH_B6|PH_B9|Q|S|VPB|VPWR pfet L=0.15U
+ W=0.42U AS=0.0588P AD=0.0567P PS=0.7U PD=0.69U
* device instance $619 r0 *1 42.995,-144.115 pfet
M$619 A|A_N|B|D|DOUT0|DOUT7|PH_B6|PH_B9|Q|S|VPB|VPWR \$12 \$17
+ A|A_N|B|D|DOUT0|DOUT7|PH_B6|PH_B9|Q|S|VPB|VPWR pfet L=0.15U W=0.42U
+ AS=0.0567P AD=0.0819P PS=0.69U PD=0.81U
* device instance $620 r0 *1 43.535,-144.115 pfet
M$620 \$12 RESET_B|RST_B|SAMPLE A|A_N|B|D|DOUT0|DOUT7|PH_B6|PH_B9|Q|S|VPB|VPWR
+ A|A_N|B|D|DOUT0|DOUT7|PH_B6|PH_B9|Q|S|VPB|VPWR pfet L=0.15U W=0.42U
+ AS=0.0819P AD=0.0567P PS=0.81U PD=0.69U
* device instance $621 r0 *1 43.955,-144.115 pfet
M$621 A|A_N|B|D|DOUT0|DOUT7|PH_B6|PH_B9|Q|S|VPB|VPWR \$11 \$12
+ A|A_N|B|D|DOUT0|DOUT7|PH_B6|PH_B9|Q|S|VPB|VPWR pfet L=0.15U W=0.42U
+ AS=0.0567P AD=0.1134P PS=0.69U PD=1.38U
* device instance $622 r0 *1 41.65,-143.905 pfet
M$622 \$10 \$7 A|A_N|B|D|DOUT0|DOUT7|PH_B6|PH_B9|Q|S|VPB|VPWR
+ A|A_N|B|D|DOUT0|DOUT7|PH_B6|PH_B9|Q|S|VPB|VPWR pfet L=0.15U W=0.84U
+ AS=0.2184P AD=0.12915P PS=2.2U PD=1.185U
* device instance $623 r0 *1 45.03,-143.825 pfet
M$623 A0|DOUT5|Q \$12 A|A_N|B|D|DOUT0|DOUT7|PH_B6|PH_B9|Q|S|VPB|VPWR
+ A|A_N|B|D|DOUT0|DOUT7|PH_B6|PH_B9|Q|S|VPB|VPWR pfet L=0.15U W=1U AS=0.3012P
+ AD=0.26P PS=2.66U PD=2.52U
* device instance $624 r0 *1 35.765,-138.675 pfet
M$624 \$32 D|X$2 A|A_N|B|D|DOUT0|DOUT7|PH_B6|PH_B9|Q|S|VPB|VPWR
+ A|A_N|B|D|DOUT0|DOUT7|PH_B6|PH_B9|Q|S|VPB|VPWR pfet L=0.15U W=0.42U
+ AS=0.1092P AD=0.0651P PS=1.36U PD=0.73U
* device instance $625 r0 *1 36.225,-138.675 pfet
M$625 \$33 \$30 \$32 A|A_N|B|D|DOUT0|DOUT7|PH_B6|PH_B9|Q|S|VPB|VPWR pfet
+ L=0.15U W=0.42U AS=0.0651P AD=0.07245P PS=0.73U PD=0.765U
* device instance $626 r0 *1 36.72,-138.675 pfet
M$626 \$34 \$29 \$33 A|A_N|B|D|DOUT0|DOUT7|PH_B6|PH_B9|Q|S|VPB|VPWR pfet
+ L=0.15U W=0.42U AS=0.07245P AD=0.1155P PS=0.765U PD=0.97U
* device instance $627 r0 *1 37.42,-138.675 pfet
M$627 A|A_N|B|D|DOUT0|DOUT7|PH_B6|PH_B9|Q|S|VPB|VPWR \$35 \$34
+ A|A_N|B|D|DOUT0|DOUT7|PH_B6|PH_B9|Q|S|VPB|VPWR pfet L=0.15U W=0.42U
+ AS=0.1155P AD=0.07035P PS=0.97U PD=0.755U
* device instance $628 r0 *1 37.905,-138.675 pfet
M$628 \$34 RESET_B|RST_B|SAMPLE A|A_N|B|D|DOUT0|DOUT7|PH_B6|PH_B9|Q|S|VPB|VPWR
+ A|A_N|B|D|DOUT0|DOUT7|PH_B6|PH_B9|Q|S|VPB|VPWR pfet L=0.15U W=0.42U
+ AS=0.07035P AD=0.1092P PS=0.755U PD=1.36U
* device instance $629 r0 *1 36.77,-143.975 pfet
M$629 A|A_N|B|D|DOUT0|DOUT7|PH_B6|PH_B9|Q|S|VPB|VPWR A|CLK|X \$3
+ A|A_N|B|D|DOUT0|DOUT7|PH_B6|PH_B9|Q|S|VPB|VPWR pfet L=0.15U W=0.64U
+ AS=0.1664P AD=0.0864P PS=1.8U PD=0.91U
* device instance $630 r0 *1 37.19,-143.975 pfet
M$630 \$4 \$3 A|A_N|B|D|DOUT0|DOUT7|PH_B6|PH_B9|Q|S|VPB|VPWR
+ A|A_N|B|D|DOUT0|DOUT7|PH_B6|PH_B9|Q|S|VPB|VPWR pfet L=0.15U W=0.64U
+ AS=0.0864P AD=0.1664P PS=0.91U PD=1.8U
* device instance $631 r0 *1 39.385,-138.675 pfet
M$631 \$36 \$29 \$35 A|A_N|B|D|DOUT0|DOUT7|PH_B6|PH_B9|Q|S|VPB|VPWR pfet
+ L=0.15U W=0.42U AS=0.12915P AD=0.0588P PS=1.185U PD=0.7U
* device instance $632 r0 *1 39.815,-138.675 pfet
M$632 \$52 \$30 \$36 A|A_N|B|D|DOUT0|DOUT7|PH_B6|PH_B9|Q|S|VPB|VPWR pfet
+ L=0.15U W=0.42U AS=0.0588P AD=0.0567P PS=0.7U PD=0.69U
* device instance $633 r0 *1 40.235,-138.675 pfet
M$633 A|A_N|B|D|DOUT0|DOUT7|PH_B6|PH_B9|Q|S|VPB|VPWR \$37 \$52
+ A|A_N|B|D|DOUT0|DOUT7|PH_B6|PH_B9|Q|S|VPB|VPWR pfet L=0.15U W=0.42U
+ AS=0.0567P AD=0.0819P PS=0.69U PD=0.81U
* device instance $634 r0 *1 40.775,-138.675 pfet
M$634 \$37 RESET_B|RST_B|SAMPLE A|A_N|B|D|DOUT0|DOUT7|PH_B6|PH_B9|Q|S|VPB|VPWR
+ A|A_N|B|D|DOUT0|DOUT7|PH_B6|PH_B9|Q|S|VPB|VPWR pfet L=0.15U W=0.42U
+ AS=0.0819P AD=0.0567P PS=0.81U PD=0.69U
* device instance $635 r0 *1 41.195,-138.675 pfet
M$635 A|A_N|B|D|DOUT0|DOUT7|PH_B6|PH_B9|Q|S|VPB|VPWR \$36 \$37
+ A|A_N|B|D|DOUT0|DOUT7|PH_B6|PH_B9|Q|S|VPB|VPWR pfet L=0.15U W=0.42U
+ AS=0.0567P AD=0.1134P PS=0.69U PD=1.38U
* device instance $636 r0 *1 38.89,-138.465 pfet
M$636 \$35 \$33 A|A_N|B|D|DOUT0|DOUT7|PH_B6|PH_B9|Q|S|VPB|VPWR
+ A|A_N|B|D|DOUT0|DOUT7|PH_B6|PH_B9|Q|S|VPB|VPWR pfet L=0.15U W=0.84U
+ AS=0.2184P AD=0.12915P PS=2.2U PD=1.185U
* device instance $637 r0 *1 39.53,-139.855 pfet
M$637 A|A_N|B|D|DOUT0|DOUT7|PH_B6|PH_B9|Q|S|VPB|VPWR A|X \$20
+ A|A_N|B|D|DOUT0|DOUT7|PH_B6|PH_B9|Q|S|VPB|VPWR pfet L=0.15U W=1U AS=0.26P
+ AD=0.135P PS=2.52U PD=1.27U
* device instance $638 r0 *1 39.95,-139.855 pfet
M$638 A|CLK|X \$20 A|A_N|B|D|DOUT0|DOUT7|PH_B6|PH_B9|Q|S|VPB|VPWR
+ A|A_N|B|D|DOUT0|DOUT7|PH_B6|PH_B9|Q|S|VPB|VPWR pfet L=0.15U W=1U AS=0.135P
+ AD=0.135P PS=1.27U PD=1.27U
* device instance $639 r0 *1 40.37,-139.855 pfet
M$639 A|A_N|B|D|DOUT0|DOUT7|PH_B6|PH_B9|Q|S|VPB|VPWR \$20 A|CLK|X
+ A|A_N|B|D|DOUT0|DOUT7|PH_B6|PH_B9|Q|S|VPB|VPWR pfet L=0.15U W=1U AS=0.135P
+ AD=0.135P PS=1.27U PD=1.27U
* device instance $640 r0 *1 40.79,-139.855 pfet
M$640 A|CLK|X \$20 A|A_N|B|D|DOUT0|DOUT7|PH_B6|PH_B9|Q|S|VPB|VPWR
+ A|A_N|B|D|DOUT0|DOUT7|PH_B6|PH_B9|Q|S|VPB|VPWR pfet L=0.15U W=1U AS=0.135P
+ AD=0.135P PS=1.27U PD=1.27U
* device instance $641 r0 *1 41.21,-139.855 pfet
M$641 A|A_N|B|D|DOUT0|DOUT7|PH_B6|PH_B9|Q|S|VPB|VPWR \$20 A|CLK|X
+ A|A_N|B|D|DOUT0|DOUT7|PH_B6|PH_B9|Q|S|VPB|VPWR pfet L=0.15U W=1U AS=0.135P
+ AD=0.26P PS=1.27U PD=2.52U
* device instance $642 r0 *1 42.27,-138.385 pfet
M$642 A0|DOUT3|Q \$37 A|A_N|B|D|DOUT0|DOUT7|PH_B6|PH_B9|Q|S|VPB|VPWR
+ A|A_N|B|D|DOUT0|DOUT7|PH_B6|PH_B9|Q|S|VPB|VPWR pfet L=0.15U W=1U AS=0.3012P
+ AD=0.26P PS=2.66U PD=2.52U
* device instance $643 r0 *1 52.13,-139.775 pfet
M$643 \$22 A|X$1 A|A_N|B|D|DOUT0|DOUT7|PH_B6|PH_B9|Q|S|VPB|VPWR
+ A|A_N|B|D|DOUT0|DOUT7|PH_B6|PH_B9|Q|S|VPB|VPWR pfet L=0.15U W=0.42U
+ AS=0.1176P AD=0.0567P PS=1.4U PD=0.69U
* device instance $644 r0 *1 52.55,-139.775 pfet
M$644 \$22 B|X A|A_N|B|D|DOUT0|DOUT7|PH_B6|PH_B9|Q|S|VPB|VPWR
+ A|A_N|B|D|DOUT0|DOUT7|PH_B6|PH_B9|Q|S|VPB|VPWR pfet L=0.15U W=0.42U
+ AS=0.16655P AD=0.0567P PS=1.39U PD=0.69U
* device instance $645 r0 *1 53.09,-139.855 pfet
M$645 D|X$1 \$22 A|A_N|B|D|DOUT0|DOUT7|PH_B6|PH_B9|Q|S|VPB|VPWR
+ A|A_N|B|D|DOUT0|DOUT7|PH_B6|PH_B9|Q|S|VPB|VPWR pfet L=0.15U W=1U AS=0.16655P
+ AD=0.475P PS=1.39U PD=2.95U
* device instance $646 r0 *1 54.165,-138.675 pfet
M$646 \$44 D|X$1 A|A_N|B|D|DOUT0|DOUT7|PH_B6|PH_B9|Q|S|VPB|VPWR
+ A|A_N|B|D|DOUT0|DOUT7|PH_B6|PH_B9|Q|S|VPB|VPWR pfet L=0.15U W=0.42U
+ AS=0.1092P AD=0.0651P PS=1.36U PD=0.73U
* device instance $647 r0 *1 54.625,-138.675 pfet
M$647 \$45 \$43 \$44 A|A_N|B|D|DOUT0|DOUT7|PH_B6|PH_B9|Q|S|VPB|VPWR pfet
+ L=0.15U W=0.42U AS=0.0651P AD=0.07245P PS=0.73U PD=0.765U
* device instance $648 r0 *1 55.12,-138.675 pfet
M$648 \$46 \$42 \$45 A|A_N|B|D|DOUT0|DOUT7|PH_B6|PH_B9|Q|S|VPB|VPWR pfet
+ L=0.15U W=0.42U AS=0.07245P AD=0.1155P PS=0.765U PD=0.97U
* device instance $649 r0 *1 55.82,-138.675 pfet
M$649 A|A_N|B|D|DOUT0|DOUT7|PH_B6|PH_B9|Q|S|VPB|VPWR \$47 \$46
+ A|A_N|B|D|DOUT0|DOUT7|PH_B6|PH_B9|Q|S|VPB|VPWR pfet L=0.15U W=0.42U
+ AS=0.1155P AD=0.07035P PS=0.97U PD=0.755U
* device instance $650 r0 *1 56.305,-138.675 pfet
M$650 \$46 RESET_B|RST_B|SAMPLE A|A_N|B|D|DOUT0|DOUT7|PH_B6|PH_B9|Q|S|VPB|VPWR
+ A|A_N|B|D|DOUT0|DOUT7|PH_B6|PH_B9|Q|S|VPB|VPWR pfet L=0.15U W=0.42U
+ AS=0.07035P AD=0.1092P PS=0.755U PD=1.36U
* device instance $651 r0 *1 57.785,-138.675 pfet
M$651 \$48 \$42 \$47 A|A_N|B|D|DOUT0|DOUT7|PH_B6|PH_B9|Q|S|VPB|VPWR pfet
+ L=0.15U W=0.42U AS=0.12915P AD=0.0588P PS=1.185U PD=0.7U
* device instance $652 r0 *1 58.215,-138.675 pfet
M$652 \$54 \$43 \$48 A|A_N|B|D|DOUT0|DOUT7|PH_B6|PH_B9|Q|S|VPB|VPWR pfet
+ L=0.15U W=0.42U AS=0.0588P AD=0.0567P PS=0.7U PD=0.69U
* device instance $653 r0 *1 58.635,-138.675 pfet
M$653 A|A_N|B|D|DOUT0|DOUT7|PH_B6|PH_B9|Q|S|VPB|VPWR \$49 \$54
+ A|A_N|B|D|DOUT0|DOUT7|PH_B6|PH_B9|Q|S|VPB|VPWR pfet L=0.15U W=0.42U
+ AS=0.0567P AD=0.0819P PS=0.69U PD=0.81U
* device instance $654 r0 *1 59.175,-138.675 pfet
M$654 \$49 RESET_B|RST_B|SAMPLE A|A_N|B|D|DOUT0|DOUT7|PH_B6|PH_B9|Q|S|VPB|VPWR
+ A|A_N|B|D|DOUT0|DOUT7|PH_B6|PH_B9|Q|S|VPB|VPWR pfet L=0.15U W=0.42U
+ AS=0.0819P AD=0.0567P PS=0.81U PD=0.69U
* device instance $655 r0 *1 59.595,-138.675 pfet
M$655 A|A_N|B|D|DOUT0|DOUT7|PH_B6|PH_B9|Q|S|VPB|VPWR \$48 \$49
+ A|A_N|B|D|DOUT0|DOUT7|PH_B6|PH_B9|Q|S|VPB|VPWR pfet L=0.15U W=0.42U
+ AS=0.0567P AD=0.1134P PS=0.69U PD=1.38U
* device instance $656 r0 *1 57.29,-138.465 pfet
M$656 \$47 \$45 A|A_N|B|D|DOUT0|DOUT7|PH_B6|PH_B9|Q|S|VPB|VPWR
+ A|A_N|B|D|DOUT0|DOUT7|PH_B6|PH_B9|Q|S|VPB|VPWR pfet L=0.15U W=0.84U
+ AS=0.2184P AD=0.12915P PS=2.2U PD=1.185U
* device instance $657 r0 *1 60.67,-138.385 pfet
M$657 A0|DOUT6|Q \$49 A|A_N|B|D|DOUT0|DOUT7|PH_B6|PH_B9|Q|S|VPB|VPWR
+ A|A_N|B|D|DOUT0|DOUT7|PH_B6|PH_B9|Q|S|VPB|VPWR pfet L=0.15U W=1U AS=0.3012P
+ AD=0.26P PS=2.66U PD=2.52U
* device instance $658 r0 *1 23.89,-134.265 pfet
M$658 A|A_N|B|D|DOUT0|DOUT7|PH_B6|PH_B9|Q|S|VPB|VPWR A|CLK|X \$63
+ A|A_N|B|D|DOUT0|DOUT7|PH_B6|PH_B9|Q|S|VPB|VPWR pfet L=0.15U W=0.64U
+ AS=0.1664P AD=0.0864P PS=1.8U PD=0.91U
* device instance $659 r0 *1 24.31,-134.265 pfet
M$659 \$64 \$63 A|A_N|B|D|DOUT0|DOUT7|PH_B6|PH_B9|Q|S|VPB|VPWR
+ A|A_N|B|D|DOUT0|DOUT7|PH_B6|PH_B9|Q|S|VPB|VPWR pfet L=0.15U W=0.64U
+ AS=0.0864P AD=0.1664P PS=0.91U PD=1.8U
* device instance $660 r0 *1 28.77,-134.335 pfet
M$660 \$68 \$67 A|A_N|B|D|DOUT0|DOUT7|PH_B6|PH_B9|Q|S|VPB|VPWR
+ A|A_N|B|D|DOUT0|DOUT7|PH_B6|PH_B9|Q|S|VPB|VPWR pfet L=0.15U W=0.84U
+ AS=0.2184P AD=0.12915P PS=2.2U PD=1.185U
* device instance $661 r0 *1 29.265,-134.125 pfet
M$661 \$69 \$63 \$68 A|A_N|B|D|DOUT0|DOUT7|PH_B6|PH_B9|Q|S|VPB|VPWR pfet
+ L=0.15U W=0.42U AS=0.12915P AD=0.0588P PS=1.185U PD=0.7U
* device instance $662 r0 *1 29.695,-134.125 pfet
M$662 \$105 \$64 \$69 A|A_N|B|D|DOUT0|DOUT7|PH_B6|PH_B9|Q|S|VPB|VPWR pfet
+ L=0.15U W=0.42U AS=0.0588P AD=0.0567P PS=0.7U PD=0.69U
* device instance $663 r0 *1 30.115,-134.125 pfet
M$663 A|A_N|B|D|DOUT0|DOUT7|PH_B6|PH_B9|Q|S|VPB|VPWR \$70 \$105
+ A|A_N|B|D|DOUT0|DOUT7|PH_B6|PH_B9|Q|S|VPB|VPWR pfet L=0.15U W=0.42U
+ AS=0.0567P AD=0.0819P PS=0.69U PD=0.81U
* device instance $664 r0 *1 30.655,-134.125 pfet
M$664 \$70 RESET_B|RST_B|SAMPLE A|A_N|B|D|DOUT0|DOUT7|PH_B6|PH_B9|Q|S|VPB|VPWR
+ A|A_N|B|D|DOUT0|DOUT7|PH_B6|PH_B9|Q|S|VPB|VPWR pfet L=0.15U W=0.42U
+ AS=0.0819P AD=0.0567P PS=0.81U PD=0.69U
* device instance $665 r0 *1 31.075,-134.125 pfet
M$665 A|A_N|B|D|DOUT0|DOUT7|PH_B6|PH_B9|Q|S|VPB|VPWR \$69 \$70
+ A|A_N|B|D|DOUT0|DOUT7|PH_B6|PH_B9|Q|S|VPB|VPWR pfet L=0.15U W=0.42U
+ AS=0.0567P AD=0.1134P PS=0.69U PD=1.38U
* device instance $666 r0 *1 30.075,-138.095 pfet
M$666 \$51 B|D|PH_B4|Q|S \$25 A|A_N|B|D|DOUT0|DOUT7|PH_B6|PH_B9|Q|S|VPB|VPWR
+ pfet L=0.15U W=0.42U AS=0.1092P AD=0.0441P PS=1.36U PD=0.63U
* device instance $667 r0 *1 30.435,-138.095 pfet
M$667 \$51 A|X$2 A|A_N|B|D|DOUT0|DOUT7|PH_B6|PH_B9|Q|S|VPB|VPWR
+ A|A_N|B|D|DOUT0|DOUT7|PH_B6|PH_B9|Q|S|VPB|VPWR pfet L=0.15U W=0.42U
+ AS=0.14575P AD=0.0441P PS=1.335U PD=0.63U
* device instance $668 r0 *1 30.92,-138.385 pfet
M$668 A|X$3 \$25 A|A_N|B|D|DOUT0|DOUT7|PH_B6|PH_B9|Q|S|VPB|VPWR
+ A|A_N|B|D|DOUT0|DOUT7|PH_B6|PH_B9|Q|S|VPB|VPWR pfet L=0.15U W=1U AS=0.14575P
+ AD=0.34P PS=1.335U PD=2.68U
* device instance $669 r0 *1 32.15,-134.415 pfet
M$669 B|C|D|PH_B3|Q|S \$70 A|A_N|B|D|DOUT0|DOUT7|PH_B6|PH_B9|Q|S|VPB|VPWR
+ A|A_N|B|D|DOUT0|DOUT7|PH_B6|PH_B9|Q|S|VPB|VPWR pfet L=0.15U W=1U AS=0.3012P
+ AD=0.26P PS=2.66U PD=2.52U
* device instance $670 r0 *1 34.01,-138.535 pfet
M$670 A|A_N|B|D|DOUT0|DOUT7|PH_B6|PH_B9|Q|S|VPB|VPWR A|CLK|X \$29
+ A|A_N|B|D|DOUT0|DOUT7|PH_B6|PH_B9|Q|S|VPB|VPWR pfet L=0.15U W=0.64U
+ AS=0.1664P AD=0.0864P PS=1.8U PD=0.91U
* device instance $671 r0 *1 34.43,-138.535 pfet
M$671 \$30 \$29 A|A_N|B|D|DOUT0|DOUT7|PH_B6|PH_B9|Q|S|VPB|VPWR
+ A|A_N|B|D|DOUT0|DOUT7|PH_B6|PH_B9|Q|S|VPB|VPWR pfet L=0.15U W=0.64U
+ AS=0.0864P AD=0.1664P PS=0.91U PD=1.8U
* device instance $672 r0 *1 35.11,-134.335 pfet
M$672 \$72 A|X$3 A|A_N|B|D|DOUT0|DOUT7|PH_B6|PH_B9|Q|S|VPB|VPWR
+ A|A_N|B|D|DOUT0|DOUT7|PH_B6|PH_B9|Q|S|VPB|VPWR pfet L=0.15U W=0.42U
+ AS=0.1176P AD=0.0567P PS=1.4U PD=0.69U
* device instance $673 r0 *1 35.53,-134.335 pfet
M$673 \$72 B|X A|A_N|B|D|DOUT0|DOUT7|PH_B6|PH_B9|Q|S|VPB|VPWR
+ A|A_N|B|D|DOUT0|DOUT7|PH_B6|PH_B9|Q|S|VPB|VPWR pfet L=0.15U W=0.42U
+ AS=0.16655P AD=0.0567P PS=1.39U PD=0.69U
* device instance $674 r0 *1 36.07,-134.415 pfet
M$674 D|X$2 \$72 A|A_N|B|D|DOUT0|DOUT7|PH_B6|PH_B9|Q|S|VPB|VPWR
+ A|A_N|B|D|DOUT0|DOUT7|PH_B6|PH_B9|Q|S|VPB|VPWR pfet L=0.15U W=1U AS=0.16655P
+ AD=0.475P PS=1.39U PD=2.95U
* device instance $675 r0 *1 38.33,-134.335 pfet
M$675 \$73 A|X$7 A|A_N|B|D|DOUT0|DOUT7|PH_B6|PH_B9|Q|S|VPB|VPWR
+ A|A_N|B|D|DOUT0|DOUT7|PH_B6|PH_B9|Q|S|VPB|VPWR pfet L=0.15U W=0.42U
+ AS=0.1176P AD=0.0567P PS=1.4U PD=0.69U
* device instance $676 r0 *1 38.75,-134.335 pfet
M$676 \$73 B|X A|A_N|B|D|DOUT0|DOUT7|PH_B6|PH_B9|Q|S|VPB|VPWR
+ A|A_N|B|D|DOUT0|DOUT7|PH_B6|PH_B9|Q|S|VPB|VPWR pfet L=0.15U W=0.42U
+ AS=0.16655P AD=0.0567P PS=1.39U PD=0.69U
* device instance $677 r0 *1 39.29,-134.415 pfet
M$677 D|X \$73 A|A_N|B|D|DOUT0|DOUT7|PH_B6|PH_B9|Q|S|VPB|VPWR
+ A|A_N|B|D|DOUT0|DOUT7|PH_B6|PH_B9|Q|S|VPB|VPWR pfet L=0.15U W=1U AS=0.16655P
+ AD=0.475P PS=1.39U PD=2.95U
* device instance $678 r0 *1 43.39,-138.465 pfet
M$678 \$39 A|X$4 A|A_N|B|D|DOUT0|DOUT7|PH_B6|PH_B9|Q|S|VPB|VPWR
+ A|A_N|B|D|DOUT0|DOUT7|PH_B6|PH_B9|Q|S|VPB|VPWR pfet L=0.15U W=0.42U
+ AS=0.1176P AD=0.0567P PS=1.4U PD=0.69U
* device instance $679 r0 *1 43.81,-138.465 pfet
M$679 \$39 B|X A|A_N|B|D|DOUT0|DOUT7|PH_B6|PH_B9|Q|S|VPB|VPWR
+ A|A_N|B|D|DOUT0|DOUT7|PH_B6|PH_B9|Q|S|VPB|VPWR pfet L=0.15U W=0.42U
+ AS=0.16655P AD=0.0567P PS=1.39U PD=0.69U
* device instance $680 r0 *1 44.35,-138.385 pfet
M$680 D|X$3 \$39 A|A_N|B|D|DOUT0|DOUT7|PH_B6|PH_B9|Q|S|VPB|VPWR
+ A|A_N|B|D|DOUT0|DOUT7|PH_B6|PH_B9|Q|S|VPB|VPWR pfet L=0.15U W=1U AS=0.16655P
+ AD=0.475P PS=1.39U PD=2.95U
* device instance $681 r0 *1 44.13,-134.265 pfet
M$681 A|A_N|B|D|DOUT0|DOUT7|PH_B6|PH_B9|Q|S|VPB|VPWR A|CLK|X \$74
+ A|A_N|B|D|DOUT0|DOUT7|PH_B6|PH_B9|Q|S|VPB|VPWR pfet L=0.15U W=0.64U
+ AS=0.1664P AD=0.0864P PS=1.8U PD=0.91U
* device instance $682 r0 *1 44.55,-134.265 pfet
M$682 \$75 \$74 A|A_N|B|D|DOUT0|DOUT7|PH_B6|PH_B9|Q|S|VPB|VPWR
+ A|A_N|B|D|DOUT0|DOUT7|PH_B6|PH_B9|Q|S|VPB|VPWR pfet L=0.15U W=0.64U
+ AS=0.0864P AD=0.1664P PS=0.91U PD=1.8U
* device instance $683 r0 *1 49.01,-134.335 pfet
M$683 \$78 \$77 A|A_N|B|D|DOUT0|DOUT7|PH_B6|PH_B9|Q|S|VPB|VPWR
+ A|A_N|B|D|DOUT0|DOUT7|PH_B6|PH_B9|Q|S|VPB|VPWR pfet L=0.15U W=0.84U
+ AS=0.2184P AD=0.12915P PS=2.2U PD=1.185U
* device instance $684 r0 *1 49.505,-134.125 pfet
M$684 \$79 \$74 \$78 A|A_N|B|D|DOUT0|DOUT7|PH_B6|PH_B9|Q|S|VPB|VPWR pfet
+ L=0.15U W=0.42U AS=0.12915P AD=0.0588P PS=1.185U PD=0.7U
* device instance $685 r0 *1 49.935,-134.125 pfet
M$685 \$104 \$75 \$79 A|A_N|B|D|DOUT0|DOUT7|PH_B6|PH_B9|Q|S|VPB|VPWR pfet
+ L=0.15U W=0.42U AS=0.0588P AD=0.0567P PS=0.7U PD=0.69U
* device instance $686 r0 *1 50.355,-134.125 pfet
M$686 A|A_N|B|D|DOUT0|DOUT7|PH_B6|PH_B9|Q|S|VPB|VPWR \$80 \$104
+ A|A_N|B|D|DOUT0|DOUT7|PH_B6|PH_B9|Q|S|VPB|VPWR pfet L=0.15U W=0.42U
+ AS=0.0567P AD=0.0819P PS=0.69U PD=0.81U
* device instance $687 r0 *1 50.895,-134.125 pfet
M$687 \$80 RESET_B|RST_B|SAMPLE A|A_N|B|D|DOUT0|DOUT7|PH_B6|PH_B9|Q|S|VPB|VPWR
+ A|A_N|B|D|DOUT0|DOUT7|PH_B6|PH_B9|Q|S|VPB|VPWR pfet L=0.15U W=0.42U
+ AS=0.0819P AD=0.0567P PS=0.81U PD=0.69U
* device instance $688 r0 *1 51.315,-134.125 pfet
M$688 A|A_N|B|D|DOUT0|DOUT7|PH_B6|PH_B9|Q|S|VPB|VPWR \$79 \$80
+ A|A_N|B|D|DOUT0|DOUT7|PH_B6|PH_B9|Q|S|VPB|VPWR pfet L=0.15U W=0.42U
+ AS=0.0567P AD=0.1134P PS=0.69U PD=1.38U
* device instance $689 r0 *1 52.39,-134.415 pfet
M$689 A0|DOUT4|Q \$80 A|A_N|B|D|DOUT0|DOUT7|PH_B6|PH_B9|Q|S|VPB|VPWR
+ A|A_N|B|D|DOUT0|DOUT7|PH_B6|PH_B9|Q|S|VPB|VPWR pfet L=0.15U W=1U AS=0.3012P
+ AD=0.26P PS=2.66U PD=2.52U
* device instance $690 r0 *1 52.41,-138.535 pfet
M$690 A|A_N|B|D|DOUT0|DOUT7|PH_B6|PH_B9|Q|S|VPB|VPWR A|CLK|X \$42
+ A|A_N|B|D|DOUT0|DOUT7|PH_B6|PH_B9|Q|S|VPB|VPWR pfet L=0.15U W=0.64U
+ AS=0.1664P AD=0.0864P PS=1.8U PD=0.91U
* device instance $691 r0 *1 52.83,-138.535 pfet
M$691 \$43 \$42 A|A_N|B|D|DOUT0|DOUT7|PH_B6|PH_B9|Q|S|VPB|VPWR
+ A|A_N|B|D|DOUT0|DOUT7|PH_B6|PH_B9|Q|S|VPB|VPWR pfet L=0.15U W=0.64U
+ AS=0.0864P AD=0.1664P PS=0.91U PD=1.8U
* device instance $692 r0 *1 55.375,-134.705 pfet
M$692 \$103 B|C|D|PH_B7|Q|S \$83 A|A_N|B|D|DOUT0|DOUT7|PH_B6|PH_B9|Q|S|VPB|VPWR
+ pfet L=0.15U W=0.42U AS=0.1092P AD=0.0441P PS=1.36U PD=0.63U
* device instance $693 r0 *1 55.735,-134.705 pfet
M$693 A|A_N|B|D|DOUT0|DOUT7|PH_B6|PH_B9|Q|S|VPB|VPWR A|X$5 \$103
+ A|A_N|B|D|DOUT0|DOUT7|PH_B6|PH_B9|Q|S|VPB|VPWR pfet L=0.15U W=0.42U
+ AS=0.0441P AD=0.14575P PS=0.63U PD=1.335U
* device instance $694 r0 *1 56.22,-134.415 pfet
M$694 A|X$1 \$83 A|A_N|B|D|DOUT0|DOUT7|PH_B6|PH_B9|Q|S|VPB|VPWR
+ A|A_N|B|D|DOUT0|DOUT7|PH_B6|PH_B9|Q|S|VPB|VPWR pfet L=0.15U W=1U AS=0.14575P
+ AD=0.34P PS=1.335U PD=2.68U
* device instance $695 r0 *1 58.475,-134.32 pfet
M$695 \$102 A|A_N|B|D|DOUT0|DOUT7|PH_B6|PH_B9|Q|S|VPB|VPWR
+ A|A_N|B|D|DOUT0|DOUT7|PH_B6|PH_B9|Q|S|VPB|VPWR
+ A|A_N|B|D|DOUT0|DOUT7|PH_B6|PH_B9|Q|S|VPB|VPWR pfet L=0.15U W=0.42U
+ AS=0.15835P AD=0.07665P PS=1.395U PD=0.785U
* device instance $696 r0 *1 58.99,-134.32 pfet
M$696 \$85 A0|DOUT6|Q \$102 A|A_N|B|D|DOUT0|DOUT7|PH_B6|PH_B9|Q|S|VPB|VPWR pfet
+ L=0.15U W=0.42U AS=0.07665P AD=0.1932P PS=0.785U PD=1.34U
* device instance $697 r0 *1 60.06,-134.32 pfet
M$697 \$101 A1|Y \$85 A|A_N|B|D|DOUT0|DOUT7|PH_B6|PH_B9|Q|S|VPB|VPWR pfet
+ L=0.15U W=0.42U AS=0.1932P AD=0.0441P PS=1.34U PD=0.63U
* device instance $698 r0 *1 60.42,-134.32 pfet
M$698 A|A_N|B|D|DOUT0|DOUT7|PH_B6|PH_B9|Q|S|VPB|VPWR \$86 \$101
+ A|A_N|B|D|DOUT0|DOUT7|PH_B6|PH_B9|Q|S|VPB|VPWR pfet L=0.15U W=0.42U
+ AS=0.0441P AD=0.0693P PS=0.63U PD=0.75U
* device instance $699 r0 *1 60.9,-134.32 pfet
M$699 \$86 A|A_N|B|D|DOUT0|DOUT7|PH_B6|PH_B9|Q|S|VPB|VPWR
+ A|A_N|B|D|DOUT0|DOUT7|PH_B6|PH_B9|Q|S|VPB|VPWR
+ A|A_N|B|D|DOUT0|DOUT7|PH_B6|PH_B9|Q|S|VPB|VPWR pfet L=0.15U W=0.42U
+ AS=0.0693P AD=0.1176P PS=0.75U PD=1.4U
* device instance $700 r0 *1 57.93,-134.415 pfet
M$700 A|A_N|B|D|DOUT0|DOUT7|PH_B6|PH_B9|Q|S|VPB|VPWR \$85 A|X$5
+ A|A_N|B|D|DOUT0|DOUT7|PH_B6|PH_B9|Q|S|VPB|VPWR pfet L=0.15U W=1U AS=0.26P
+ AD=0.15835P PS=2.52U PD=1.395U
* device instance $701 r0 *1 25.645,-134.125 pfet
M$701 \$66 B|D|PH_B4|Q|S A|A_N|B|D|DOUT0|DOUT7|PH_B6|PH_B9|Q|S|VPB|VPWR
+ A|A_N|B|D|DOUT0|DOUT7|PH_B6|PH_B9|Q|S|VPB|VPWR pfet L=0.15U W=0.42U
+ AS=0.1092P AD=0.0651P PS=1.36U PD=0.73U
* device instance $702 r0 *1 26.105,-134.125 pfet
M$702 \$67 \$64 \$66 A|A_N|B|D|DOUT0|DOUT7|PH_B6|PH_B9|Q|S|VPB|VPWR pfet
+ L=0.15U W=0.42U AS=0.0651P AD=0.07245P PS=0.73U PD=0.765U
* device instance $703 r0 *1 26.6,-134.125 pfet
M$703 \$99 \$63 \$67 A|A_N|B|D|DOUT0|DOUT7|PH_B6|PH_B9|Q|S|VPB|VPWR pfet
+ L=0.15U W=0.42U AS=0.07245P AD=0.1155P PS=0.765U PD=0.97U
* device instance $704 r0 *1 27.3,-134.125 pfet
M$704 A|A_N|B|D|DOUT0|DOUT7|PH_B6|PH_B9|Q|S|VPB|VPWR \$68 \$99
+ A|A_N|B|D|DOUT0|DOUT7|PH_B6|PH_B9|Q|S|VPB|VPWR pfet L=0.15U W=0.42U
+ AS=0.1155P AD=0.07035P PS=0.97U PD=0.755U
* device instance $705 r0 *1 27.785,-134.125 pfet
M$705 \$99 RESET_B|RST_B|SAMPLE A|A_N|B|D|DOUT0|DOUT7|PH_B6|PH_B9|Q|S|VPB|VPWR
+ A|A_N|B|D|DOUT0|DOUT7|PH_B6|PH_B9|Q|S|VPB|VPWR pfet L=0.15U W=0.42U
+ AS=0.07035P AD=0.1092P PS=0.755U PD=1.36U
* device instance $706 r0 *1 45.885,-134.125 pfet
M$706 \$76 D|X$3 A|A_N|B|D|DOUT0|DOUT7|PH_B6|PH_B9|Q|S|VPB|VPWR
+ A|A_N|B|D|DOUT0|DOUT7|PH_B6|PH_B9|Q|S|VPB|VPWR pfet L=0.15U W=0.42U
+ AS=0.1092P AD=0.0651P PS=1.36U PD=0.73U
* device instance $707 r0 *1 46.345,-134.125 pfet
M$707 \$77 \$75 \$76 A|A_N|B|D|DOUT0|DOUT7|PH_B6|PH_B9|Q|S|VPB|VPWR pfet
+ L=0.15U W=0.42U AS=0.0651P AD=0.07245P PS=0.73U PD=0.765U
* device instance $708 r0 *1 46.84,-134.125 pfet
M$708 \$100 \$74 \$77 A|A_N|B|D|DOUT0|DOUT7|PH_B6|PH_B9|Q|S|VPB|VPWR pfet
+ L=0.15U W=0.42U AS=0.07245P AD=0.1155P PS=0.765U PD=0.97U
* device instance $709 r0 *1 47.54,-134.125 pfet
M$709 A|A_N|B|D|DOUT0|DOUT7|PH_B6|PH_B9|Q|S|VPB|VPWR \$78 \$100
+ A|A_N|B|D|DOUT0|DOUT7|PH_B6|PH_B9|Q|S|VPB|VPWR pfet L=0.15U W=0.42U
+ AS=0.1155P AD=0.07035P PS=0.97U PD=0.755U
* device instance $710 r0 *1 48.025,-134.125 pfet
M$710 \$100 RESET_B|RST_B|SAMPLE A|A_N|B|D|DOUT0|DOUT7|PH_B6|PH_B9|Q|S|VPB|VPWR
+ A|A_N|B|D|DOUT0|DOUT7|PH_B6|PH_B9|Q|S|VPB|VPWR pfet L=0.15U W=0.42U
+ AS=0.07035P AD=0.1092P PS=0.755U PD=1.36U
* device instance $711 r0 *1 28.77,-128.895 pfet
M$711 \$136 \$135 A|A_N|B|D|DOUT0|DOUT7|PH_B6|PH_B9|Q|S|VPB|VPWR
+ A|A_N|B|D|DOUT0|DOUT7|PH_B6|PH_B9|Q|S|VPB|VPWR pfet L=0.15U W=0.84U
+ AS=0.2184P AD=0.12915P PS=2.2U PD=1.185U
* device instance $712 r0 *1 29.265,-128.685 pfet
M$712 \$137 \$132 \$136 A|A_N|B|D|DOUT0|DOUT7|PH_B6|PH_B9|Q|S|VPB|VPWR pfet
+ L=0.15U W=0.42U AS=0.12915P AD=0.0588P PS=1.185U PD=0.7U
* device instance $713 r0 *1 29.695,-128.685 pfet
M$713 \$175 \$133 \$137 A|A_N|B|D|DOUT0|DOUT7|PH_B6|PH_B9|Q|S|VPB|VPWR pfet
+ L=0.15U W=0.42U AS=0.0588P AD=0.0567P PS=0.7U PD=0.69U
* device instance $714 r0 *1 30.115,-128.685 pfet
M$714 A|A_N|B|D|DOUT0|DOUT7|PH_B6|PH_B9|Q|S|VPB|VPWR \$138 \$175
+ A|A_N|B|D|DOUT0|DOUT7|PH_B6|PH_B9|Q|S|VPB|VPWR pfet L=0.15U W=0.42U
+ AS=0.0567P AD=0.0819P PS=0.69U PD=0.81U
* device instance $715 r0 *1 30.655,-128.685 pfet
M$715 \$138 RESET_B|RST_B|SAMPLE A|A_N|B|D|DOUT0|DOUT7|PH_B6|PH_B9|Q|S|VPB|VPWR
+ A|A_N|B|D|DOUT0|DOUT7|PH_B6|PH_B9|Q|S|VPB|VPWR pfet L=0.15U W=0.42U
+ AS=0.0819P AD=0.0567P PS=0.81U PD=0.69U
* device instance $716 r0 *1 31.075,-128.685 pfet
M$716 A|A_N|B|D|DOUT0|DOUT7|PH_B6|PH_B9|Q|S|VPB|VPWR \$137 \$138
+ A|A_N|B|D|DOUT0|DOUT7|PH_B6|PH_B9|Q|S|VPB|VPWR pfet L=0.15U W=0.42U
+ AS=0.0567P AD=0.1134P PS=0.69U PD=1.38U
* device instance $717 r0 *1 30.875,-133.04 pfet
M$717 \$122 B|C|D|PH_B3|Q|S A|A_N|B|D|DOUT0|DOUT7|PH_B6|PH_B9|Q|S|VPB|VPWR
+ A|A_N|B|D|DOUT0|DOUT7|PH_B6|PH_B9|Q|S|VPB|VPWR pfet L=0.15U W=0.42U
+ AS=0.15835P AD=0.07665P PS=1.395U PD=0.785U
* device instance $718 r0 *1 31.39,-133.04 pfet
M$718 \$106 A0|DOUT3|Q \$122 A|A_N|B|D|DOUT0|DOUT7|PH_B6|PH_B9|Q|S|VPB|VPWR
+ pfet L=0.15U W=0.42U AS=0.07665P AD=0.1932P PS=0.785U PD=1.34U
* device instance $719 r0 *1 32.46,-133.04 pfet
M$719 \$125 A1|Y \$106 A|A_N|B|D|DOUT0|DOUT7|PH_B6|PH_B9|Q|S|VPB|VPWR pfet
+ L=0.15U W=0.42U AS=0.1932P AD=0.0441P PS=1.34U PD=0.63U
* device instance $720 r0 *1 32.82,-133.04 pfet
M$720 A|A_N|B|D|DOUT0|DOUT7|PH_B6|PH_B9|Q|S|VPB|VPWR \$109 \$125
+ A|A_N|B|D|DOUT0|DOUT7|PH_B6|PH_B9|Q|S|VPB|VPWR pfet L=0.15U W=0.42U
+ AS=0.0441P AD=0.0693P PS=0.63U PD=0.75U
* device instance $721 r0 *1 33.3,-133.04 pfet
M$721 \$109 B|C|D|PH_B3|Q|S A|A_N|B|D|DOUT0|DOUT7|PH_B6|PH_B9|Q|S|VPB|VPWR
+ A|A_N|B|D|DOUT0|DOUT7|PH_B6|PH_B9|Q|S|VPB|VPWR pfet L=0.15U W=0.42U
+ AS=0.0693P AD=0.1176P PS=0.75U PD=1.4U
* device instance $722 r0 *1 30.33,-132.945 pfet
M$722 A|A_N|B|D|DOUT0|DOUT7|PH_B6|PH_B9|Q|S|VPB|VPWR \$106 A|X$2
+ A|A_N|B|D|DOUT0|DOUT7|PH_B6|PH_B9|Q|S|VPB|VPWR pfet L=0.15U W=1U AS=0.26P
+ AD=0.15835P PS=2.52U PD=1.395U
* device instance $723 r0 *1 32.15,-128.975 pfet
M$723 B|D|PH_B2|Q|S \$138 A|A_N|B|D|DOUT0|DOUT7|PH_B6|PH_B9|Q|S|VPB|VPWR
+ A|A_N|B|D|DOUT0|DOUT7|PH_B6|PH_B9|Q|S|VPB|VPWR pfet L=0.15U W=1U AS=0.3012P
+ AD=0.26P PS=2.66U PD=2.52U
* device instance $724 r0 *1 36.055,-132.655 pfet
M$724 \$126 A|A_N|B|D|DOUT0|DOUT7|PH_B6|PH_B9|Q|S|VPB|VPWR \$110
+ A|A_N|B|D|DOUT0|DOUT7|PH_B6|PH_B9|Q|S|VPB|VPWR pfet L=0.15U W=0.42U
+ AS=0.1092P AD=0.0441P PS=1.36U PD=0.63U
* device instance $725 r0 *1 36.415,-132.655 pfet
M$725 \$126 A|X$6 A|A_N|B|D|DOUT0|DOUT7|PH_B6|PH_B9|Q|S|VPB|VPWR
+ A|A_N|B|D|DOUT0|DOUT7|PH_B6|PH_B9|Q|S|VPB|VPWR pfet L=0.15U W=0.42U
+ AS=0.14575P AD=0.0441P PS=1.335U PD=0.63U
* device instance $726 r0 *1 36.9,-132.945 pfet
M$726 A|X$7 \$110 A|A_N|B|D|DOUT0|DOUT7|PH_B6|PH_B9|Q|S|VPB|VPWR
+ A|A_N|B|D|DOUT0|DOUT7|PH_B6|PH_B9|Q|S|VPB|VPWR pfet L=0.15U W=1U AS=0.14575P
+ AD=0.34P PS=1.335U PD=2.68U
* device instance $727 r0 *1 39.555,-132.945 pfet
M$727 A|A_N|B|D|DOUT0|DOUT7|PH_B6|PH_B9|Q|S|VPB|VPWR A|CLK|X Y
+ A|A_N|B|D|DOUT0|DOUT7|PH_B6|PH_B9|Q|S|VPB|VPWR pfet L=0.15U W=1U AS=0.265P
+ AD=0.14P PS=2.53U PD=1.28U
* device instance $728 r0 *1 39.985,-132.945 pfet
M$728 Y A|CLK|X A|A_N|B|D|DOUT0|DOUT7|PH_B6|PH_B9|Q|S|VPB|VPWR
+ A|A_N|B|D|DOUT0|DOUT7|PH_B6|PH_B9|Q|S|VPB|VPWR pfet L=0.15U W=1U AS=0.14P
+ AD=0.14P PS=1.28U PD=1.28U
* device instance $729 r0 *1 40.415,-132.945 pfet
M$729 A|A_N|B|D|DOUT0|DOUT7|PH_B6|PH_B9|Q|S|VPB|VPWR A|CLK|X Y
+ A|A_N|B|D|DOUT0|DOUT7|PH_B6|PH_B9|Q|S|VPB|VPWR pfet L=0.15U W=1U AS=0.14P
+ AD=0.265P PS=1.28U PD=2.53U
* device instance $730 r0 *1 40.45,-128.975 pfet
M$730 A|A_N|B|D|DOUT0|DOUT7|PH_B6|PH_B9|Q|S|VPB|VPWR A|CLK \$141
+ A|A_N|B|D|DOUT0|DOUT7|PH_B6|PH_B9|Q|S|VPB|VPWR pfet L=0.15U W=1U AS=0.26P
+ AD=0.135P PS=2.52U PD=1.27U
* device instance $731 r0 *1 40.87,-128.975 pfet
M$731 A|X \$141 A|A_N|B|D|DOUT0|DOUT7|PH_B6|PH_B9|Q|S|VPB|VPWR
+ A|A_N|B|D|DOUT0|DOUT7|PH_B6|PH_B9|Q|S|VPB|VPWR pfet L=0.15U W=1U AS=0.135P
+ AD=0.135P PS=1.27U PD=1.27U
* device instance $732 r0 *1 41.29,-128.975 pfet
M$732 A|A_N|B|D|DOUT0|DOUT7|PH_B6|PH_B9|Q|S|VPB|VPWR \$141 A|X
+ A|A_N|B|D|DOUT0|DOUT7|PH_B6|PH_B9|Q|S|VPB|VPWR pfet L=0.15U W=1U AS=0.135P
+ AD=0.135P PS=1.27U PD=1.27U
* device instance $733 r0 *1 41.71,-128.975 pfet
M$733 A|X \$141 A|A_N|B|D|DOUT0|DOUT7|PH_B6|PH_B9|Q|S|VPB|VPWR
+ A|A_N|B|D|DOUT0|DOUT7|PH_B6|PH_B9|Q|S|VPB|VPWR pfet L=0.15U W=1U AS=0.135P
+ AD=0.135P PS=1.27U PD=1.27U
* device instance $734 r0 *1 42.13,-128.975 pfet
M$734 A|A_N|B|D|DOUT0|DOUT7|PH_B6|PH_B9|Q|S|VPB|VPWR \$141 A|X
+ A|A_N|B|D|DOUT0|DOUT7|PH_B6|PH_B9|Q|S|VPB|VPWR pfet L=0.15U W=1U AS=0.135P
+ AD=0.26P PS=1.27U PD=2.52U
* device instance $735 r0 *1 44.675,-128.88 pfet
M$735 \$172 B|D|PH_B4|Q|S A|A_N|B|D|DOUT0|DOUT7|PH_B6|PH_B9|Q|S|VPB|VPWR
+ A|A_N|B|D|DOUT0|DOUT7|PH_B6|PH_B9|Q|S|VPB|VPWR pfet L=0.15U W=0.42U
+ AS=0.15835P AD=0.07665P PS=1.395U PD=0.785U
* device instance $736 r0 *1 45.19,-128.88 pfet
M$736 \$142 A0|DOUT4|Q \$172 A|A_N|B|D|DOUT0|DOUT7|PH_B6|PH_B9|Q|S|VPB|VPWR
+ pfet L=0.15U W=0.42U AS=0.07665P AD=0.1932P PS=0.785U PD=1.34U
* device instance $737 r0 *1 46.26,-128.88 pfet
M$737 \$173 A1|Y \$142 A|A_N|B|D|DOUT0|DOUT7|PH_B6|PH_B9|Q|S|VPB|VPWR pfet
+ L=0.15U W=0.42U AS=0.1932P AD=0.0441P PS=1.34U PD=0.63U
* device instance $738 r0 *1 46.62,-128.88 pfet
M$738 A|A_N|B|D|DOUT0|DOUT7|PH_B6|PH_B9|Q|S|VPB|VPWR \$143 \$173
+ A|A_N|B|D|DOUT0|DOUT7|PH_B6|PH_B9|Q|S|VPB|VPWR pfet L=0.15U W=0.42U
+ AS=0.0441P AD=0.0693P PS=0.63U PD=0.75U
* device instance $739 r0 *1 47.1,-128.88 pfet
M$739 \$143 B|D|PH_B4|Q|S A|A_N|B|D|DOUT0|DOUT7|PH_B6|PH_B9|Q|S|VPB|VPWR
+ A|A_N|B|D|DOUT0|DOUT7|PH_B6|PH_B9|Q|S|VPB|VPWR pfet L=0.15U W=0.42U
+ AS=0.0693P AD=0.1176P PS=0.75U PD=1.4U
* device instance $740 r0 *1 44.13,-128.975 pfet
M$740 A|A_N|B|D|DOUT0|DOUT7|PH_B6|PH_B9|Q|S|VPB|VPWR \$142 A|X$10
+ A|A_N|B|D|DOUT0|DOUT7|PH_B6|PH_B9|Q|S|VPB|VPWR pfet L=0.15U W=1U AS=0.26P
+ AD=0.15835P PS=2.52U PD=1.395U
* device instance $741 r0 *1 49.395,-129.265 pfet
M$741 \$171 B|C|D|PH_B3|Q|S \$144
+ A|A_N|B|D|DOUT0|DOUT7|PH_B6|PH_B9|Q|S|VPB|VPWR pfet L=0.15U W=0.42U
+ AS=0.1092P AD=0.0441P PS=1.36U PD=0.63U
* device instance $742 r0 *1 49.755,-129.265 pfet
M$742 A|A_N|B|D|DOUT0|DOUT7|PH_B6|PH_B9|Q|S|VPB|VPWR A|X$8 \$171
+ A|A_N|B|D|DOUT0|DOUT7|PH_B6|PH_B9|Q|S|VPB|VPWR pfet L=0.15U W=0.42U
+ AS=0.0441P AD=0.14575P PS=0.63U PD=1.335U
* device instance $743 r0 *1 50.24,-128.975 pfet
M$743 A|X$9 \$144 A|A_N|B|D|DOUT0|DOUT7|PH_B6|PH_B9|Q|S|VPB|VPWR
+ A|A_N|B|D|DOUT0|DOUT7|PH_B6|PH_B9|Q|S|VPB|VPWR pfet L=0.15U W=1U AS=0.14575P
+ AD=0.34P PS=1.335U PD=2.68U
* device instance $744 r0 *1 56.55,-133.095 pfet
M$744 A|A_N|B|D|DOUT0|DOUT7|PH_B6|PH_B9|Q|S|VPB|VPWR A|CLK|X \$114
+ A|A_N|B|D|DOUT0|DOUT7|PH_B6|PH_B9|Q|S|VPB|VPWR pfet L=0.15U W=0.64U
+ AS=0.1664P AD=0.0864P PS=1.8U PD=0.91U
* device instance $745 r0 *1 56.97,-133.095 pfet
M$745 \$115 \$114 A|A_N|B|D|DOUT0|DOUT7|PH_B6|PH_B9|Q|S|VPB|VPWR
+ A|A_N|B|D|DOUT0|DOUT7|PH_B6|PH_B9|Q|S|VPB|VPWR pfet L=0.15U W=0.64U
+ AS=0.0864P AD=0.1664P PS=0.91U PD=1.8U
* device instance $746 r0 *1 58.305,-133.235 pfet
M$746 \$116 B|C|D|PH_B7|Q|S A|A_N|B|D|DOUT0|DOUT7|PH_B6|PH_B9|Q|S|VPB|VPWR
+ A|A_N|B|D|DOUT0|DOUT7|PH_B6|PH_B9|Q|S|VPB|VPWR pfet L=0.15U W=0.42U
+ AS=0.1092P AD=0.0651P PS=1.36U PD=0.73U
* device instance $747 r0 *1 58.765,-133.235 pfet
M$747 \$117 \$115 \$116 A|A_N|B|D|DOUT0|DOUT7|PH_B6|PH_B9|Q|S|VPB|VPWR pfet
+ L=0.15U W=0.42U AS=0.0651P AD=0.07245P PS=0.73U PD=0.765U
* device instance $748 r0 *1 59.26,-133.235 pfet
M$748 \$118 \$114 \$117 A|A_N|B|D|DOUT0|DOUT7|PH_B6|PH_B9|Q|S|VPB|VPWR pfet
+ L=0.15U W=0.42U AS=0.07245P AD=0.1155P PS=0.765U PD=0.97U
* device instance $749 r0 *1 59.96,-133.235 pfet
M$749 A|A_N|B|D|DOUT0|DOUT7|PH_B6|PH_B9|Q|S|VPB|VPWR \$119 \$118
+ A|A_N|B|D|DOUT0|DOUT7|PH_B6|PH_B9|Q|S|VPB|VPWR pfet L=0.15U W=0.42U
+ AS=0.1155P AD=0.07035P PS=0.97U PD=0.755U
* device instance $750 r0 *1 60.445,-133.235 pfet
M$750 \$118 RESET_B|RST_B|SAMPLE A|A_N|B|D|DOUT0|DOUT7|PH_B6|PH_B9|Q|S|VPB|VPWR
+ A|A_N|B|D|DOUT0|DOUT7|PH_B6|PH_B9|Q|S|VPB|VPWR pfet L=0.15U W=0.42U
+ AS=0.07035P AD=0.1092P PS=0.755U PD=1.36U
* device instance $751 r0 *1 59.13,-128.895 pfet
M$751 \$153 \$152 A|A_N|B|D|DOUT0|DOUT7|PH_B6|PH_B9|Q|S|VPB|VPWR
+ A|A_N|B|D|DOUT0|DOUT7|PH_B6|PH_B9|Q|S|VPB|VPWR pfet L=0.15U W=0.84U
+ AS=0.2184P AD=0.12915P PS=2.2U PD=1.185U
* device instance $752 r0 *1 59.625,-128.685 pfet
M$752 \$154 \$149 \$153 A|A_N|B|D|DOUT0|DOUT7|PH_B6|PH_B9|Q|S|VPB|VPWR pfet
+ L=0.15U W=0.42U AS=0.12915P AD=0.0588P PS=1.185U PD=0.7U
* device instance $753 r0 *1 60.055,-128.685 pfet
M$753 \$174 \$150 \$154 A|A_N|B|D|DOUT0|DOUT7|PH_B6|PH_B9|Q|S|VPB|VPWR pfet
+ L=0.15U W=0.42U AS=0.0588P AD=0.0567P PS=0.7U PD=0.69U
* device instance $754 r0 *1 60.475,-128.685 pfet
M$754 A|A_N|B|D|DOUT0|DOUT7|PH_B6|PH_B9|Q|S|VPB|VPWR \$155 \$174
+ A|A_N|B|D|DOUT0|DOUT7|PH_B6|PH_B9|Q|S|VPB|VPWR pfet L=0.15U W=0.42U
+ AS=0.0567P AD=0.0819P PS=0.69U PD=0.81U
* device instance $755 r0 *1 61.015,-128.685 pfet
M$755 \$155 RESET_B|RST_B|SAMPLE A|A_N|B|D|DOUT0|DOUT7|PH_B6|PH_B9|Q|S|VPB|VPWR
+ A|A_N|B|D|DOUT0|DOUT7|PH_B6|PH_B9|Q|S|VPB|VPWR pfet L=0.15U W=0.42U
+ AS=0.0819P AD=0.0567P PS=0.81U PD=0.69U
* device instance $756 r0 *1 61.435,-128.685 pfet
M$756 A|A_N|B|D|DOUT0|DOUT7|PH_B6|PH_B9|Q|S|VPB|VPWR \$154 \$155
+ A|A_N|B|D|DOUT0|DOUT7|PH_B6|PH_B9|Q|S|VPB|VPWR pfet L=0.15U W=0.42U
+ AS=0.0567P AD=0.1134P PS=0.69U PD=1.38U
* device instance $757 r0 *1 61.925,-133.235 pfet
M$757 \$120 \$114 \$119 A|A_N|B|D|DOUT0|DOUT7|PH_B6|PH_B9|Q|S|VPB|VPWR pfet
+ L=0.15U W=0.42U AS=0.12915P AD=0.0588P PS=1.185U PD=0.7U
* device instance $758 r0 *1 62.355,-133.235 pfet
M$758 \$129 \$115 \$120 A|A_N|B|D|DOUT0|DOUT7|PH_B6|PH_B9|Q|S|VPB|VPWR pfet
+ L=0.15U W=0.42U AS=0.0588P AD=0.0567P PS=0.7U PD=0.69U
* device instance $759 r0 *1 62.775,-133.235 pfet
M$759 A|A_N|B|D|DOUT0|DOUT7|PH_B6|PH_B9|Q|S|VPB|VPWR \$121 \$129
+ A|A_N|B|D|DOUT0|DOUT7|PH_B6|PH_B9|Q|S|VPB|VPWR pfet L=0.15U W=0.42U
+ AS=0.0567P AD=0.0819P PS=0.69U PD=0.81U
* device instance $760 r0 *1 63.315,-133.235 pfet
M$760 \$121 RESET_B|RST_B|SAMPLE A|A_N|B|D|DOUT0|DOUT7|PH_B6|PH_B9|Q|S|VPB|VPWR
+ A|A_N|B|D|DOUT0|DOUT7|PH_B6|PH_B9|Q|S|VPB|VPWR pfet L=0.15U W=0.42U
+ AS=0.0819P AD=0.0567P PS=0.81U PD=0.69U
* device instance $761 r0 *1 63.735,-133.235 pfet
M$761 A|A_N|B|D|DOUT0|DOUT7|PH_B6|PH_B9|Q|S|VPB|VPWR \$120 \$121
+ A|A_N|B|D|DOUT0|DOUT7|PH_B6|PH_B9|Q|S|VPB|VPWR pfet L=0.15U W=0.42U
+ AS=0.0567P AD=0.1134P PS=0.69U PD=1.38U
* device instance $762 r0 *1 61.43,-133.025 pfet
M$762 \$119 \$117 A|A_N|B|D|DOUT0|DOUT7|PH_B6|PH_B9|Q|S|VPB|VPWR
+ A|A_N|B|D|DOUT0|DOUT7|PH_B6|PH_B9|Q|S|VPB|VPWR pfet L=0.15U W=0.84U
+ AS=0.2184P AD=0.12915P PS=2.2U PD=1.185U
* device instance $763 r0 *1 62.51,-128.975 pfet
M$763 A0|DOUT2|Q \$155 A|A_N|B|D|DOUT0|DOUT7|PH_B6|PH_B9|Q|S|VPB|VPWR
+ A|A_N|B|D|DOUT0|DOUT7|PH_B6|PH_B9|Q|S|VPB|VPWR pfet L=0.15U W=1U AS=0.3012P
+ AD=0.26P PS=2.66U PD=2.52U
* device instance $764 r0 *1 64.81,-132.945 pfet
M$764 A|A_N|B|D|DOUT0|DOUT7|PH_B6|PH_B9|Q|S|VPB|VPWR \$121
+ A|A_N|B|D|DOUT0|DOUT7|PH_B6|PH_B9|Q|S|VPB|VPWR
+ A|A_N|B|D|DOUT0|DOUT7|PH_B6|PH_B9|Q|S|VPB|VPWR pfet L=0.15U W=1U AS=0.3012P
+ AD=0.26P PS=2.66U PD=2.52U
* device instance $765 r0 *1 23.89,-128.825 pfet
M$765 A|A_N|B|D|DOUT0|DOUT7|PH_B6|PH_B9|Q|S|VPB|VPWR A|CLK|X \$132
+ A|A_N|B|D|DOUT0|DOUT7|PH_B6|PH_B9|Q|S|VPB|VPWR pfet L=0.15U W=0.64U
+ AS=0.1664P AD=0.0864P PS=1.8U PD=0.91U
* device instance $766 r0 *1 24.31,-128.825 pfet
M$766 \$133 \$132 A|A_N|B|D|DOUT0|DOUT7|PH_B6|PH_B9|Q|S|VPB|VPWR
+ A|A_N|B|D|DOUT0|DOUT7|PH_B6|PH_B9|Q|S|VPB|VPWR pfet L=0.15U W=0.64U
+ AS=0.0864P AD=0.1664P PS=0.91U PD=1.8U
* device instance $767 r0 *1 25.645,-128.685 pfet
M$767 \$134 B|C|D|PH_B3|Q|S A|A_N|B|D|DOUT0|DOUT7|PH_B6|PH_B9|Q|S|VPB|VPWR
+ A|A_N|B|D|DOUT0|DOUT7|PH_B6|PH_B9|Q|S|VPB|VPWR pfet L=0.15U W=0.42U
+ AS=0.1092P AD=0.0651P PS=1.36U PD=0.73U
* device instance $768 r0 *1 26.105,-128.685 pfet
M$768 \$135 \$133 \$134 A|A_N|B|D|DOUT0|DOUT7|PH_B6|PH_B9|Q|S|VPB|VPWR pfet
+ L=0.15U W=0.42U AS=0.0651P AD=0.07245P PS=0.73U PD=0.765U
* device instance $769 r0 *1 26.6,-128.685 pfet
M$769 \$168 \$132 \$135 A|A_N|B|D|DOUT0|DOUT7|PH_B6|PH_B9|Q|S|VPB|VPWR pfet
+ L=0.15U W=0.42U AS=0.07245P AD=0.1155P PS=0.765U PD=0.97U
* device instance $770 r0 *1 27.3,-128.685 pfet
M$770 A|A_N|B|D|DOUT0|DOUT7|PH_B6|PH_B9|Q|S|VPB|VPWR \$136 \$168
+ A|A_N|B|D|DOUT0|DOUT7|PH_B6|PH_B9|Q|S|VPB|VPWR pfet L=0.15U W=0.42U
+ AS=0.1155P AD=0.07035P PS=0.97U PD=0.755U
* device instance $771 r0 *1 27.785,-128.685 pfet
M$771 \$168 RESET_B|RST_B|SAMPLE A|A_N|B|D|DOUT0|DOUT7|PH_B6|PH_B9|Q|S|VPB|VPWR
+ A|A_N|B|D|DOUT0|DOUT7|PH_B6|PH_B9|Q|S|VPB|VPWR pfet L=0.15U W=0.42U
+ AS=0.07035P AD=0.1092P PS=0.755U PD=1.36U
* device instance $772 r0 *1 51.67,-128.895 pfet
M$772 \$147 A|X$9 A|A_N|B|D|DOUT0|DOUT7|PH_B6|PH_B9|Q|S|VPB|VPWR
+ A|A_N|B|D|DOUT0|DOUT7|PH_B6|PH_B9|Q|S|VPB|VPWR pfet L=0.15U W=0.42U
+ AS=0.1176P AD=0.0567P PS=1.4U PD=0.69U
* device instance $773 r0 *1 52.09,-128.895 pfet
M$773 \$147 B|X A|A_N|B|D|DOUT0|DOUT7|PH_B6|PH_B9|Q|S|VPB|VPWR
+ A|A_N|B|D|DOUT0|DOUT7|PH_B6|PH_B9|Q|S|VPB|VPWR pfet L=0.15U W=0.42U
+ AS=0.16655P AD=0.0567P PS=1.39U PD=0.69U
* device instance $774 r0 *1 52.63,-128.975 pfet
M$774 D|X$4 \$147 A|A_N|B|D|DOUT0|DOUT7|PH_B6|PH_B9|Q|S|VPB|VPWR
+ A|A_N|B|D|DOUT0|DOUT7|PH_B6|PH_B9|Q|S|VPB|VPWR pfet L=0.15U W=1U AS=0.16655P
+ AD=0.475P PS=1.39U PD=2.95U
* device instance $775 r0 *1 54.25,-128.825 pfet
M$775 A|A_N|B|D|DOUT0|DOUT7|PH_B6|PH_B9|Q|S|VPB|VPWR A|CLK|X \$149
+ A|A_N|B|D|DOUT0|DOUT7|PH_B6|PH_B9|Q|S|VPB|VPWR pfet L=0.15U W=0.64U
+ AS=0.1664P AD=0.0864P PS=1.8U PD=0.91U
* device instance $776 r0 *1 54.67,-128.825 pfet
M$776 \$150 \$149 A|A_N|B|D|DOUT0|DOUT7|PH_B6|PH_B9|Q|S|VPB|VPWR
+ A|A_N|B|D|DOUT0|DOUT7|PH_B6|PH_B9|Q|S|VPB|VPWR pfet L=0.15U W=0.64U
+ AS=0.0864P AD=0.1664P PS=0.91U PD=1.8U
* device instance $777 r0 *1 56.005,-128.685 pfet
M$777 \$151 D|X$4 A|A_N|B|D|DOUT0|DOUT7|PH_B6|PH_B9|Q|S|VPB|VPWR
+ A|A_N|B|D|DOUT0|DOUT7|PH_B6|PH_B9|Q|S|VPB|VPWR pfet L=0.15U W=0.42U
+ AS=0.1092P AD=0.0651P PS=1.36U PD=0.73U
* device instance $778 r0 *1 56.465,-128.685 pfet
M$778 \$152 \$150 \$151 A|A_N|B|D|DOUT0|DOUT7|PH_B6|PH_B9|Q|S|VPB|VPWR pfet
+ L=0.15U W=0.42U AS=0.0651P AD=0.07245P PS=0.73U PD=0.765U
* device instance $779 r0 *1 56.96,-128.685 pfet
M$779 \$170 \$149 \$152 A|A_N|B|D|DOUT0|DOUT7|PH_B6|PH_B9|Q|S|VPB|VPWR pfet
+ L=0.15U W=0.42U AS=0.07245P AD=0.1155P PS=0.765U PD=0.97U
* device instance $780 r0 *1 57.66,-128.685 pfet
M$780 A|A_N|B|D|DOUT0|DOUT7|PH_B6|PH_B9|Q|S|VPB|VPWR \$153 \$170
+ A|A_N|B|D|DOUT0|DOUT7|PH_B6|PH_B9|Q|S|VPB|VPWR pfet L=0.15U W=0.42U
+ AS=0.1155P AD=0.07035P PS=0.97U PD=0.755U
* device instance $781 r0 *1 58.145,-128.685 pfet
M$781 \$170 RESET_B|RST_B|SAMPLE A|A_N|B|D|DOUT0|DOUT7|PH_B6|PH_B9|Q|S|VPB|VPWR
+ A|A_N|B|D|DOUT0|DOUT7|PH_B6|PH_B9|Q|S|VPB|VPWR pfet L=0.15U W=0.42U
+ AS=0.07035P AD=0.1092P PS=0.755U PD=1.36U
* device instance $782 r0 *1 23.89,-123.385 pfet
M$782 A|A_N|B|D|DOUT0|DOUT7|PH_B6|PH_B9|Q|S|VPB|VPWR CLK|X \$193
+ A|A_N|B|D|DOUT0|DOUT7|PH_B6|PH_B9|Q|S|VPB|VPWR pfet L=0.15U W=0.64U
+ AS=0.1664P AD=0.0864P PS=1.8U PD=0.91U
* device instance $783 r0 *1 24.31,-123.385 pfet
M$783 \$194 \$193 A|A_N|B|D|DOUT0|DOUT7|PH_B6|PH_B9|Q|S|VPB|VPWR
+ A|A_N|B|D|DOUT0|DOUT7|PH_B6|PH_B9|Q|S|VPB|VPWR pfet L=0.15U W=0.64U
+ AS=0.0864P AD=0.1664P PS=0.91U PD=1.8U
* device instance $784 r0 *1 25.645,-123.245 pfet
M$784 \$195 B|D|PH_B2|Q|S A|A_N|B|D|DOUT0|DOUT7|PH_B6|PH_B9|Q|S|VPB|VPWR
+ A|A_N|B|D|DOUT0|DOUT7|PH_B6|PH_B9|Q|S|VPB|VPWR pfet L=0.15U W=0.42U
+ AS=0.1092P AD=0.0651P PS=1.36U PD=0.73U
* device instance $785 r0 *1 26.105,-123.245 pfet
M$785 \$196 \$194 \$195 A|A_N|B|D|DOUT0|DOUT7|PH_B6|PH_B9|Q|S|VPB|VPWR pfet
+ L=0.15U W=0.42U AS=0.0651P AD=0.07245P PS=0.73U PD=0.765U
* device instance $786 r0 *1 26.6,-123.245 pfet
M$786 \$237 \$193 \$196 A|A_N|B|D|DOUT0|DOUT7|PH_B6|PH_B9|Q|S|VPB|VPWR pfet
+ L=0.15U W=0.42U AS=0.07245P AD=0.1155P PS=0.765U PD=0.97U
* device instance $787 r0 *1 27.3,-123.245 pfet
M$787 A|A_N|B|D|DOUT0|DOUT7|PH_B6|PH_B9|Q|S|VPB|VPWR \$197 \$237
+ A|A_N|B|D|DOUT0|DOUT7|PH_B6|PH_B9|Q|S|VPB|VPWR pfet L=0.15U W=0.42U
+ AS=0.1155P AD=0.07035P PS=0.97U PD=0.755U
* device instance $788 r0 *1 27.785,-123.245 pfet
M$788 \$237 RESET_B|RST_B|SAMPLE A|A_N|B|D|DOUT0|DOUT7|PH_B6|PH_B9|Q|S|VPB|VPWR
+ A|A_N|B|D|DOUT0|DOUT7|PH_B6|PH_B9|Q|S|VPB|VPWR pfet L=0.15U W=0.42U
+ AS=0.07035P AD=0.1092P PS=0.755U PD=1.36U
* device instance $789 r0 *1 28.77,-123.455 pfet
M$789 \$197 \$196 A|A_N|B|D|DOUT0|DOUT7|PH_B6|PH_B9|Q|S|VPB|VPWR
+ A|A_N|B|D|DOUT0|DOUT7|PH_B6|PH_B9|Q|S|VPB|VPWR pfet L=0.15U W=0.84U
+ AS=0.2184P AD=0.12915P PS=2.2U PD=1.185U
* device instance $790 r0 *1 29.265,-123.245 pfet
M$790 \$198 \$193 \$197 A|A_N|B|D|DOUT0|DOUT7|PH_B6|PH_B9|Q|S|VPB|VPWR pfet
+ L=0.15U W=0.42U AS=0.12915P AD=0.0588P PS=1.185U PD=0.7U
* device instance $791 r0 *1 29.695,-123.245 pfet
M$791 \$241 \$194 \$198 A|A_N|B|D|DOUT0|DOUT7|PH_B6|PH_B9|Q|S|VPB|VPWR pfet
+ L=0.15U W=0.42U AS=0.0588P AD=0.0567P PS=0.7U PD=0.69U
* device instance $792 r0 *1 30.115,-123.245 pfet
M$792 A|A_N|B|D|DOUT0|DOUT7|PH_B6|PH_B9|Q|S|VPB|VPWR \$199 \$241
+ A|A_N|B|D|DOUT0|DOUT7|PH_B6|PH_B9|Q|S|VPB|VPWR pfet L=0.15U W=0.42U
+ AS=0.0567P AD=0.0819P PS=0.69U PD=0.81U
* device instance $793 r0 *1 30.655,-123.245 pfet
M$793 \$199 RESET_B|RST_B|SAMPLE A|A_N|B|D|DOUT0|DOUT7|PH_B6|PH_B9|Q|S|VPB|VPWR
+ A|A_N|B|D|DOUT0|DOUT7|PH_B6|PH_B9|Q|S|VPB|VPWR pfet L=0.15U W=0.42U
+ AS=0.0819P AD=0.0567P PS=0.81U PD=0.69U
* device instance $794 r0 *1 31.075,-123.245 pfet
M$794 A|A_N|B|D|DOUT0|DOUT7|PH_B6|PH_B9|Q|S|VPB|VPWR \$198 \$199
+ A|A_N|B|D|DOUT0|DOUT7|PH_B6|PH_B9|Q|S|VPB|VPWR pfet L=0.15U W=0.42U
+ AS=0.0567P AD=0.1134P PS=0.69U PD=1.38U
* device instance $795 r0 *1 31.25,-127.655 pfet
M$795 A|A_N|B|D|DOUT0|DOUT7|PH_B6|PH_B9|Q|S|VPB|VPWR A|CLK|X \$176
+ A|A_N|B|D|DOUT0|DOUT7|PH_B6|PH_B9|Q|S|VPB|VPWR pfet L=0.15U W=0.64U
+ AS=0.1664P AD=0.0864P PS=1.8U PD=0.91U
* device instance $796 r0 *1 31.67,-127.655 pfet
M$796 \$177 \$176 A|A_N|B|D|DOUT0|DOUT7|PH_B6|PH_B9|Q|S|VPB|VPWR
+ A|A_N|B|D|DOUT0|DOUT7|PH_B6|PH_B9|Q|S|VPB|VPWR pfet L=0.15U W=0.64U
+ AS=0.0864P AD=0.1664P PS=0.91U PD=1.8U
* device instance $797 r0 *1 32.15,-123.535 pfet
M$797 A|B|D|PH_B1|Q|S \$199 A|A_N|B|D|DOUT0|DOUT7|PH_B6|PH_B9|Q|S|VPB|VPWR
+ A|A_N|B|D|DOUT0|DOUT7|PH_B6|PH_B9|Q|S|VPB|VPWR pfet L=0.15U W=1U AS=0.3012P
+ AD=0.26P PS=2.66U PD=2.52U
* device instance $798 r0 *1 33.005,-127.795 pfet
M$798 \$178 A|A_N|B|D|DOUT0|DOUT7|PH_B6|PH_B9|Q|S|VPB|VPWR
+ A|A_N|B|D|DOUT0|DOUT7|PH_B6|PH_B9|Q|S|VPB|VPWR
+ A|A_N|B|D|DOUT0|DOUT7|PH_B6|PH_B9|Q|S|VPB|VPWR pfet L=0.15U W=0.42U
+ AS=0.1092P AD=0.0651P PS=1.36U PD=0.73U
* device instance $799 r0 *1 33.465,-127.795 pfet
M$799 \$179 \$177 \$178 A|A_N|B|D|DOUT0|DOUT7|PH_B6|PH_B9|Q|S|VPB|VPWR pfet
+ L=0.15U W=0.42U AS=0.0651P AD=0.07245P PS=0.73U PD=0.765U
* device instance $800 r0 *1 33.96,-127.795 pfet
M$800 \$180 \$176 \$179 A|A_N|B|D|DOUT0|DOUT7|PH_B6|PH_B9|Q|S|VPB|VPWR pfet
+ L=0.15U W=0.42U AS=0.07245P AD=0.1155P PS=0.765U PD=0.97U
* device instance $801 r0 *1 34.66,-127.795 pfet
M$801 A|A_N|B|D|DOUT0|DOUT7|PH_B6|PH_B9|Q|S|VPB|VPWR \$181 \$180
+ A|A_N|B|D|DOUT0|DOUT7|PH_B6|PH_B9|Q|S|VPB|VPWR pfet L=0.15U W=0.42U
+ AS=0.1155P AD=0.07035P PS=0.97U PD=0.755U
* device instance $802 r0 *1 35.145,-127.795 pfet
M$802 \$180 RESET_B|RST_B|SAMPLE A|A_N|B|D|DOUT0|DOUT7|PH_B6|PH_B9|Q|S|VPB|VPWR
+ A|A_N|B|D|DOUT0|DOUT7|PH_B6|PH_B9|Q|S|VPB|VPWR pfet L=0.15U W=0.42U
+ AS=0.07035P AD=0.1092P PS=0.755U PD=1.36U
* device instance $803 r0 *1 36.625,-127.795 pfet
M$803 \$182 \$176 \$181 A|A_N|B|D|DOUT0|DOUT7|PH_B6|PH_B9|Q|S|VPB|VPWR pfet
+ L=0.15U W=0.42U AS=0.12915P AD=0.0588P PS=1.185U PD=0.7U
* device instance $804 r0 *1 37.055,-127.795 pfet
M$804 \$190 \$177 \$182 A|A_N|B|D|DOUT0|DOUT7|PH_B6|PH_B9|Q|S|VPB|VPWR pfet
+ L=0.15U W=0.42U AS=0.0588P AD=0.0567P PS=0.7U PD=0.69U
* device instance $805 r0 *1 37.475,-127.795 pfet
M$805 A|A_N|B|D|DOUT0|DOUT7|PH_B6|PH_B9|Q|S|VPB|VPWR \$183 \$190
+ A|A_N|B|D|DOUT0|DOUT7|PH_B6|PH_B9|Q|S|VPB|VPWR pfet L=0.15U W=0.42U
+ AS=0.0567P AD=0.0819P PS=0.69U PD=0.81U
* device instance $806 r0 *1 38.015,-127.795 pfet
M$806 \$183 RESET_B|RST_B|SAMPLE A|A_N|B|D|DOUT0|DOUT7|PH_B6|PH_B9|Q|S|VPB|VPWR
+ A|A_N|B|D|DOUT0|DOUT7|PH_B6|PH_B9|Q|S|VPB|VPWR pfet L=0.15U W=0.42U
+ AS=0.0819P AD=0.0567P PS=0.81U PD=0.69U
* device instance $807 r0 *1 38.435,-127.795 pfet
M$807 A|A_N|B|D|DOUT0|DOUT7|PH_B6|PH_B9|Q|S|VPB|VPWR \$182 \$183
+ A|A_N|B|D|DOUT0|DOUT7|PH_B6|PH_B9|Q|S|VPB|VPWR pfet L=0.15U W=0.42U
+ AS=0.0567P AD=0.1134P PS=0.69U PD=1.38U
* device instance $808 r0 *1 36.13,-127.585 pfet
M$808 \$181 \$179 A|A_N|B|D|DOUT0|DOUT7|PH_B6|PH_B9|Q|S|VPB|VPWR
+ A|A_N|B|D|DOUT0|DOUT7|PH_B6|PH_B9|Q|S|VPB|VPWR pfet L=0.15U W=0.84U
+ AS=0.2184P AD=0.12915P PS=2.2U PD=1.185U
* device instance $809 r0 *1 38.61,-123.385 pfet
M$809 A|A_N|B|D|DOUT0|DOUT7|PH_B6|PH_B9|Q|S|VPB|VPWR CLK|X \$202
+ A|A_N|B|D|DOUT0|DOUT7|PH_B6|PH_B9|Q|S|VPB|VPWR pfet L=0.15U W=0.64U
+ AS=0.1664P AD=0.0864P PS=1.8U PD=0.91U
* device instance $810 r0 *1 39.03,-123.385 pfet
M$810 \$203 \$202 A|A_N|B|D|DOUT0|DOUT7|PH_B6|PH_B9|Q|S|VPB|VPWR
+ A|A_N|B|D|DOUT0|DOUT7|PH_B6|PH_B9|Q|S|VPB|VPWR pfet L=0.15U W=0.64U
+ AS=0.0864P AD=0.1664P PS=0.91U PD=1.8U
* device instance $811 r0 *1 39.51,-127.505 pfet
M$811 A|B|D|PH_B5|Q|S \$183 A|A_N|B|D|DOUT0|DOUT7|PH_B6|PH_B9|Q|S|VPB|VPWR
+ A|A_N|B|D|DOUT0|DOUT7|PH_B6|PH_B9|Q|S|VPB|VPWR pfet L=0.15U W=1U AS=0.3012P
+ AD=0.26P PS=2.66U PD=2.52U
* device instance $812 r0 *1 40.365,-123.245 pfet
M$812 \$204 A|B|D|PH_B5|Q|S A|A_N|B|D|DOUT0|DOUT7|PH_B6|PH_B9|Q|S|VPB|VPWR
+ A|A_N|B|D|DOUT0|DOUT7|PH_B6|PH_B9|Q|S|VPB|VPWR pfet L=0.15U W=0.42U
+ AS=0.1092P AD=0.0651P PS=1.36U PD=0.73U
* device instance $813 r0 *1 40.825,-123.245 pfet
M$813 \$205 \$203 \$204 A|A_N|B|D|DOUT0|DOUT7|PH_B6|PH_B9|Q|S|VPB|VPWR pfet
+ L=0.15U W=0.42U AS=0.0651P AD=0.07245P PS=0.73U PD=0.765U
* device instance $814 r0 *1 41.32,-123.245 pfet
M$814 \$238 \$202 \$205 A|A_N|B|D|DOUT0|DOUT7|PH_B6|PH_B9|Q|S|VPB|VPWR pfet
+ L=0.15U W=0.42U AS=0.07245P AD=0.1155P PS=0.765U PD=0.97U
* device instance $815 r0 *1 42.02,-123.245 pfet
M$815 A|A_N|B|D|DOUT0|DOUT7|PH_B6|PH_B9|Q|S|VPB|VPWR \$206 \$238
+ A|A_N|B|D|DOUT0|DOUT7|PH_B6|PH_B9|Q|S|VPB|VPWR pfet L=0.15U W=0.42U
+ AS=0.1155P AD=0.07035P PS=0.97U PD=0.755U
* device instance $816 r0 *1 42.505,-123.245 pfet
M$816 \$238 RESET_B|RST_B|SAMPLE A|A_N|B|D|DOUT0|DOUT7|PH_B6|PH_B9|Q|S|VPB|VPWR
+ A|A_N|B|D|DOUT0|DOUT7|PH_B6|PH_B9|Q|S|VPB|VPWR pfet L=0.15U W=0.42U
+ AS=0.07035P AD=0.1092P PS=0.755U PD=1.36U
* device instance $817 r0 *1 41.115,-127.215 pfet
M$817 \$192 A|B|D|PH_B5|Q|S \$185
+ A|A_N|B|D|DOUT0|DOUT7|PH_B6|PH_B9|Q|S|VPB|VPWR pfet L=0.15U W=0.42U
+ AS=0.1092P AD=0.0441P PS=1.36U PD=0.63U
* device instance $818 r0 *1 41.475,-127.215 pfet
M$818 \$192 A|X$10 A|A_N|B|D|DOUT0|DOUT7|PH_B6|PH_B9|Q|S|VPB|VPWR
+ A|A_N|B|D|DOUT0|DOUT7|PH_B6|PH_B9|Q|S|VPB|VPWR pfet L=0.15U W=0.42U
+ AS=0.14575P AD=0.0441P PS=1.335U PD=0.63U
* device instance $819 r0 *1 41.96,-127.505 pfet
M$819 A|X$4 \$185 A|A_N|B|D|DOUT0|DOUT7|PH_B6|PH_B9|Q|S|VPB|VPWR
+ A|A_N|B|D|DOUT0|DOUT7|PH_B6|PH_B9|Q|S|VPB|VPWR pfet L=0.15U W=1U AS=0.14575P
+ AD=0.34P PS=1.335U PD=2.68U
* device instance $820 r0 *1 43.49,-123.455 pfet
M$820 \$206 \$205 A|A_N|B|D|DOUT0|DOUT7|PH_B6|PH_B9|Q|S|VPB|VPWR
+ A|A_N|B|D|DOUT0|DOUT7|PH_B6|PH_B9|Q|S|VPB|VPWR pfet L=0.15U W=0.84U
+ AS=0.2184P AD=0.12915P PS=2.2U PD=1.185U
* device instance $821 r0 *1 43.985,-123.245 pfet
M$821 \$207 \$202 \$206 A|A_N|B|D|DOUT0|DOUT7|PH_B6|PH_B9|Q|S|VPB|VPWR pfet
+ L=0.15U W=0.42U AS=0.12915P AD=0.0588P PS=1.185U PD=0.7U
* device instance $822 r0 *1 44.415,-123.245 pfet
M$822 \$244 \$203 \$207 A|A_N|B|D|DOUT0|DOUT7|PH_B6|PH_B9|Q|S|VPB|VPWR pfet
+ L=0.15U W=0.42U AS=0.0588P AD=0.0567P PS=0.7U PD=0.69U
* device instance $823 r0 *1 44.835,-123.245 pfet
M$823 A|A_N|B|D|DOUT0|DOUT7|PH_B6|PH_B9|Q|S|VPB|VPWR \$208 \$244
+ A|A_N|B|D|DOUT0|DOUT7|PH_B6|PH_B9|Q|S|VPB|VPWR pfet L=0.15U W=0.42U
+ AS=0.0567P AD=0.0819P PS=0.69U PD=0.81U
* device instance $824 r0 *1 45.375,-123.245 pfet
M$824 \$208 RESET_B|RST_B|SAMPLE A|A_N|B|D|DOUT0|DOUT7|PH_B6|PH_B9|Q|S|VPB|VPWR
+ A|A_N|B|D|DOUT0|DOUT7|PH_B6|PH_B9|Q|S|VPB|VPWR pfet L=0.15U W=0.42U
+ AS=0.0819P AD=0.0567P PS=0.81U PD=0.69U
* device instance $825 r0 *1 45.795,-123.245 pfet
M$825 A|A_N|B|D|DOUT0|DOUT7|PH_B6|PH_B9|Q|S|VPB|VPWR \$207 \$208
+ A|A_N|B|D|DOUT0|DOUT7|PH_B6|PH_B9|Q|S|VPB|VPWR pfet L=0.15U W=0.42U
+ AS=0.0567P AD=0.1134P PS=0.69U PD=1.38U
* device instance $826 r0 *1 46.87,-123.535 pfet
M$826 B|D|PH_B4|Q|S \$208 A|A_N|B|D|DOUT0|DOUT7|PH_B6|PH_B9|Q|S|VPB|VPWR
+ A|A_N|B|D|DOUT0|DOUT7|PH_B6|PH_B9|Q|S|VPB|VPWR pfet L=0.15U W=1U AS=0.3012P
+ AD=0.26P PS=2.66U PD=2.52U
* device instance $827 r0 *1 48.815,-123.44 pfet
M$827 \$243 B|D|PH_B2|Q|S A|A_N|B|D|DOUT0|DOUT7|PH_B6|PH_B9|Q|S|VPB|VPWR
+ A|A_N|B|D|DOUT0|DOUT7|PH_B6|PH_B9|Q|S|VPB|VPWR pfet L=0.15U W=0.42U
+ AS=0.15835P AD=0.07665P PS=1.395U PD=0.785U
* device instance $828 r0 *1 49.33,-123.44 pfet
M$828 \$209 A0|DOUT2|Q \$243 A|A_N|B|D|DOUT0|DOUT7|PH_B6|PH_B9|Q|S|VPB|VPWR
+ pfet L=0.15U W=0.42U AS=0.07665P AD=0.1932P PS=0.785U PD=1.34U
* device instance $829 r0 *1 50.4,-123.44 pfet
M$829 \$242 A1|Y \$209 A|A_N|B|D|DOUT0|DOUT7|PH_B6|PH_B9|Q|S|VPB|VPWR pfet
+ L=0.15U W=0.42U AS=0.1932P AD=0.0441P PS=1.34U PD=0.63U
* device instance $830 r0 *1 50.76,-123.44 pfet
M$830 A|A_N|B|D|DOUT0|DOUT7|PH_B6|PH_B9|Q|S|VPB|VPWR \$210 \$242
+ A|A_N|B|D|DOUT0|DOUT7|PH_B6|PH_B9|Q|S|VPB|VPWR pfet L=0.15U W=0.42U
+ AS=0.0441P AD=0.0693P PS=0.63U PD=0.75U
* device instance $831 r0 *1 51.24,-123.44 pfet
M$831 \$210 B|D|PH_B2|Q|S A|A_N|B|D|DOUT0|DOUT7|PH_B6|PH_B9|Q|S|VPB|VPWR
+ A|A_N|B|D|DOUT0|DOUT7|PH_B6|PH_B9|Q|S|VPB|VPWR pfet L=0.15U W=0.42U
+ AS=0.0693P AD=0.1176P PS=0.75U PD=1.4U
* device instance $832 r0 *1 48.27,-123.535 pfet
M$832 A|A_N|B|D|DOUT0|DOUT7|PH_B6|PH_B9|Q|S|VPB|VPWR \$209 A|X$8
+ A|A_N|B|D|DOUT0|DOUT7|PH_B6|PH_B9|Q|S|VPB|VPWR pfet L=0.15U W=1U AS=0.26P
+ AD=0.15835P PS=2.52U PD=1.395U
* device instance $833 r0 *1 52.59,-123.455 pfet
M$833 \$212 A|X$11 A|A_N|B|D|DOUT0|DOUT7|PH_B6|PH_B9|Q|S|VPB|VPWR
+ A|A_N|B|D|DOUT0|DOUT7|PH_B6|PH_B9|Q|S|VPB|VPWR pfet L=0.15U W=0.42U
+ AS=0.1176P AD=0.0567P PS=1.4U PD=0.69U
* device instance $834 r0 *1 53.01,-123.455 pfet
M$834 \$212 B|X A|A_N|B|D|DOUT0|DOUT7|PH_B6|PH_B9|Q|S|VPB|VPWR
+ A|A_N|B|D|DOUT0|DOUT7|PH_B6|PH_B9|Q|S|VPB|VPWR pfet L=0.15U W=0.42U
+ AS=0.16655P AD=0.0567P PS=1.39U PD=0.69U
* device instance $835 r0 *1 53.55,-123.535 pfet
M$835 D|X$5 \$212 A|A_N|B|D|DOUT0|DOUT7|PH_B6|PH_B9|Q|S|VPB|VPWR
+ A|A_N|B|D|DOUT0|DOUT7|PH_B6|PH_B9|Q|S|VPB|VPWR pfet L=0.15U W=1U AS=0.16655P
+ AD=0.475P PS=1.39U PD=2.95U
* device instance $836 r0 *1 55.17,-123.385 pfet
M$836 A|A_N|B|D|DOUT0|DOUT7|PH_B6|PH_B9|Q|S|VPB|VPWR CLK|X \$214
+ A|A_N|B|D|DOUT0|DOUT7|PH_B6|PH_B9|Q|S|VPB|VPWR pfet L=0.15U W=0.64U
+ AS=0.1664P AD=0.0864P PS=1.8U PD=0.91U
* device instance $837 r0 *1 55.59,-123.385 pfet
M$837 \$215 \$214 A|A_N|B|D|DOUT0|DOUT7|PH_B6|PH_B9|Q|S|VPB|VPWR
+ A|A_N|B|D|DOUT0|DOUT7|PH_B6|PH_B9|Q|S|VPB|VPWR pfet L=0.15U W=0.64U
+ AS=0.0864P AD=0.1664P PS=0.91U PD=1.8U
* device instance $838 r0 *1 56.925,-123.245 pfet
M$838 \$216 D|X$5 A|A_N|B|D|DOUT0|DOUT7|PH_B6|PH_B9|Q|S|VPB|VPWR
+ A|A_N|B|D|DOUT0|DOUT7|PH_B6|PH_B9|Q|S|VPB|VPWR pfet L=0.15U W=0.42U
+ AS=0.1092P AD=0.0651P PS=1.36U PD=0.73U
* device instance $839 r0 *1 57.385,-123.245 pfet
M$839 \$217 \$215 \$216 A|A_N|B|D|DOUT0|DOUT7|PH_B6|PH_B9|Q|S|VPB|VPWR pfet
+ L=0.15U W=0.42U AS=0.0651P AD=0.07245P PS=0.73U PD=0.765U
* device instance $840 r0 *1 57.88,-123.245 pfet
M$840 \$239 \$214 \$217 A|A_N|B|D|DOUT0|DOUT7|PH_B6|PH_B9|Q|S|VPB|VPWR pfet
+ L=0.15U W=0.42U AS=0.07245P AD=0.1155P PS=0.765U PD=0.97U
* device instance $841 r0 *1 58.58,-123.245 pfet
M$841 A|A_N|B|D|DOUT0|DOUT7|PH_B6|PH_B9|Q|S|VPB|VPWR \$218 \$239
+ A|A_N|B|D|DOUT0|DOUT7|PH_B6|PH_B9|Q|S|VPB|VPWR pfet L=0.15U W=0.42U
+ AS=0.1155P AD=0.07035P PS=0.97U PD=0.755U
* device instance $842 r0 *1 59.065,-123.245 pfet
M$842 \$239 RESET_B|RST_B|SAMPLE A|A_N|B|D|DOUT0|DOUT7|PH_B6|PH_B9|Q|S|VPB|VPWR
+ A|A_N|B|D|DOUT0|DOUT7|PH_B6|PH_B9|Q|S|VPB|VPWR pfet L=0.15U W=0.42U
+ AS=0.07035P AD=0.1092P PS=0.755U PD=1.36U
* device instance $843 r0 *1 60.05,-123.455 pfet
M$843 \$218 \$217 A|A_N|B|D|DOUT0|DOUT7|PH_B6|PH_B9|Q|S|VPB|VPWR
+ A|A_N|B|D|DOUT0|DOUT7|PH_B6|PH_B9|Q|S|VPB|VPWR pfet L=0.15U W=0.84U
+ AS=0.2184P AD=0.12915P PS=2.2U PD=1.185U
* device instance $844 r0 *1 60.545,-123.245 pfet
M$844 \$219 \$214 \$218 A|A_N|B|D|DOUT0|DOUT7|PH_B6|PH_B9|Q|S|VPB|VPWR pfet
+ L=0.15U W=0.42U AS=0.12915P AD=0.0588P PS=1.185U PD=0.7U
* device instance $845 r0 *1 60.975,-123.245 pfet
M$845 \$240 \$215 \$219 A|A_N|B|D|DOUT0|DOUT7|PH_B6|PH_B9|Q|S|VPB|VPWR pfet
+ L=0.15U W=0.42U AS=0.0588P AD=0.0567P PS=0.7U PD=0.69U
* device instance $846 r0 *1 61.395,-123.245 pfet
M$846 A|A_N|B|D|DOUT0|DOUT7|PH_B6|PH_B9|Q|S|VPB|VPWR \$221 \$240
+ A|A_N|B|D|DOUT0|DOUT7|PH_B6|PH_B9|Q|S|VPB|VPWR pfet L=0.15U W=0.42U
+ AS=0.0567P AD=0.0819P PS=0.69U PD=0.81U
* device instance $847 r0 *1 61.935,-123.245 pfet
M$847 \$221 RESET_B|RST_B|SAMPLE A|A_N|B|D|DOUT0|DOUT7|PH_B6|PH_B9|Q|S|VPB|VPWR
+ A|A_N|B|D|DOUT0|DOUT7|PH_B6|PH_B9|Q|S|VPB|VPWR pfet L=0.15U W=0.42U
+ AS=0.0819P AD=0.0567P PS=0.81U PD=0.69U
* device instance $848 r0 *1 62.355,-123.245 pfet
M$848 A|A_N|B|D|DOUT0|DOUT7|PH_B6|PH_B9|Q|S|VPB|VPWR \$219 \$221
+ A|A_N|B|D|DOUT0|DOUT7|PH_B6|PH_B9|Q|S|VPB|VPWR pfet L=0.15U W=0.42U
+ AS=0.0567P AD=0.1134P PS=0.69U PD=1.38U
* device instance $849 r0 *1 63.43,-123.535 pfet
M$849 A0|DOUT7|Q \$221 A|A_N|B|D|DOUT0|DOUT7|PH_B6|PH_B9|Q|S|VPB|VPWR
+ A|A_N|B|D|DOUT0|DOUT7|PH_B6|PH_B9|Q|S|VPB|VPWR pfet L=0.15U W=1U AS=0.3012P
+ AD=0.26P PS=2.66U PD=2.52U
* device instance $850 r0 *1 23.89,-122.215 pfet
M$850 A|A_N|B|D|DOUT0|DOUT7|PH_B6|PH_B9|Q|S|VPB|VPWR CLK|X \$245
+ A|A_N|B|D|DOUT0|DOUT7|PH_B6|PH_B9|Q|S|VPB|VPWR pfet L=0.15U W=0.64U
+ AS=0.1664P AD=0.0864P PS=1.8U PD=0.91U
* device instance $851 r0 *1 24.31,-122.215 pfet
M$851 \$246 \$245 A|A_N|B|D|DOUT0|DOUT7|PH_B6|PH_B9|Q|S|VPB|VPWR
+ A|A_N|B|D|DOUT0|DOUT7|PH_B6|PH_B9|Q|S|VPB|VPWR pfet L=0.15U W=0.64U
+ AS=0.0864P AD=0.1664P PS=0.91U PD=1.8U
* device instance $852 r0 *1 25.645,-122.355 pfet
M$852 \$247 A|B|D|PH_B1|Q|S A|A_N|B|D|DOUT0|DOUT7|PH_B6|PH_B9|Q|S|VPB|VPWR
+ A|A_N|B|D|DOUT0|DOUT7|PH_B6|PH_B9|Q|S|VPB|VPWR pfet L=0.15U W=0.42U
+ AS=0.1092P AD=0.0651P PS=1.36U PD=0.73U
* device instance $853 r0 *1 26.105,-122.355 pfet
M$853 \$248 \$246 \$247 A|A_N|B|D|DOUT0|DOUT7|PH_B6|PH_B9|Q|S|VPB|VPWR pfet
+ L=0.15U W=0.42U AS=0.0651P AD=0.07245P PS=0.73U PD=0.765U
* device instance $854 r0 *1 26.6,-122.355 pfet
M$854 \$249 \$245 \$248 A|A_N|B|D|DOUT0|DOUT7|PH_B6|PH_B9|Q|S|VPB|VPWR pfet
+ L=0.15U W=0.42U AS=0.07245P AD=0.1155P PS=0.765U PD=0.97U
* device instance $855 r0 *1 27.3,-122.355 pfet
M$855 A|A_N|B|D|DOUT0|DOUT7|PH_B6|PH_B9|Q|S|VPB|VPWR \$250 \$249
+ A|A_N|B|D|DOUT0|DOUT7|PH_B6|PH_B9|Q|S|VPB|VPWR pfet L=0.15U W=0.42U
+ AS=0.1155P AD=0.07035P PS=0.97U PD=0.755U
* device instance $856 r0 *1 27.785,-122.355 pfet
M$856 \$249 RESET_B|RST_B|SAMPLE A|A_N|B|D|DOUT0|DOUT7|PH_B6|PH_B9|Q|S|VPB|VPWR
+ A|A_N|B|D|DOUT0|DOUT7|PH_B6|PH_B9|Q|S|VPB|VPWR pfet L=0.15U W=0.42U
+ AS=0.07035P AD=0.1092P PS=0.755U PD=1.36U
* device instance $857 r0 *1 29.265,-122.355 pfet
M$857 \$251 \$245 \$250 A|A_N|B|D|DOUT0|DOUT7|PH_B6|PH_B9|Q|S|VPB|VPWR pfet
+ L=0.15U W=0.42U AS=0.12915P AD=0.0588P PS=1.185U PD=0.7U
* device instance $858 r0 *1 29.695,-122.355 pfet
M$858 \$271 \$246 \$251 A|A_N|B|D|DOUT0|DOUT7|PH_B6|PH_B9|Q|S|VPB|VPWR pfet
+ L=0.15U W=0.42U AS=0.0588P AD=0.0567P PS=0.7U PD=0.69U
* device instance $859 r0 *1 30.115,-122.355 pfet
M$859 A|A_N|B|D|DOUT0|DOUT7|PH_B6|PH_B9|Q|S|VPB|VPWR \$252 \$271
+ A|A_N|B|D|DOUT0|DOUT7|PH_B6|PH_B9|Q|S|VPB|VPWR pfet L=0.15U W=0.42U
+ AS=0.0567P AD=0.0819P PS=0.69U PD=0.81U
* device instance $860 r0 *1 30.655,-122.355 pfet
M$860 \$252 RESET_B|RST_B|SAMPLE A|A_N|B|D|DOUT0|DOUT7|PH_B6|PH_B9|Q|S|VPB|VPWR
+ A|A_N|B|D|DOUT0|DOUT7|PH_B6|PH_B9|Q|S|VPB|VPWR pfet L=0.15U W=0.42U
+ AS=0.0819P AD=0.0567P PS=0.81U PD=0.69U
* device instance $861 r0 *1 31.075,-122.355 pfet
M$861 A|A_N|B|D|DOUT0|DOUT7|PH_B6|PH_B9|Q|S|VPB|VPWR \$251 \$252
+ A|A_N|B|D|DOUT0|DOUT7|PH_B6|PH_B9|Q|S|VPB|VPWR pfet L=0.15U W=0.42U
+ AS=0.0567P AD=0.1134P PS=0.69U PD=1.38U
* device instance $862 r0 *1 28.77,-122.145 pfet
M$862 \$250 \$248 A|A_N|B|D|DOUT0|DOUT7|PH_B6|PH_B9|Q|S|VPB|VPWR
+ A|A_N|B|D|DOUT0|DOUT7|PH_B6|PH_B9|Q|S|VPB|VPWR pfet L=0.15U W=0.84U
+ AS=0.2184P AD=0.12915P PS=2.2U PD=1.185U
* device instance $863 r0 *1 32.15,-122.065 pfet
M$863 B|D|PH_B0|Q|S \$252 A|A_N|B|D|DOUT0|DOUT7|PH_B6|PH_B9|Q|S|VPB|VPWR
+ A|A_N|B|D|DOUT0|DOUT7|PH_B6|PH_B9|Q|S|VPB|VPWR pfet L=0.15U W=1U AS=0.3012P
+ AD=0.26P PS=2.66U PD=2.52U
* device instance $864 r0 *1 32.835,-118.385 pfet
M$864 \$304 A|B|D|PH_B1|Q|S \$291
+ A|A_N|B|D|DOUT0|DOUT7|PH_B6|PH_B9|Q|S|VPB|VPWR pfet L=0.15U W=0.42U
+ AS=0.1092P AD=0.0441P PS=1.36U PD=0.63U
* device instance $865 r0 *1 33.195,-118.385 pfet
M$865 A|A_N|B|D|DOUT0|DOUT7|PH_B6|PH_B9|Q|S|VPB|VPWR A|X$12 \$304
+ A|A_N|B|D|DOUT0|DOUT7|PH_B6|PH_B9|Q|S|VPB|VPWR pfet L=0.15U W=0.42U
+ AS=0.0441P AD=0.14575P PS=0.63U PD=1.335U
* device instance $866 r0 *1 33.68,-118.095 pfet
M$866 A|X$16 \$291 A|A_N|B|D|DOUT0|DOUT7|PH_B6|PH_B9|Q|S|VPB|VPWR
+ A|A_N|B|D|DOUT0|DOUT7|PH_B6|PH_B9|Q|S|VPB|VPWR pfet L=0.15U W=1U AS=0.14575P
+ AD=0.34P PS=1.335U PD=2.68U
* device instance $867 r0 *1 33.635,-122.16 pfet
M$867 \$272 B|D|PH_B0|Q|S A|A_N|B|D|DOUT0|DOUT7|PH_B6|PH_B9|Q|S|VPB|VPWR
+ A|A_N|B|D|DOUT0|DOUT7|PH_B6|PH_B9|Q|S|VPB|VPWR pfet L=0.15U W=0.42U
+ AS=0.15835P AD=0.07665P PS=1.395U PD=0.785U
* device instance $868 r0 *1 34.15,-122.16 pfet
M$868 \$255 A0|DOUT0|Q \$272 A|A_N|B|D|DOUT0|DOUT7|PH_B6|PH_B9|Q|S|VPB|VPWR
+ pfet L=0.15U W=0.42U AS=0.07665P AD=0.1932P PS=0.785U PD=1.34U
* device instance $869 r0 *1 35.22,-122.16 pfet
M$869 \$273 A1|Y \$255 A|A_N|B|D|DOUT0|DOUT7|PH_B6|PH_B9|Q|S|VPB|VPWR pfet
+ L=0.15U W=0.42U AS=0.1932P AD=0.0441P PS=1.34U PD=0.63U
* device instance $870 r0 *1 35.58,-122.16 pfet
M$870 A|A_N|B|D|DOUT0|DOUT7|PH_B6|PH_B9|Q|S|VPB|VPWR \$257 \$273
+ A|A_N|B|D|DOUT0|DOUT7|PH_B6|PH_B9|Q|S|VPB|VPWR pfet L=0.15U W=0.42U
+ AS=0.0441P AD=0.0693P PS=0.63U PD=0.75U
* device instance $871 r0 *1 36.06,-122.16 pfet
M$871 \$257 B|D|PH_B0|Q|S A|A_N|B|D|DOUT0|DOUT7|PH_B6|PH_B9|Q|S|VPB|VPWR
+ A|A_N|B|D|DOUT0|DOUT7|PH_B6|PH_B9|Q|S|VPB|VPWR pfet L=0.15U W=0.42U
+ AS=0.0693P AD=0.1176P PS=0.75U PD=1.4U
* device instance $872 r0 *1 33.09,-122.065 pfet
M$872 A|A_N|B|D|DOUT0|DOUT7|PH_B6|PH_B9|Q|S|VPB|VPWR \$255 A|X$12
+ A|A_N|B|D|DOUT0|DOUT7|PH_B6|PH_B9|Q|S|VPB|VPWR pfet L=0.15U W=1U AS=0.26P
+ AD=0.15835P PS=2.52U PD=1.395U
* device instance $873 r0 *1 38.235,-122.16 pfet
M$873 \$274 A|B|D|PH_B5|Q|S A|A_N|B|D|DOUT0|DOUT7|PH_B6|PH_B9|Q|S|VPB|VPWR
+ A|A_N|B|D|DOUT0|DOUT7|PH_B6|PH_B9|Q|S|VPB|VPWR pfet L=0.15U W=0.42U
+ AS=0.15835P AD=0.07665P PS=1.395U PD=0.785U
* device instance $874 r0 *1 38.75,-122.16 pfet
M$874 \$258 A0|DOUT5|Q \$274 A|A_N|B|D|DOUT0|DOUT7|PH_B6|PH_B9|Q|S|VPB|VPWR
+ pfet L=0.15U W=0.42U AS=0.07665P AD=0.1932P PS=0.785U PD=1.34U
* device instance $875 r0 *1 39.82,-122.16 pfet
M$875 \$275 A1|Y \$258 A|A_N|B|D|DOUT0|DOUT7|PH_B6|PH_B9|Q|S|VPB|VPWR pfet
+ L=0.15U W=0.42U AS=0.1932P AD=0.0441P PS=1.34U PD=0.63U
* device instance $876 r0 *1 40.18,-122.16 pfet
M$876 A|A_N|B|D|DOUT0|DOUT7|PH_B6|PH_B9|Q|S|VPB|VPWR \$259 \$275
+ A|A_N|B|D|DOUT0|DOUT7|PH_B6|PH_B9|Q|S|VPB|VPWR pfet L=0.15U W=0.42U
+ AS=0.0441P AD=0.0693P PS=0.63U PD=0.75U
* device instance $877 r0 *1 40.66,-122.16 pfet
M$877 \$259 A|B|D|PH_B5|Q|S A|A_N|B|D|DOUT0|DOUT7|PH_B6|PH_B9|Q|S|VPB|VPWR
+ A|A_N|B|D|DOUT0|DOUT7|PH_B6|PH_B9|Q|S|VPB|VPWR pfet L=0.15U W=0.42U
+ AS=0.0693P AD=0.1176P PS=0.75U PD=1.4U
* device instance $878 r0 *1 37.69,-122.065 pfet
M$878 A|A_N|B|D|DOUT0|DOUT7|PH_B6|PH_B9|Q|S|VPB|VPWR \$258 A|X$6
+ A|A_N|B|D|DOUT0|DOUT7|PH_B6|PH_B9|Q|S|VPB|VPWR pfet L=0.15U W=1U AS=0.26P
+ AD=0.15835P PS=2.52U PD=1.395U
* device instance $879 r0 *1 42.035,-118.385 pfet
M$879 \$305 B|D|PH_B2|Q|S \$293 A|A_N|B|D|DOUT0|DOUT7|PH_B6|PH_B9|Q|S|VPB|VPWR
+ pfet L=0.15U W=0.42U AS=0.1092P AD=0.0441P PS=1.36U PD=0.63U
* device instance $880 r0 *1 42.395,-118.385 pfet
M$880 A|A_N|B|D|DOUT0|DOUT7|PH_B6|PH_B9|Q|S|VPB|VPWR A|X$17 \$305
+ A|A_N|B|D|DOUT0|DOUT7|PH_B6|PH_B9|Q|S|VPB|VPWR pfet L=0.15U W=0.42U
+ AS=0.0441P AD=0.14575P PS=0.63U PD=1.335U
* device instance $881 r0 *1 42.88,-118.095 pfet
M$881 A|X$13 \$293 A|A_N|B|D|DOUT0|DOUT7|PH_B6|PH_B9|Q|S|VPB|VPWR
+ A|A_N|B|D|DOUT0|DOUT7|PH_B6|PH_B9|Q|S|VPB|VPWR pfet L=0.15U W=1U AS=0.14575P
+ AD=0.34P PS=1.335U PD=2.68U
* device instance $882 r0 *1 42.93,-122.145 pfet
M$882 \$261 A|X$13 A|A_N|B|D|DOUT0|DOUT7|PH_B6|PH_B9|Q|S|VPB|VPWR
+ A|A_N|B|D|DOUT0|DOUT7|PH_B6|PH_B9|Q|S|VPB|VPWR pfet L=0.15U W=0.42U
+ AS=0.1176P AD=0.0567P PS=1.4U PD=0.69U
* device instance $883 r0 *1 43.35,-122.145 pfet
M$883 \$261 B|X A|A_N|B|D|DOUT0|DOUT7|PH_B6|PH_B9|Q|S|VPB|VPWR
+ A|A_N|B|D|DOUT0|DOUT7|PH_B6|PH_B9|Q|S|VPB|VPWR pfet L=0.15U W=0.42U
+ AS=0.16655P AD=0.0567P PS=1.39U PD=0.69U
* device instance $884 r0 *1 43.89,-122.065 pfet
M$884 D|X$6 \$261 A|A_N|B|D|DOUT0|DOUT7|PH_B6|PH_B9|Q|S|VPB|VPWR
+ A|A_N|B|D|DOUT0|DOUT7|PH_B6|PH_B9|Q|S|VPB|VPWR pfet L=0.15U W=1U AS=0.16655P
+ AD=0.475P PS=1.39U PD=2.95U
* device instance $885 r0 *1 44.13,-117.945 pfet
M$885 A|A_N|B|D|DOUT0|DOUT7|PH_B6|PH_B9|Q|S|VPB|VPWR CLK|X \$295
+ A|A_N|B|D|DOUT0|DOUT7|PH_B6|PH_B9|Q|S|VPB|VPWR pfet L=0.15U W=0.64U
+ AS=0.1664P AD=0.0864P PS=1.8U PD=0.91U
* device instance $886 r0 *1 44.55,-117.945 pfet
M$886 \$296 \$295 A|A_N|B|D|DOUT0|DOUT7|PH_B6|PH_B9|Q|S|VPB|VPWR
+ A|A_N|B|D|DOUT0|DOUT7|PH_B6|PH_B9|Q|S|VPB|VPWR pfet L=0.15U W=0.64U
+ AS=0.0864P AD=0.1664P PS=0.91U PD=1.8U
* device instance $887 r0 *1 49.01,-118.015 pfet
M$887 \$300 \$298 A|A_N|B|D|DOUT0|DOUT7|PH_B6|PH_B9|Q|S|VPB|VPWR
+ A|A_N|B|D|DOUT0|DOUT7|PH_B6|PH_B9|Q|S|VPB|VPWR pfet L=0.15U W=0.84U
+ AS=0.2184P AD=0.12915P PS=2.2U PD=1.185U
* device instance $888 r0 *1 49.505,-117.805 pfet
M$888 \$301 \$295 \$300 A|A_N|B|D|DOUT0|DOUT7|PH_B6|PH_B9|Q|S|VPB|VPWR pfet
+ L=0.15U W=0.42U AS=0.12915P AD=0.0588P PS=1.185U PD=0.7U
* device instance $889 r0 *1 49.935,-117.805 pfet
M$889 \$309 \$296 \$301 A|A_N|B|D|DOUT0|DOUT7|PH_B6|PH_B9|Q|S|VPB|VPWR pfet
+ L=0.15U W=0.42U AS=0.0588P AD=0.0567P PS=0.7U PD=0.69U
* device instance $890 r0 *1 50.355,-117.805 pfet
M$890 A|A_N|B|D|DOUT0|DOUT7|PH_B6|PH_B9|Q|S|VPB|VPWR \$302 \$309
+ A|A_N|B|D|DOUT0|DOUT7|PH_B6|PH_B9|Q|S|VPB|VPWR pfet L=0.15U W=0.42U
+ AS=0.0567P AD=0.0819P PS=0.69U PD=0.81U
* device instance $891 r0 *1 50.895,-117.805 pfet
M$891 \$302 RESET_B|RST_B|SAMPLE A|A_N|B|D|DOUT0|DOUT7|PH_B6|PH_B9|Q|S|VPB|VPWR
+ A|A_N|B|D|DOUT0|DOUT7|PH_B6|PH_B9|Q|S|VPB|VPWR pfet L=0.15U W=0.42U
+ AS=0.0819P AD=0.0567P PS=0.81U PD=0.69U
* device instance $892 r0 *1 51.315,-117.805 pfet
M$892 A|A_N|B|D|DOUT0|DOUT7|PH_B6|PH_B9|Q|S|VPB|VPWR \$301 \$302
+ A|A_N|B|D|DOUT0|DOUT7|PH_B6|PH_B9|Q|S|VPB|VPWR pfet L=0.15U W=0.42U
+ AS=0.0567P AD=0.1134P PS=0.69U PD=1.38U
* device instance $893 r0 *1 52.13,-122.145 pfet
M$893 \$264 A|X$14 A|A_N|B|D|DOUT0|DOUT7|PH_B6|PH_B9|Q|S|VPB|VPWR
+ A|A_N|B|D|DOUT0|DOUT7|PH_B6|PH_B9|Q|S|VPB|VPWR pfet L=0.15U W=0.42U
+ AS=0.1176P AD=0.0567P PS=1.4U PD=0.69U
* device instance $894 r0 *1 52.55,-122.145 pfet
M$894 \$264 B|X A|A_N|B|D|DOUT0|DOUT7|PH_B6|PH_B9|Q|S|VPB|VPWR
+ A|A_N|B|D|DOUT0|DOUT7|PH_B6|PH_B9|Q|S|VPB|VPWR pfet L=0.15U W=0.42U
+ AS=0.16655P AD=0.0567P PS=1.39U PD=0.69U
* device instance $895 r0 *1 53.09,-122.065 pfet
M$895 D|X$7 \$264 A|A_N|B|D|DOUT0|DOUT7|PH_B6|PH_B9|Q|S|VPB|VPWR
+ A|A_N|B|D|DOUT0|DOUT7|PH_B6|PH_B9|Q|S|VPB|VPWR pfet L=0.15U W=1U AS=0.16655P
+ AD=0.475P PS=1.39U PD=2.95U
* device instance $896 r0 *1 52.39,-118.095 pfet
M$896 A|B|D|PH_B9|Q|S \$302 A|A_N|B|D|DOUT0|DOUT7|PH_B6|PH_B9|Q|S|VPB|VPWR
+ A|A_N|B|D|DOUT0|DOUT7|PH_B6|PH_B9|Q|S|VPB|VPWR pfet L=0.15U W=1U AS=0.3012P
+ AD=0.26P PS=2.66U PD=2.52U
* device instance $897 r0 *1 55.835,-121.775 pfet
M$897 \$276 B|D|PH_B8|Q|S \$267 A|A_N|B|D|DOUT0|DOUT7|PH_B6|PH_B9|Q|S|VPB|VPWR
+ pfet L=0.15U W=0.42U AS=0.1092P AD=0.0441P PS=1.36U PD=0.63U
* device instance $898 r0 *1 56.195,-121.775 pfet
M$898 \$276 A|X$15 A|A_N|B|D|DOUT0|DOUT7|PH_B6|PH_B9|Q|S|VPB|VPWR
+ A|A_N|B|D|DOUT0|DOUT7|PH_B6|PH_B9|Q|S|VPB|VPWR pfet L=0.15U W=0.42U
+ AS=0.14575P AD=0.0441P PS=1.335U PD=0.63U
* device instance $899 r0 *1 56.68,-122.065 pfet
M$899 A|X$11 \$267 A|A_N|B|D|DOUT0|DOUT7|PH_B6|PH_B9|Q|S|VPB|VPWR
+ A|A_N|B|D|DOUT0|DOUT7|PH_B6|PH_B9|Q|S|VPB|VPWR pfet L=0.15U W=1U AS=0.14575P
+ AD=0.34P PS=1.335U PD=2.68U
* device instance $900 r0 *1 59.395,-122.16 pfet
M$900 \$277 B|C|D|PH_B7|Q|S A|A_N|B|D|DOUT0|DOUT7|PH_B6|PH_B9|Q|S|VPB|VPWR
+ A|A_N|B|D|DOUT0|DOUT7|PH_B6|PH_B9|Q|S|VPB|VPWR pfet L=0.15U W=0.42U
+ AS=0.15835P AD=0.07665P PS=1.395U PD=0.785U
* device instance $901 r0 *1 59.91,-122.16 pfet
M$901 \$269 A0|DOUT7|Q \$277 A|A_N|B|D|DOUT0|DOUT7|PH_B6|PH_B9|Q|S|VPB|VPWR
+ pfet L=0.15U W=0.42U AS=0.07665P AD=0.1932P PS=0.785U PD=1.34U
* device instance $902 r0 *1 60.98,-122.16 pfet
M$902 \$278 A1|Y \$269 A|A_N|B|D|DOUT0|DOUT7|PH_B6|PH_B9|Q|S|VPB|VPWR pfet
+ L=0.15U W=0.42U AS=0.1932P AD=0.0441P PS=1.34U PD=0.63U
* device instance $903 r0 *1 61.34,-122.16 pfet
M$903 A|A_N|B|D|DOUT0|DOUT7|PH_B6|PH_B9|Q|S|VPB|VPWR \$270 \$278
+ A|A_N|B|D|DOUT0|DOUT7|PH_B6|PH_B9|Q|S|VPB|VPWR pfet L=0.15U W=0.42U
+ AS=0.0441P AD=0.0693P PS=0.63U PD=0.75U
* device instance $904 r0 *1 61.82,-122.16 pfet
M$904 \$270 B|C|D|PH_B7|Q|S A|A_N|B|D|DOUT0|DOUT7|PH_B6|PH_B9|Q|S|VPB|VPWR
+ A|A_N|B|D|DOUT0|DOUT7|PH_B6|PH_B9|Q|S|VPB|VPWR pfet L=0.15U W=0.42U
+ AS=0.0693P AD=0.1176P PS=0.75U PD=1.4U
* device instance $905 r0 *1 58.85,-122.065 pfet
M$905 A|A_N|B|D|DOUT0|DOUT7|PH_B6|PH_B9|Q|S|VPB|VPWR \$269 A|X$15
+ A|A_N|B|D|DOUT0|DOUT7|PH_B6|PH_B9|Q|S|VPB|VPWR pfet L=0.15U W=1U AS=0.26P
+ AD=0.15835P PS=2.52U PD=1.395U
* device instance $906 r0 *1 27.945,-116.915 pfet
M$906 \$314 D|X$8 A|A_N|B|D|DOUT0|DOUT7|PH_B6|PH_B9|Q|S|VPB|VPWR
+ A|A_N|B|D|DOUT0|DOUT7|PH_B6|PH_B9|Q|S|VPB|VPWR pfet L=0.15U W=0.42U
+ AS=0.1092P AD=0.0651P PS=1.36U PD=0.73U
* device instance $907 r0 *1 28.405,-116.915 pfet
M$907 \$315 \$312 \$314 A|A_N|B|D|DOUT0|DOUT7|PH_B6|PH_B9|Q|S|VPB|VPWR pfet
+ L=0.15U W=0.42U AS=0.0651P AD=0.07245P PS=0.73U PD=0.765U
* device instance $908 r0 *1 28.9,-116.915 pfet
M$908 \$316 \$311 \$315 A|A_N|B|D|DOUT0|DOUT7|PH_B6|PH_B9|Q|S|VPB|VPWR pfet
+ L=0.15U W=0.42U AS=0.07245P AD=0.1155P PS=0.765U PD=0.97U
* device instance $909 r0 *1 29.6,-116.915 pfet
M$909 A|A_N|B|D|DOUT0|DOUT7|PH_B6|PH_B9|Q|S|VPB|VPWR \$317 \$316
+ A|A_N|B|D|DOUT0|DOUT7|PH_B6|PH_B9|Q|S|VPB|VPWR pfet L=0.15U W=0.42U
+ AS=0.1155P AD=0.07035P PS=0.97U PD=0.755U
* device instance $910 r0 *1 30.085,-116.915 pfet
M$910 \$316 RESET_B|RST_B|SAMPLE A|A_N|B|D|DOUT0|DOUT7|PH_B6|PH_B9|Q|S|VPB|VPWR
+ A|A_N|B|D|DOUT0|DOUT7|PH_B6|PH_B9|Q|S|VPB|VPWR pfet L=0.15U W=0.42U
+ AS=0.07035P AD=0.1092P PS=0.755U PD=1.36U
* device instance $911 r0 *1 31.565,-116.915 pfet
M$911 \$318 \$311 \$317 A|A_N|B|D|DOUT0|DOUT7|PH_B6|PH_B9|Q|S|VPB|VPWR pfet
+ L=0.15U W=0.42U AS=0.12915P AD=0.0588P PS=1.185U PD=0.7U
* device instance $912 r0 *1 31.995,-116.915 pfet
M$912 \$337 \$312 \$318 A|A_N|B|D|DOUT0|DOUT7|PH_B6|PH_B9|Q|S|VPB|VPWR pfet
+ L=0.15U W=0.42U AS=0.0588P AD=0.0567P PS=0.7U PD=0.69U
* device instance $913 r0 *1 32.415,-116.915 pfet
M$913 A|A_N|B|D|DOUT0|DOUT7|PH_B6|PH_B9|Q|S|VPB|VPWR \$319 \$337
+ A|A_N|B|D|DOUT0|DOUT7|PH_B6|PH_B9|Q|S|VPB|VPWR pfet L=0.15U W=0.42U
+ AS=0.0567P AD=0.0819P PS=0.69U PD=0.81U
* device instance $914 r0 *1 32.955,-116.915 pfet
M$914 \$319 RESET_B|RST_B|SAMPLE A|A_N|B|D|DOUT0|DOUT7|PH_B6|PH_B9|Q|S|VPB|VPWR
+ A|A_N|B|D|DOUT0|DOUT7|PH_B6|PH_B9|Q|S|VPB|VPWR pfet L=0.15U W=0.42U
+ AS=0.0819P AD=0.0567P PS=0.81U PD=0.69U
* device instance $915 r0 *1 33.375,-116.915 pfet
M$915 A|A_N|B|D|DOUT0|DOUT7|PH_B6|PH_B9|Q|S|VPB|VPWR \$318 \$319
+ A|A_N|B|D|DOUT0|DOUT7|PH_B6|PH_B9|Q|S|VPB|VPWR pfet L=0.15U W=0.42U
+ AS=0.0567P AD=0.1134P PS=0.69U PD=1.38U
* device instance $916 r0 *1 31.07,-116.705 pfet
M$916 \$317 \$315 A|A_N|B|D|DOUT0|DOUT7|PH_B6|PH_B9|Q|S|VPB|VPWR
+ A|A_N|B|D|DOUT0|DOUT7|PH_B6|PH_B9|Q|S|VPB|VPWR pfet L=0.15U W=0.84U
+ AS=0.2184P AD=0.12915P PS=2.2U PD=1.185U
* device instance $917 r0 *1 34.45,-116.625 pfet
M$917 A0|DOUT0|Q \$319 A|A_N|B|D|DOUT0|DOUT7|PH_B6|PH_B9|Q|S|VPB|VPWR
+ A|A_N|B|D|DOUT0|DOUT7|PH_B6|PH_B9|Q|S|VPB|VPWR pfet L=0.15U W=1U AS=0.3012P
+ AD=0.26P PS=2.66U PD=2.52U
* device instance $918 r0 *1 43.755,-116.72 pfet
M$918 \$339 A|B|D|PH_B1|Q|S A|A_N|B|D|DOUT0|DOUT7|PH_B6|PH_B9|Q|S|VPB|VPWR
+ A|A_N|B|D|DOUT0|DOUT7|PH_B6|PH_B9|Q|S|VPB|VPWR pfet L=0.15U W=0.42U
+ AS=0.15835P AD=0.07665P PS=1.395U PD=0.785U
* device instance $919 r0 *1 44.27,-116.72 pfet
M$919 \$323 A0|DOUT1|Q \$339 A|A_N|B|D|DOUT0|DOUT7|PH_B6|PH_B9|Q|S|VPB|VPWR
+ pfet L=0.15U W=0.42U AS=0.07665P AD=0.1932P PS=0.785U PD=1.34U
* device instance $920 r0 *1 45.34,-116.72 pfet
M$920 \$340 A1|Y \$323 A|A_N|B|D|DOUT0|DOUT7|PH_B6|PH_B9|Q|S|VPB|VPWR pfet
+ L=0.15U W=0.42U AS=0.1932P AD=0.0441P PS=1.34U PD=0.63U
* device instance $921 r0 *1 45.7,-116.72 pfet
M$921 A|A_N|B|D|DOUT0|DOUT7|PH_B6|PH_B9|Q|S|VPB|VPWR \$325 \$340
+ A|A_N|B|D|DOUT0|DOUT7|PH_B6|PH_B9|Q|S|VPB|VPWR pfet L=0.15U W=0.42U
+ AS=0.0441P AD=0.0693P PS=0.63U PD=0.75U
* device instance $922 r0 *1 46.18,-116.72 pfet
M$922 \$325 A|B|D|PH_B1|Q|S A|A_N|B|D|DOUT0|DOUT7|PH_B6|PH_B9|Q|S|VPB|VPWR
+ A|A_N|B|D|DOUT0|DOUT7|PH_B6|PH_B9|Q|S|VPB|VPWR pfet L=0.15U W=0.42U
+ AS=0.0693P AD=0.1176P PS=0.75U PD=1.4U
* device instance $923 r0 *1 43.21,-116.625 pfet
M$923 A|A_N|B|D|DOUT0|DOUT7|PH_B6|PH_B9|Q|S|VPB|VPWR \$323 A|X$17
+ A|A_N|B|D|DOUT0|DOUT7|PH_B6|PH_B9|Q|S|VPB|VPWR pfet L=0.15U W=1U AS=0.26P
+ AD=0.15835P PS=2.52U PD=1.395U
* device instance $924 r0 *1 45.885,-117.805 pfet
M$924 \$297 D|PH_SAMPLE|Y A|A_N|B|D|DOUT0|DOUT7|PH_B6|PH_B9|Q|S|VPB|VPWR
+ A|A_N|B|D|DOUT0|DOUT7|PH_B6|PH_B9|Q|S|VPB|VPWR pfet L=0.15U W=0.42U
+ AS=0.1092P AD=0.0651P PS=1.36U PD=0.73U
* device instance $925 r0 *1 46.345,-117.805 pfet
M$925 \$298 \$296 \$297 A|A_N|B|D|DOUT0|DOUT7|PH_B6|PH_B9|Q|S|VPB|VPWR pfet
+ L=0.15U W=0.42U AS=0.0651P AD=0.07245P PS=0.73U PD=0.765U
* device instance $926 r0 *1 46.84,-117.805 pfet
M$926 \$299 \$295 \$298 A|A_N|B|D|DOUT0|DOUT7|PH_B6|PH_B9|Q|S|VPB|VPWR pfet
+ L=0.15U W=0.42U AS=0.07245P AD=0.1155P PS=0.765U PD=0.97U
* device instance $927 r0 *1 47.54,-117.805 pfet
M$927 A|A_N|B|D|DOUT0|DOUT7|PH_B6|PH_B9|Q|S|VPB|VPWR \$300 \$299
+ A|A_N|B|D|DOUT0|DOUT7|PH_B6|PH_B9|Q|S|VPB|VPWR pfet L=0.15U W=0.42U
+ AS=0.1155P AD=0.07035P PS=0.97U PD=0.755U
* device instance $928 r0 *1 48.025,-117.805 pfet
M$928 \$299 RESET_B|RST_B|SAMPLE A|A_N|B|D|DOUT0|DOUT7|PH_B6|PH_B9|Q|S|VPB|VPWR
+ A|A_N|B|D|DOUT0|DOUT7|PH_B6|PH_B9|Q|S|VPB|VPWR pfet L=0.15U W=0.42U
+ AS=0.07035P AD=0.1092P PS=0.755U PD=1.36U
* device instance $929 r0 *1 56.465,-116.915 pfet
M$929 \$330 D|X$7 A|A_N|B|D|DOUT0|DOUT7|PH_B6|PH_B9|Q|S|VPB|VPWR
+ A|A_N|B|D|DOUT0|DOUT7|PH_B6|PH_B9|Q|S|VPB|VPWR pfet L=0.15U W=0.42U
+ AS=0.1092P AD=0.0651P PS=1.36U PD=0.73U
* device instance $930 r0 *1 56.925,-116.915 pfet
M$930 \$331 \$329 \$330 A|A_N|B|D|DOUT0|DOUT7|PH_B6|PH_B9|Q|S|VPB|VPWR pfet
+ L=0.15U W=0.42U AS=0.0651P AD=0.07245P PS=0.73U PD=0.765U
* device instance $931 r0 *1 57.42,-116.915 pfet
M$931 \$332 \$328 \$331 A|A_N|B|D|DOUT0|DOUT7|PH_B6|PH_B9|Q|S|VPB|VPWR pfet
+ L=0.15U W=0.42U AS=0.07245P AD=0.1155P PS=0.765U PD=0.97U
* device instance $932 r0 *1 58.12,-116.915 pfet
M$932 A|A_N|B|D|DOUT0|DOUT7|PH_B6|PH_B9|Q|S|VPB|VPWR \$333 \$332
+ A|A_N|B|D|DOUT0|DOUT7|PH_B6|PH_B9|Q|S|VPB|VPWR pfet L=0.15U W=0.42U
+ AS=0.1155P AD=0.07035P PS=0.97U PD=0.755U
* device instance $933 r0 *1 58.605,-116.915 pfet
M$933 \$332 RESET_B|RST_B|SAMPLE A|A_N|B|D|DOUT0|DOUT7|PH_B6|PH_B9|Q|S|VPB|VPWR
+ A|A_N|B|D|DOUT0|DOUT7|PH_B6|PH_B9|Q|S|VPB|VPWR pfet L=0.15U W=0.42U
+ AS=0.07035P AD=0.1092P PS=0.755U PD=1.36U
* device instance $934 r0 *1 60.085,-116.915 pfet
M$934 \$334 \$328 \$333 A|A_N|B|D|DOUT0|DOUT7|PH_B6|PH_B9|Q|S|VPB|VPWR pfet
+ L=0.15U W=0.42U AS=0.12915P AD=0.0588P PS=1.185U PD=0.7U
* device instance $935 r0 *1 60.515,-116.915 pfet
M$935 \$342 \$329 \$334 A|A_N|B|D|DOUT0|DOUT7|PH_B6|PH_B9|Q|S|VPB|VPWR pfet
+ L=0.15U W=0.42U AS=0.0588P AD=0.0567P PS=0.7U PD=0.69U
* device instance $936 r0 *1 60.935,-116.915 pfet
M$936 A|A_N|B|D|DOUT0|DOUT7|PH_B6|PH_B9|Q|S|VPB|VPWR \$335 \$342
+ A|A_N|B|D|DOUT0|DOUT7|PH_B6|PH_B9|Q|S|VPB|VPWR pfet L=0.15U W=0.42U
+ AS=0.0567P AD=0.0819P PS=0.69U PD=0.81U
* device instance $937 r0 *1 61.475,-116.915 pfet
M$937 \$335 RESET_B|RST_B|SAMPLE A|A_N|B|D|DOUT0|DOUT7|PH_B6|PH_B9|Q|S|VPB|VPWR
+ A|A_N|B|D|DOUT0|DOUT7|PH_B6|PH_B9|Q|S|VPB|VPWR pfet L=0.15U W=0.42U
+ AS=0.0819P AD=0.0567P PS=0.81U PD=0.69U
* device instance $938 r0 *1 61.895,-116.915 pfet
M$938 A|A_N|B|D|DOUT0|DOUT7|PH_B6|PH_B9|Q|S|VPB|VPWR \$334 \$335
+ A|A_N|B|D|DOUT0|DOUT7|PH_B6|PH_B9|Q|S|VPB|VPWR pfet L=0.15U W=0.42U
+ AS=0.0567P AD=0.1134P PS=0.69U PD=1.38U
* device instance $939 r0 *1 59.59,-116.705 pfet
M$939 \$333 \$331 A|A_N|B|D|DOUT0|DOUT7|PH_B6|PH_B9|Q|S|VPB|VPWR
+ A|A_N|B|D|DOUT0|DOUT7|PH_B6|PH_B9|Q|S|VPB|VPWR pfet L=0.15U W=0.84U
+ AS=0.2184P AD=0.12915P PS=2.2U PD=1.185U
* device instance $940 r0 *1 62.97,-116.625 pfet
M$940 A0|DOUT8|Q \$335 A|A_N|B|D|DOUT0|DOUT7|PH_B6|PH_B9|Q|S|VPB|VPWR
+ A|A_N|B|D|DOUT0|DOUT7|PH_B6|PH_B9|Q|S|VPB|VPWR pfet L=0.15U W=1U AS=0.3012P
+ AD=0.26P PS=2.66U PD=2.52U
* device instance $941 r0 *1 26.19,-116.775 pfet
M$941 A|A_N|B|D|DOUT0|DOUT7|PH_B6|PH_B9|Q|S|VPB|VPWR CLK|X \$311
+ A|A_N|B|D|DOUT0|DOUT7|PH_B6|PH_B9|Q|S|VPB|VPWR pfet L=0.15U W=0.64U
+ AS=0.1664P AD=0.0864P PS=1.8U PD=0.91U
* device instance $942 r0 *1 26.61,-116.775 pfet
M$942 \$312 \$311 A|A_N|B|D|DOUT0|DOUT7|PH_B6|PH_B9|Q|S|VPB|VPWR
+ A|A_N|B|D|DOUT0|DOUT7|PH_B6|PH_B9|Q|S|VPB|VPWR pfet L=0.15U W=0.64U
+ AS=0.0864P AD=0.1664P PS=0.91U PD=1.8U
* device instance $943 r0 *1 28.77,-112.575 pfet
M$943 \$359 \$358 A|A_N|B|D|DOUT0|DOUT7|PH_B6|PH_B9|Q|S|VPB|VPWR
+ A|A_N|B|D|DOUT0|DOUT7|PH_B6|PH_B9|Q|S|VPB|VPWR pfet L=0.15U W=0.84U
+ AS=0.2184P AD=0.12915P PS=2.2U PD=1.185U
* device instance $944 r0 *1 29.265,-112.365 pfet
M$944 \$360 \$354 \$359 A|A_N|B|D|DOUT0|DOUT7|PH_B6|PH_B9|Q|S|VPB|VPWR pfet
+ L=0.15U W=0.42U AS=0.12915P AD=0.0588P PS=1.185U PD=0.7U
* device instance $945 r0 *1 29.695,-112.365 pfet
M$945 \$400 \$355 \$360 A|A_N|B|D|DOUT0|DOUT7|PH_B6|PH_B9|Q|S|VPB|VPWR pfet
+ L=0.15U W=0.42U AS=0.0588P AD=0.0567P PS=0.7U PD=0.69U
* device instance $946 r0 *1 30.115,-112.365 pfet
M$946 A|A_N|B|D|DOUT0|DOUT7|PH_B6|PH_B9|Q|S|VPB|VPWR \$361 \$400
+ A|A_N|B|D|DOUT0|DOUT7|PH_B6|PH_B9|Q|S|VPB|VPWR pfet L=0.15U W=0.42U
+ AS=0.0567P AD=0.0819P PS=0.69U PD=0.81U
* device instance $947 r0 *1 30.655,-112.365 pfet
M$947 \$361 RESET_B|RST_B|SAMPLE A|A_N|B|D|DOUT0|DOUT7|PH_B6|PH_B9|Q|S|VPB|VPWR
+ A|A_N|B|D|DOUT0|DOUT7|PH_B6|PH_B9|Q|S|VPB|VPWR pfet L=0.15U W=0.42U
+ AS=0.0819P AD=0.0567P PS=0.81U PD=0.69U
* device instance $948 r0 *1 31.075,-112.365 pfet
M$948 A|A_N|B|D|DOUT0|DOUT7|PH_B6|PH_B9|Q|S|VPB|VPWR \$360 \$361
+ A|A_N|B|D|DOUT0|DOUT7|PH_B6|PH_B9|Q|S|VPB|VPWR pfet L=0.15U W=0.42U
+ AS=0.0567P AD=0.1134P PS=0.69U PD=1.38U
* device instance $949 r0 *1 32.15,-112.655 pfet
M$949 A0|B|DOUT9|Q \$361 A|A_N|B|D|DOUT0|DOUT7|PH_B6|PH_B9|Q|S|VPB|VPWR
+ A|A_N|B|D|DOUT0|DOUT7|PH_B6|PH_B9|Q|S|VPB|VPWR pfet L=0.15U W=1U AS=0.3012P
+ AD=0.26P PS=2.66U PD=2.52U
* device instance $950 r0 *1 33.635,-112.56 pfet
M$950 \$395 A|B|D|PH_B9|Q|S A|A_N|B|D|DOUT0|DOUT7|PH_B6|PH_B9|Q|S|VPB|VPWR
+ A|A_N|B|D|DOUT0|DOUT7|PH_B6|PH_B9|Q|S|VPB|VPWR pfet L=0.15U W=0.42U
+ AS=0.15835P AD=0.07665P PS=1.395U PD=0.785U
* device instance $951 r0 *1 34.15,-112.56 pfet
M$951 \$363 A0|B|DOUT9|Q \$395 A|A_N|B|D|DOUT0|DOUT7|PH_B6|PH_B9|Q|S|VPB|VPWR
+ pfet L=0.15U W=0.42U AS=0.07665P AD=0.1932P PS=0.785U PD=1.34U
* device instance $952 r0 *1 35.22,-112.56 pfet
M$952 \$396 A|A1|COMP_OUT \$363 A|A_N|B|D|DOUT0|DOUT7|PH_B6|PH_B9|Q|S|VPB|VPWR
+ pfet L=0.15U W=0.42U AS=0.1932P AD=0.0441P PS=1.34U PD=0.63U
* device instance $953 r0 *1 35.58,-112.56 pfet
M$953 A|A_N|B|D|DOUT0|DOUT7|PH_B6|PH_B9|Q|S|VPB|VPWR \$365 \$396
+ A|A_N|B|D|DOUT0|DOUT7|PH_B6|PH_B9|Q|S|VPB|VPWR pfet L=0.15U W=0.42U
+ AS=0.0441P AD=0.0693P PS=0.63U PD=0.75U
* device instance $954 r0 *1 36.06,-112.56 pfet
M$954 \$365 A|B|D|PH_B9|Q|S A|A_N|B|D|DOUT0|DOUT7|PH_B6|PH_B9|Q|S|VPB|VPWR
+ A|A_N|B|D|DOUT0|DOUT7|PH_B6|PH_B9|Q|S|VPB|VPWR pfet L=0.15U W=0.42U
+ AS=0.0693P AD=0.1176P PS=0.75U PD=1.4U
* device instance $955 r0 *1 33.09,-112.655 pfet
M$955 A|A_N|B|D|DOUT0|DOUT7|PH_B6|PH_B9|Q|S|VPB|VPWR \$363 D|X$9
+ A|A_N|B|D|DOUT0|DOUT7|PH_B6|PH_B9|Q|S|VPB|VPWR pfet L=0.15U W=1U AS=0.26P
+ AD=0.15835P PS=2.52U PD=1.395U
* device instance $956 r0 *1 36.49,-116.705 pfet
M$956 \$320 A|X$16 A|A_N|B|D|DOUT0|DOUT7|PH_B6|PH_B9|Q|S|VPB|VPWR
+ A|A_N|B|D|DOUT0|DOUT7|PH_B6|PH_B9|Q|S|VPB|VPWR pfet L=0.15U W=0.42U
+ AS=0.1176P AD=0.0567P PS=1.4U PD=0.69U
* device instance $957 r0 *1 36.91,-116.705 pfet
M$957 \$320 B|X A|A_N|B|D|DOUT0|DOUT7|PH_B6|PH_B9|Q|S|VPB|VPWR
+ A|A_N|B|D|DOUT0|DOUT7|PH_B6|PH_B9|Q|S|VPB|VPWR pfet L=0.15U W=0.42U
+ AS=0.16655P AD=0.0567P PS=1.39U PD=0.69U
* device instance $958 r0 *1 37.45,-116.625 pfet
M$958 D|X$8 \$320 A|A_N|B|D|DOUT0|DOUT7|PH_B6|PH_B9|Q|S|VPB|VPWR
+ A|A_N|B|D|DOUT0|DOUT7|PH_B6|PH_B9|Q|S|VPB|VPWR pfet L=0.15U W=1U AS=0.16655P
+ AD=0.475P PS=1.39U PD=2.95U
* device instance $959 r0 *1 38.61,-112.655 pfet
M$959 A|A_N|B|D|DOUT0|DOUT7|PH_B6|PH_B9|Q|S|VPB|VPWR A|X \$366
+ A|A_N|B|D|DOUT0|DOUT7|PH_B6|PH_B9|Q|S|VPB|VPWR pfet L=0.15U W=1U AS=0.26P
+ AD=0.135P PS=2.52U PD=1.27U
* device instance $960 r0 *1 39.03,-112.655 pfet
M$960 CLK|X \$366 A|A_N|B|D|DOUT0|DOUT7|PH_B6|PH_B9|Q|S|VPB|VPWR
+ A|A_N|B|D|DOUT0|DOUT7|PH_B6|PH_B9|Q|S|VPB|VPWR pfet L=0.15U W=1U AS=0.135P
+ AD=0.135P PS=1.27U PD=1.27U
* device instance $961 r0 *1 39.45,-112.655 pfet
M$961 A|A_N|B|D|DOUT0|DOUT7|PH_B6|PH_B9|Q|S|VPB|VPWR \$366 CLK|X
+ A|A_N|B|D|DOUT0|DOUT7|PH_B6|PH_B9|Q|S|VPB|VPWR pfet L=0.15U W=1U AS=0.135P
+ AD=0.135P PS=1.27U PD=1.27U
* device instance $962 r0 *1 39.87,-112.655 pfet
M$962 CLK|X \$366 A|A_N|B|D|DOUT0|DOUT7|PH_B6|PH_B9|Q|S|VPB|VPWR
+ A|A_N|B|D|DOUT0|DOUT7|PH_B6|PH_B9|Q|S|VPB|VPWR pfet L=0.15U W=1U AS=0.135P
+ AD=0.135P PS=1.27U PD=1.27U
* device instance $963 r0 *1 40.29,-112.655 pfet
M$963 A|A_N|B|D|DOUT0|DOUT7|PH_B6|PH_B9|Q|S|VPB|VPWR \$366 CLK|X
+ A|A_N|B|D|DOUT0|DOUT7|PH_B6|PH_B9|Q|S|VPB|VPWR pfet L=0.15U W=1U AS=0.135P
+ AD=0.26P PS=1.27U PD=2.52U
* device instance $964 r0 *1 40.655,-116.335 pfet
M$964 \$338 B|D|PH_B0|Q|S \$321 A|A_N|B|D|DOUT0|DOUT7|PH_B6|PH_B9|Q|S|VPB|VPWR
+ pfet L=0.15U W=0.42U AS=0.1092P AD=0.0441P PS=1.36U PD=0.63U
* device instance $965 r0 *1 41.015,-116.335 pfet
M$965 \$338 A|B|D|PH_B1|Q|S A|A_N|B|D|DOUT0|DOUT7|PH_B6|PH_B9|Q|S|VPB|VPWR
+ A|A_N|B|D|DOUT0|DOUT7|PH_B6|PH_B9|Q|S|VPB|VPWR pfet L=0.15U W=0.42U
+ AS=0.14575P AD=0.0441P PS=1.335U PD=0.63U
* device instance $966 r0 *1 41.5,-116.625 pfet
M$966 C|X \$321 A|A_N|B|D|DOUT0|DOUT7|PH_B6|PH_B9|Q|S|VPB|VPWR
+ A|A_N|B|D|DOUT0|DOUT7|PH_B6|PH_B9|Q|S|VPB|VPWR pfet L=0.15U W=1U AS=0.14575P
+ AD=0.34P PS=1.335U PD=2.68U
* device instance $967 r0 *1 41.38,-112.945 pfet
M$967 \$397 C|X \$367 A|A_N|B|D|DOUT0|DOUT7|PH_B6|PH_B9|Q|S|VPB|VPWR pfet
+ L=0.15U W=0.42U AS=0.1092P AD=0.0441P PS=1.36U PD=0.63U
* device instance $968 r0 *1 41.74,-112.945 pfet
M$968 \$398 B|X$1 \$397 A|A_N|B|D|DOUT0|DOUT7|PH_B6|PH_B9|Q|S|VPB|VPWR pfet
+ L=0.15U W=0.42U AS=0.0441P AD=0.0693P PS=0.63U PD=0.75U
* device instance $969 r0 *1 42.22,-112.945 pfet
M$969 A|A_N|B|D|DOUT0|DOUT7|PH_B6|PH_B9|Q|S|VPB|VPWR A|X$19 \$398
+ A|A_N|B|D|DOUT0|DOUT7|PH_B6|PH_B9|Q|S|VPB|VPWR pfet L=0.15U W=0.42U
+ AS=0.0693P AD=0.14825P PS=0.75U PD=1.34U
* device instance $970 r0 *1 42.71,-112.655 pfet
M$970 B|X \$367 A|A_N|B|D|DOUT0|DOUT7|PH_B6|PH_B9|Q|S|VPB|VPWR
+ A|A_N|B|D|DOUT0|DOUT7|PH_B6|PH_B9|Q|S|VPB|VPWR pfet L=0.15U W=1U AS=0.14825P
+ AD=0.28P PS=1.34U PD=2.56U
* device instance $971 r0 *1 48.55,-112.575 pfet
M$971 \$373 \$372 A|A_N|B|D|DOUT0|DOUT7|PH_B6|PH_B9|Q|S|VPB|VPWR
+ A|A_N|B|D|DOUT0|DOUT7|PH_B6|PH_B9|Q|S|VPB|VPWR pfet L=0.15U W=0.84U
+ AS=0.2184P AD=0.12915P PS=2.2U PD=1.185U
* device instance $972 r0 *1 49.045,-112.365 pfet
M$972 \$374 \$369 \$373 A|A_N|B|D|DOUT0|DOUT7|PH_B6|PH_B9|Q|S|VPB|VPWR pfet
+ L=0.15U W=0.42U AS=0.12915P AD=0.0588P PS=1.185U PD=0.7U
* device instance $973 r0 *1 49.475,-112.365 pfet
M$973 \$399 \$370 \$374 A|A_N|B|D|DOUT0|DOUT7|PH_B6|PH_B9|Q|S|VPB|VPWR pfet
+ L=0.15U W=0.42U AS=0.0588P AD=0.0567P PS=0.7U PD=0.69U
* device instance $974 r0 *1 49.895,-112.365 pfet
M$974 A|A_N|B|D|DOUT0|DOUT7|PH_B6|PH_B9|Q|S|VPB|VPWR \$375 \$399
+ A|A_N|B|D|DOUT0|DOUT7|PH_B6|PH_B9|Q|S|VPB|VPWR pfet L=0.15U W=0.42U
+ AS=0.0567P AD=0.0819P PS=0.69U PD=0.81U
* device instance $975 r0 *1 50.435,-112.365 pfet
M$975 \$375 RESET_B|RST_B|SAMPLE A|A_N|B|D|DOUT0|DOUT7|PH_B6|PH_B9|Q|S|VPB|VPWR
+ A|A_N|B|D|DOUT0|DOUT7|PH_B6|PH_B9|Q|S|VPB|VPWR pfet L=0.15U W=0.42U
+ AS=0.0819P AD=0.0567P PS=0.81U PD=0.69U
* device instance $976 r0 *1 50.855,-112.365 pfet
M$976 A|A_N|B|D|DOUT0|DOUT7|PH_B6|PH_B9|Q|S|VPB|VPWR \$374 \$375
+ A|A_N|B|D|DOUT0|DOUT7|PH_B6|PH_B9|Q|S|VPB|VPWR pfet L=0.15U W=0.42U
+ AS=0.0567P AD=0.1134P PS=0.69U PD=1.38U
* device instance $977 r0 *1 51.93,-112.655 pfet
M$977 A0|DOUT1|Q \$375 A|A_N|B|D|DOUT0|DOUT7|PH_B6|PH_B9|Q|S|VPB|VPWR
+ A|A_N|B|D|DOUT0|DOUT7|PH_B6|PH_B9|Q|S|VPB|VPWR pfet L=0.15U W=1U AS=0.3012P
+ AD=0.26P PS=2.66U PD=2.52U
* device instance $978 r0 *1 52.155,-116.335 pfet
M$978 \$341 A|B|D|PH_B9|Q|S \$326
+ A|A_N|B|D|DOUT0|DOUT7|PH_B6|PH_B9|Q|S|VPB|VPWR pfet L=0.15U W=0.42U
+ AS=0.1092P AD=0.0441P PS=1.36U PD=0.63U
* device instance $979 r0 *1 52.515,-116.335 pfet
M$979 \$341 A|X$18 A|A_N|B|D|DOUT0|DOUT7|PH_B6|PH_B9|Q|S|VPB|VPWR
+ A|A_N|B|D|DOUT0|DOUT7|PH_B6|PH_B9|Q|S|VPB|VPWR pfet L=0.15U W=0.42U
+ AS=0.14575P AD=0.0441P PS=1.335U PD=0.63U
* device instance $980 r0 *1 53,-116.625 pfet
M$980 A|X$14 \$326 A|A_N|B|D|DOUT0|DOUT7|PH_B6|PH_B9|Q|S|VPB|VPWR
+ A|A_N|B|D|DOUT0|DOUT7|PH_B6|PH_B9|Q|S|VPB|VPWR pfet L=0.15U W=1U AS=0.14575P
+ AD=0.34P PS=1.335U PD=2.68U
* device instance $981 r0 *1 54.71,-116.775 pfet
M$981 A|A_N|B|D|DOUT0|DOUT7|PH_B6|PH_B9|Q|S|VPB|VPWR CLK|X \$328
+ A|A_N|B|D|DOUT0|DOUT7|PH_B6|PH_B9|Q|S|VPB|VPWR pfet L=0.15U W=0.64U
+ AS=0.1664P AD=0.0864P PS=1.8U PD=0.91U
* device instance $982 r0 *1 55.13,-116.775 pfet
M$982 \$329 \$328 A|A_N|B|D|DOUT0|DOUT7|PH_B6|PH_B9|Q|S|VPB|VPWR
+ A|A_N|B|D|DOUT0|DOUT7|PH_B6|PH_B9|Q|S|VPB|VPWR pfet L=0.15U W=0.64U
+ AS=0.0864P AD=0.1664P PS=0.91U PD=1.8U
* device instance $983 r0 *1 57.095,-112.56 pfet
M$983 \$394 B|D|PH_B8|Q|S A|A_N|B|D|DOUT0|DOUT7|PH_B6|PH_B9|Q|S|VPB|VPWR
+ A|A_N|B|D|DOUT0|DOUT7|PH_B6|PH_B9|Q|S|VPB|VPWR pfet L=0.15U W=0.42U
+ AS=0.15835P AD=0.07665P PS=1.395U PD=0.785U
* device instance $984 r0 *1 57.61,-112.56 pfet
M$984 \$376 A0|DOUT8|Q \$394 A|A_N|B|D|DOUT0|DOUT7|PH_B6|PH_B9|Q|S|VPB|VPWR
+ pfet L=0.15U W=0.42U AS=0.07665P AD=0.1932P PS=0.785U PD=1.34U
* device instance $985 r0 *1 58.68,-112.56 pfet
M$985 \$393 A1|Y \$376 A|A_N|B|D|DOUT0|DOUT7|PH_B6|PH_B9|Q|S|VPB|VPWR pfet
+ L=0.15U W=0.42U AS=0.1932P AD=0.0441P PS=1.34U PD=0.63U
* device instance $986 r0 *1 59.04,-112.56 pfet
M$986 A|A_N|B|D|DOUT0|DOUT7|PH_B6|PH_B9|Q|S|VPB|VPWR \$377 \$393
+ A|A_N|B|D|DOUT0|DOUT7|PH_B6|PH_B9|Q|S|VPB|VPWR pfet L=0.15U W=0.42U
+ AS=0.0441P AD=0.0693P PS=0.63U PD=0.75U
* device instance $987 r0 *1 59.52,-112.56 pfet
M$987 \$377 B|D|PH_B8|Q|S A|A_N|B|D|DOUT0|DOUT7|PH_B6|PH_B9|Q|S|VPB|VPWR
+ A|A_N|B|D|DOUT0|DOUT7|PH_B6|PH_B9|Q|S|VPB|VPWR pfet L=0.15U W=0.42U
+ AS=0.0693P AD=0.1176P PS=0.75U PD=1.4U
* device instance $988 r0 *1 56.55,-112.655 pfet
M$988 A|A_N|B|D|DOUT0|DOUT7|PH_B6|PH_B9|Q|S|VPB|VPWR \$376 A|X$18
+ A|A_N|B|D|DOUT0|DOUT7|PH_B6|PH_B9|Q|S|VPB|VPWR pfet L=0.15U W=1U AS=0.26P
+ AD=0.15835P PS=2.52U PD=1.395U
* device instance $989 r0 *1 23.89,-112.505 pfet
M$989 A|A_N|B|D|DOUT0|DOUT7|PH_B6|PH_B9|Q|S|VPB|VPWR CLK|X \$354
+ A|A_N|B|D|DOUT0|DOUT7|PH_B6|PH_B9|Q|S|VPB|VPWR pfet L=0.15U W=0.64U
+ AS=0.1664P AD=0.0864P PS=1.8U PD=0.91U
* device instance $990 r0 *1 24.31,-112.505 pfet
M$990 \$355 \$354 A|A_N|B|D|DOUT0|DOUT7|PH_B6|PH_B9|Q|S|VPB|VPWR
+ A|A_N|B|D|DOUT0|DOUT7|PH_B6|PH_B9|Q|S|VPB|VPWR pfet L=0.15U W=0.64U
+ AS=0.0864P AD=0.1664P PS=0.91U PD=1.8U
* device instance $991 r0 *1 25.645,-112.365 pfet
M$991 \$357 D|X$9 A|A_N|B|D|DOUT0|DOUT7|PH_B6|PH_B9|Q|S|VPB|VPWR
+ A|A_N|B|D|DOUT0|DOUT7|PH_B6|PH_B9|Q|S|VPB|VPWR pfet L=0.15U W=0.42U
+ AS=0.1092P AD=0.0651P PS=1.36U PD=0.73U
* device instance $992 r0 *1 26.105,-112.365 pfet
M$992 \$358 \$355 \$357 A|A_N|B|D|DOUT0|DOUT7|PH_B6|PH_B9|Q|S|VPB|VPWR pfet
+ L=0.15U W=0.42U AS=0.0651P AD=0.07245P PS=0.73U PD=0.765U
* device instance $993 r0 *1 26.6,-112.365 pfet
M$993 \$390 \$354 \$358 A|A_N|B|D|DOUT0|DOUT7|PH_B6|PH_B9|Q|S|VPB|VPWR pfet
+ L=0.15U W=0.42U AS=0.07245P AD=0.1155P PS=0.765U PD=0.97U
* device instance $994 r0 *1 27.3,-112.365 pfet
M$994 A|A_N|B|D|DOUT0|DOUT7|PH_B6|PH_B9|Q|S|VPB|VPWR \$359 \$390
+ A|A_N|B|D|DOUT0|DOUT7|PH_B6|PH_B9|Q|S|VPB|VPWR pfet L=0.15U W=0.42U
+ AS=0.1155P AD=0.07035P PS=0.97U PD=0.755U
* device instance $995 r0 *1 27.785,-112.365 pfet
M$995 \$390 RESET_B|RST_B|SAMPLE A|A_N|B|D|DOUT0|DOUT7|PH_B6|PH_B9|Q|S|VPB|VPWR
+ A|A_N|B|D|DOUT0|DOUT7|PH_B6|PH_B9|Q|S|VPB|VPWR pfet L=0.15U W=0.42U
+ AS=0.07035P AD=0.1092P PS=0.755U PD=1.36U
* device instance $996 r0 *1 43.67,-112.505 pfet
M$996 A|A_N|B|D|DOUT0|DOUT7|PH_B6|PH_B9|Q|S|VPB|VPWR CLK|X \$369
+ A|A_N|B|D|DOUT0|DOUT7|PH_B6|PH_B9|Q|S|VPB|VPWR pfet L=0.15U W=0.64U
+ AS=0.1664P AD=0.0864P PS=1.8U PD=0.91U
* device instance $997 r0 *1 44.09,-112.505 pfet
M$997 \$370 \$369 A|A_N|B|D|DOUT0|DOUT7|PH_B6|PH_B9|Q|S|VPB|VPWR
+ A|A_N|B|D|DOUT0|DOUT7|PH_B6|PH_B9|Q|S|VPB|VPWR pfet L=0.15U W=0.64U
+ AS=0.0864P AD=0.1664P PS=0.91U PD=1.8U
* device instance $998 r0 *1 45.425,-112.365 pfet
M$998 \$371 D|X$6 A|A_N|B|D|DOUT0|DOUT7|PH_B6|PH_B9|Q|S|VPB|VPWR
+ A|A_N|B|D|DOUT0|DOUT7|PH_B6|PH_B9|Q|S|VPB|VPWR pfet L=0.15U W=0.42U
+ AS=0.1092P AD=0.0651P PS=1.36U PD=0.73U
* device instance $999 r0 *1 45.885,-112.365 pfet
M$999 \$372 \$370 \$371 A|A_N|B|D|DOUT0|DOUT7|PH_B6|PH_B9|Q|S|VPB|VPWR pfet
+ L=0.15U W=0.42U AS=0.0651P AD=0.07245P PS=0.73U PD=0.765U
* device instance $1000 r0 *1 46.38,-112.365 pfet
M$1000 \$392 \$369 \$372 A|A_N|B|D|DOUT0|DOUT7|PH_B6|PH_B9|Q|S|VPB|VPWR pfet
+ L=0.15U W=0.42U AS=0.07245P AD=0.1155P PS=0.765U PD=0.97U
* device instance $1001 r0 *1 47.08,-112.365 pfet
M$1001 A|A_N|B|D|DOUT0|DOUT7|PH_B6|PH_B9|Q|S|VPB|VPWR \$373 \$392
+ A|A_N|B|D|DOUT0|DOUT7|PH_B6|PH_B9|Q|S|VPB|VPWR pfet L=0.15U W=0.42U
+ AS=0.1155P AD=0.07035P PS=0.97U PD=0.755U
* device instance $1002 r0 *1 47.565,-112.365 pfet
M$1002 \$392 RESET_B|RST_B|SAMPLE
+ A|A_N|B|D|DOUT0|DOUT7|PH_B6|PH_B9|Q|S|VPB|VPWR
+ A|A_N|B|D|DOUT0|DOUT7|PH_B6|PH_B9|Q|S|VPB|VPWR pfet L=0.15U W=0.42U
+ AS=0.07035P AD=0.1092P PS=0.755U PD=1.36U
* device instance $1003 r0 *1 26.19,-107.065 pfet
M$1003 A|A_N|B|D|DOUT0|DOUT7|PH_B6|PH_B9|Q|S|VPB|VPWR CLK|X \$432
+ A|A_N|B|D|DOUT0|DOUT7|PH_B6|PH_B9|Q|S|VPB|VPWR pfet L=0.15U W=0.64U
+ AS=0.1664P AD=0.0864P PS=1.8U PD=0.91U
* device instance $1004 r0 *1 26.61,-107.065 pfet
M$1004 \$433 \$432 A|A_N|B|D|DOUT0|DOUT7|PH_B6|PH_B9|Q|S|VPB|VPWR
+ A|A_N|B|D|DOUT0|DOUT7|PH_B6|PH_B9|Q|S|VPB|VPWR pfet L=0.15U W=0.64U
+ AS=0.0864P AD=0.1664P PS=0.91U PD=1.8U
* device instance $1005 r0 *1 31.07,-107.135 pfet
M$1005 \$437 \$435 A|A_N|B|D|DOUT0|DOUT7|PH_B6|PH_B9|Q|S|VPB|VPWR
+ A|A_N|B|D|DOUT0|DOUT7|PH_B6|PH_B9|Q|S|VPB|VPWR pfet L=0.15U W=0.84U
+ AS=0.2184P AD=0.12915P PS=2.2U PD=1.185U
* device instance $1006 r0 *1 31.565,-106.925 pfet
M$1006 \$438 \$432 \$437 A|A_N|B|D|DOUT0|DOUT7|PH_B6|PH_B9|Q|S|VPB|VPWR pfet
+ L=0.15U W=0.42U AS=0.12915P AD=0.0588P PS=1.185U PD=0.7U
* device instance $1007 r0 *1 31.995,-106.925 pfet
M$1007 \$461 \$433 \$438 A|A_N|B|D|DOUT0|DOUT7|PH_B6|PH_B9|Q|S|VPB|VPWR pfet
+ L=0.15U W=0.42U AS=0.0588P AD=0.0567P PS=0.7U PD=0.69U
* device instance $1008 r0 *1 32.415,-106.925 pfet
M$1008 A|A_N|B|D|DOUT0|DOUT7|PH_B6|PH_B9|Q|S|VPB|VPWR \$439 \$461
+ A|A_N|B|D|DOUT0|DOUT7|PH_B6|PH_B9|Q|S|VPB|VPWR pfet L=0.15U W=0.42U
+ AS=0.0567P AD=0.0819P PS=0.69U PD=0.81U
* device instance $1009 r0 *1 32.955,-106.925 pfet
M$1009 \$439 RESET_B|RST_B|SAMPLE
+ A|A_N|B|D|DOUT0|DOUT7|PH_B6|PH_B9|Q|S|VPB|VPWR
+ A|A_N|B|D|DOUT0|DOUT7|PH_B6|PH_B9|Q|S|VPB|VPWR pfet L=0.15U W=0.42U
+ AS=0.0819P AD=0.0567P PS=0.81U PD=0.69U
* device instance $1010 r0 *1 33.375,-106.925 pfet
M$1010 A|A_N|B|D|DOUT0|DOUT7|PH_B6|PH_B9|Q|S|VPB|VPWR \$438 \$439
+ A|A_N|B|D|DOUT0|DOUT7|PH_B6|PH_B9|Q|S|VPB|VPWR pfet L=0.15U W=0.42U
+ AS=0.0567P AD=0.1134P PS=0.69U PD=1.38U
* device instance $1011 r0 *1 32.67,-111.185 pfet
M$1011 \$401 A0|B|DOUT9|Q A|A_N|B|D|DOUT0|DOUT7|PH_B6|PH_B9|Q|S|VPB|VPWR
+ A|A_N|B|D|DOUT0|DOUT7|PH_B6|PH_B9|Q|S|VPB|VPWR pfet L=0.15U W=1U AS=0.3P
+ AD=0.135P PS=2.6U PD=1.27U
* device instance $1012 r0 *1 33.09,-111.185 pfet
M$1012 A|A_N|B|D|DOUT0|DOUT7|PH_B6|PH_B9|Q|S|VPB|VPWR A|A1|COMP_OUT \$401
+ A|A_N|B|D|DOUT0|DOUT7|PH_B6|PH_B9|Q|S|VPB|VPWR pfet L=0.15U W=1U AS=0.135P
+ AD=0.365P PS=1.27U PD=1.73U
* device instance $1013 r0 *1 33.97,-111.185 pfet
M$1013 \$418 A|A1|COMP_OUT A|A_N|B|D|DOUT0|DOUT7|PH_B6|PH_B9|Q|S|VPB|VPWR
+ A|A_N|B|D|DOUT0|DOUT7|PH_B6|PH_B9|Q|S|VPB|VPWR pfet L=0.15U W=1U AS=0.365P
+ AD=0.105P PS=1.73U PD=1.21U
* device instance $1014 r0 *1 34.33,-111.185 pfet
M$1014 A1|Y A0|B|DOUT9|Q \$418 A|A_N|B|D|DOUT0|DOUT7|PH_B6|PH_B9|Q|S|VPB|VPWR
+ pfet L=0.15U W=1U AS=0.105P AD=0.165P PS=1.21U PD=1.33U
* device instance $1015 r0 *1 34.81,-111.185 pfet
M$1015 A|A_N|B|D|DOUT0|DOUT7|PH_B6|PH_B9|Q|S|VPB|VPWR \$401 A1|Y
+ A|A_N|B|D|DOUT0|DOUT7|PH_B6|PH_B9|Q|S|VPB|VPWR pfet L=0.15U W=1U AS=0.165P
+ AD=0.36P PS=1.33U PD=2.72U
* device instance $1016 r0 *1 34.45,-107.215 pfet
M$1016 C|PH_EOC|Q \$439 A|A_N|B|D|DOUT0|DOUT7|PH_B6|PH_B9|Q|S|VPB|VPWR
+ A|A_N|B|D|DOUT0|DOUT7|PH_B6|PH_B9|Q|S|VPB|VPWR pfet L=0.15U W=1U AS=0.3012P
+ AD=0.26P PS=2.66U PD=2.52U
* device instance $1017 r0 *1 37.7,-110.895 pfet
M$1017 \$419 C|PH_EOC|Q \$404 A|A_N|B|D|DOUT0|DOUT7|PH_B6|PH_B9|Q|S|VPB|VPWR
+ pfet L=0.15U W=0.42U AS=0.1092P AD=0.0441P PS=1.36U PD=0.63U
* device instance $1018 r0 *1 38.06,-110.895 pfet
M$1018 \$420 B|D|PH_B0|Q|S \$419 A|A_N|B|D|DOUT0|DOUT7|PH_B6|PH_B9|Q|S|VPB|VPWR
+ pfet L=0.15U W=0.42U AS=0.0441P AD=0.0693P PS=0.63U PD=0.75U
* device instance $1019 r0 *1 38.54,-110.895 pfet
M$1019 \$420 A|B|D|PH_B1|Q|S A|A_N|B|D|DOUT0|DOUT7|PH_B6|PH_B9|Q|S|VPB|VPWR
+ A|A_N|B|D|DOUT0|DOUT7|PH_B6|PH_B9|Q|S|VPB|VPWR pfet L=0.15U W=0.42U
+ AS=0.14825P AD=0.0693P PS=1.34U PD=0.75U
* device instance $1020 r0 *1 39.03,-111.185 pfet
M$1020 C|X$1 \$404 A|A_N|B|D|DOUT0|DOUT7|PH_B6|PH_B9|Q|S|VPB|VPWR
+ A|A_N|B|D|DOUT0|DOUT7|PH_B6|PH_B9|Q|S|VPB|VPWR pfet L=0.15U W=1U AS=0.14825P
+ AD=0.28P PS=1.34U PD=2.56U
* device instance $1021 r0 *1 38.61,-107.505 pfet
M$1021 \$453 B|D|PH_B2|Q|S \$440 A|A_N|B|D|DOUT0|DOUT7|PH_B6|PH_B9|Q|S|VPB|VPWR
+ pfet L=0.15U W=0.42U AS=0.1092P AD=0.0693P PS=1.36U PD=0.75U
* device instance $1022 r0 *1 39.09,-107.505 pfet
M$1022 \$454 B|C|D|PH_B3|Q|S \$453
+ A|A_N|B|D|DOUT0|DOUT7|PH_B6|PH_B9|Q|S|VPB|VPWR pfet L=0.15U W=0.42U
+ AS=0.0693P AD=0.0441P PS=0.75U PD=0.63U
* device instance $1023 r0 *1 39.45,-107.505 pfet
M$1023 \$455 B|D|PH_B4|Q|S \$454 A|A_N|B|D|DOUT0|DOUT7|PH_B6|PH_B9|Q|S|VPB|VPWR
+ pfet L=0.15U W=0.42U AS=0.0441P AD=0.0693P PS=0.63U PD=0.75U
* device instance $1024 r0 *1 39.93,-107.505 pfet
M$1024 A|A_N|B|D|DOUT0|DOUT7|PH_B6|PH_B9|Q|S|VPB|VPWR A|B|D|PH_B5|Q|S \$455
+ A|A_N|B|D|DOUT0|DOUT7|PH_B6|PH_B9|Q|S|VPB|VPWR pfet L=0.15U W=0.42U
+ AS=0.0693P AD=0.14825P PS=0.75U PD=1.34U
* device instance $1025 r0 *1 40.42,-107.215 pfet
M$1025 B|X$1 \$440 A|A_N|B|D|DOUT0|DOUT7|PH_B6|PH_B9|Q|S|VPB|VPWR
+ A|A_N|B|D|DOUT0|DOUT7|PH_B6|PH_B9|Q|S|VPB|VPWR pfet L=0.15U W=1U AS=0.14825P
+ AD=0.27P PS=1.34U PD=2.54U
* device instance $1026 r0 *1 40.92,-110.895 pfet
M$1026 \$421 C|X$1 \$406 A|A_N|B|D|DOUT0|DOUT7|PH_B6|PH_B9|Q|S|VPB|VPWR pfet
+ L=0.15U W=0.42U AS=0.1092P AD=0.0441P PS=1.36U PD=0.63U
* device instance $1027 r0 *1 41.28,-110.895 pfet
M$1027 \$422 B|X$1 \$421 A|A_N|B|D|DOUT0|DOUT7|PH_B6|PH_B9|Q|S|VPB|VPWR pfet
+ L=0.15U W=0.42U AS=0.0441P AD=0.0693P PS=0.63U PD=0.75U
* device instance $1028 r0 *1 41.76,-110.895 pfet
M$1028 \$422 A|X$19 A|A_N|B|D|DOUT0|DOUT7|PH_B6|PH_B9|Q|S|VPB|VPWR
+ A|A_N|B|D|DOUT0|DOUT7|PH_B6|PH_B9|Q|S|VPB|VPWR pfet L=0.15U W=0.42U
+ AS=0.14825P AD=0.0693P PS=1.34U PD=0.75U
* device instance $1029 r0 *1 42.25,-111.185 pfet
M$1029 A|BUSY|X \$406 A|A_N|B|D|DOUT0|DOUT7|PH_B6|PH_B9|Q|S|VPB|VPWR
+ A|A_N|B|D|DOUT0|DOUT7|PH_B6|PH_B9|Q|S|VPB|VPWR pfet L=0.15U W=1U AS=0.14825P
+ AD=0.28P PS=1.34U PD=2.56U
* device instance $1030 r0 *1 44.335,-111.185 pfet
M$1030 D|PH_SAMPLE|Y A|BUSY|X A|A_N|B|D|DOUT0|DOUT7|PH_B6|PH_B9|Q|S|VPB|VPWR
+ A|A_N|B|D|DOUT0|DOUT7|PH_B6|PH_B9|Q|S|VPB|VPWR pfet L=0.15U W=1U AS=0.26P
+ AD=0.26P PS=2.52U PD=2.52U
* device instance $1031 r0 *1 51.95,-110.895 pfet
M$1031 \$423 A|A_N|B|D|DOUT0|DOUT7|PH_B6|PH_B9|Q|S|VPB|VPWR \$409
+ A|A_N|B|D|DOUT0|DOUT7|PH_B6|PH_B9|Q|S|VPB|VPWR pfet L=0.15U W=0.42U
+ AS=0.1092P AD=0.0693P PS=1.36U PD=0.75U
* device instance $1032 r0 *1 52.43,-110.895 pfet
M$1032 \$424 B|C|D|PH_B7|Q|S \$423
+ A|A_N|B|D|DOUT0|DOUT7|PH_B6|PH_B9|Q|S|VPB|VPWR pfet L=0.15U W=0.42U
+ AS=0.0693P AD=0.0441P PS=0.75U PD=0.63U
* device instance $1033 r0 *1 52.79,-110.895 pfet
M$1033 \$425 B|D|PH_B8|Q|S \$424 A|A_N|B|D|DOUT0|DOUT7|PH_B6|PH_B9|Q|S|VPB|VPWR
+ pfet L=0.15U W=0.42U AS=0.0441P AD=0.0693P PS=0.63U PD=0.75U
* device instance $1034 r0 *1 53.27,-110.895 pfet
M$1034 \$425 A|B|D|PH_B9|Q|S A|A_N|B|D|DOUT0|DOUT7|PH_B6|PH_B9|Q|S|VPB|VPWR
+ A|A_N|B|D|DOUT0|DOUT7|PH_B6|PH_B9|Q|S|VPB|VPWR pfet L=0.15U W=0.42U
+ AS=0.14825P AD=0.0693P PS=1.34U PD=0.75U
* device instance $1035 r0 *1 53.76,-111.185 pfet
M$1035 A|X$19 \$409 A|A_N|B|D|DOUT0|DOUT7|PH_B6|PH_B9|Q|S|VPB|VPWR
+ A|A_N|B|D|DOUT0|DOUT7|PH_B6|PH_B9|Q|S|VPB|VPWR pfet L=0.15U W=1U AS=0.14825P
+ AD=0.27P PS=1.34U PD=2.54U
* device instance $1036 r0 *1 52.41,-107.065 pfet
M$1036 A|A_N|B|D|DOUT0|DOUT7|PH_B6|PH_B9|Q|S|VPB|VPWR CLK|X \$441
+ A|A_N|B|D|DOUT0|DOUT7|PH_B6|PH_B9|Q|S|VPB|VPWR pfet L=0.15U W=0.64U
+ AS=0.1664P AD=0.0864P PS=1.8U PD=0.91U
* device instance $1037 r0 *1 52.83,-107.065 pfet
M$1037 \$442 \$441 A|A_N|B|D|DOUT0|DOUT7|PH_B6|PH_B9|Q|S|VPB|VPWR
+ A|A_N|B|D|DOUT0|DOUT7|PH_B6|PH_B9|Q|S|VPB|VPWR pfet L=0.15U W=0.64U
+ AS=0.0864P AD=0.1664P PS=0.91U PD=1.8U
* device instance $1038 r0 *1 56.55,-111.335 pfet
M$1038 A|A_N|B|D|DOUT0|DOUT7|PH_B6|PH_B9|Q|S|VPB|VPWR CLK|X \$410
+ A|A_N|B|D|DOUT0|DOUT7|PH_B6|PH_B9|Q|S|VPB|VPWR pfet L=0.15U W=0.64U
+ AS=0.1664P AD=0.0864P PS=1.8U PD=0.91U
* device instance $1039 r0 *1 56.97,-111.335 pfet
M$1039 \$411 \$410 A|A_N|B|D|DOUT0|DOUT7|PH_B6|PH_B9|Q|S|VPB|VPWR
+ A|A_N|B|D|DOUT0|DOUT7|PH_B6|PH_B9|Q|S|VPB|VPWR pfet L=0.15U W=0.64U
+ AS=0.0864P AD=0.1664P PS=0.91U PD=1.8U
* device instance $1040 r0 *1 57.29,-107.135 pfet
M$1040 \$446 \$444 A|A_N|B|D|DOUT0|DOUT7|PH_B6|PH_B9|Q|S|VPB|VPWR
+ A|A_N|B|D|DOUT0|DOUT7|PH_B6|PH_B9|Q|S|VPB|VPWR pfet L=0.15U W=0.84U
+ AS=0.2184P AD=0.12915P PS=2.2U PD=1.185U
* device instance $1041 r0 *1 57.785,-106.925 pfet
M$1041 \$447 \$441 \$446 A|A_N|B|D|DOUT0|DOUT7|PH_B6|PH_B9|Q|S|VPB|VPWR pfet
+ L=0.15U W=0.42U AS=0.12915P AD=0.0588P PS=1.185U PD=0.7U
* device instance $1042 r0 *1 58.215,-106.925 pfet
M$1042 \$460 \$442 \$447 A|A_N|B|D|DOUT0|DOUT7|PH_B6|PH_B9|Q|S|VPB|VPWR pfet
+ L=0.15U W=0.42U AS=0.0588P AD=0.0567P PS=0.7U PD=0.69U
* device instance $1043 r0 *1 58.635,-106.925 pfet
M$1043 A|A_N|B|D|DOUT0|DOUT7|PH_B6|PH_B9|Q|S|VPB|VPWR \$448 \$460
+ A|A_N|B|D|DOUT0|DOUT7|PH_B6|PH_B9|Q|S|VPB|VPWR pfet L=0.15U W=0.42U
+ AS=0.0567P AD=0.0819P PS=0.69U PD=0.81U
* device instance $1044 r0 *1 59.175,-106.925 pfet
M$1044 \$448 RESET_B|RST_B|SAMPLE
+ A|A_N|B|D|DOUT0|DOUT7|PH_B6|PH_B9|Q|S|VPB|VPWR
+ A|A_N|B|D|DOUT0|DOUT7|PH_B6|PH_B9|Q|S|VPB|VPWR pfet L=0.15U W=0.42U
+ AS=0.0819P AD=0.0567P PS=0.81U PD=0.69U
* device instance $1045 r0 *1 59.595,-106.925 pfet
M$1045 A|A_N|B|D|DOUT0|DOUT7|PH_B6|PH_B9|Q|S|VPB|VPWR \$447 \$448
+ A|A_N|B|D|DOUT0|DOUT7|PH_B6|PH_B9|Q|S|VPB|VPWR pfet L=0.15U W=0.42U
+ AS=0.0567P AD=0.1134P PS=0.69U PD=1.38U
* device instance $1046 r0 *1 58.305,-111.475 pfet
M$1046 \$412 B|D|PH_B8|Q|S A|A_N|B|D|DOUT0|DOUT7|PH_B6|PH_B9|Q|S|VPB|VPWR
+ A|A_N|B|D|DOUT0|DOUT7|PH_B6|PH_B9|Q|S|VPB|VPWR pfet L=0.15U W=0.42U
+ AS=0.1092P AD=0.0651P PS=1.36U PD=0.73U
* device instance $1047 r0 *1 58.765,-111.475 pfet
M$1047 \$413 \$411 \$412 A|A_N|B|D|DOUT0|DOUT7|PH_B6|PH_B9|Q|S|VPB|VPWR pfet
+ L=0.15U W=0.42U AS=0.0651P AD=0.07245P PS=0.73U PD=0.765U
* device instance $1048 r0 *1 59.26,-111.475 pfet
M$1048 \$414 \$410 \$413 A|A_N|B|D|DOUT0|DOUT7|PH_B6|PH_B9|Q|S|VPB|VPWR pfet
+ L=0.15U W=0.42U AS=0.07245P AD=0.1155P PS=0.765U PD=0.97U
* device instance $1049 r0 *1 59.96,-111.475 pfet
M$1049 A|A_N|B|D|DOUT0|DOUT7|PH_B6|PH_B9|Q|S|VPB|VPWR \$415 \$414
+ A|A_N|B|D|DOUT0|DOUT7|PH_B6|PH_B9|Q|S|VPB|VPWR pfet L=0.15U W=0.42U
+ AS=0.1155P AD=0.07035P PS=0.97U PD=0.755U
* device instance $1050 r0 *1 60.445,-111.475 pfet
M$1050 \$414 RESET_B|RST_B|SAMPLE
+ A|A_N|B|D|DOUT0|DOUT7|PH_B6|PH_B9|Q|S|VPB|VPWR
+ A|A_N|B|D|DOUT0|DOUT7|PH_B6|PH_B9|Q|S|VPB|VPWR pfet L=0.15U W=0.42U
+ AS=0.07035P AD=0.1092P PS=0.755U PD=1.36U
* device instance $1051 r0 *1 60.67,-107.215 pfet
M$1051 B|D|PH_B8|Q|S \$448 A|A_N|B|D|DOUT0|DOUT7|PH_B6|PH_B9|Q|S|VPB|VPWR
+ A|A_N|B|D|DOUT0|DOUT7|PH_B6|PH_B9|Q|S|VPB|VPWR pfet L=0.15U W=1U AS=0.3012P
+ AD=0.26P PS=2.66U PD=2.52U
* device instance $1052 r0 *1 61.925,-111.475 pfet
M$1052 \$416 \$410 \$415 A|A_N|B|D|DOUT0|DOUT7|PH_B6|PH_B9|Q|S|VPB|VPWR pfet
+ L=0.15U W=0.42U AS=0.12915P AD=0.0588P PS=1.185U PD=0.7U
* device instance $1053 r0 *1 62.355,-111.475 pfet
M$1053 \$426 \$411 \$416 A|A_N|B|D|DOUT0|DOUT7|PH_B6|PH_B9|Q|S|VPB|VPWR pfet
+ L=0.15U W=0.42U AS=0.0588P AD=0.0567P PS=0.7U PD=0.69U
* device instance $1054 r0 *1 62.775,-111.475 pfet
M$1054 A|A_N|B|D|DOUT0|DOUT7|PH_B6|PH_B9|Q|S|VPB|VPWR \$417 \$426
+ A|A_N|B|D|DOUT0|DOUT7|PH_B6|PH_B9|Q|S|VPB|VPWR pfet L=0.15U W=0.42U
+ AS=0.0567P AD=0.0819P PS=0.69U PD=0.81U
* device instance $1055 r0 *1 63.315,-111.475 pfet
M$1055 \$417 RESET_B|RST_B|SAMPLE
+ A|A_N|B|D|DOUT0|DOUT7|PH_B6|PH_B9|Q|S|VPB|VPWR
+ A|A_N|B|D|DOUT0|DOUT7|PH_B6|PH_B9|Q|S|VPB|VPWR pfet L=0.15U W=0.42U
+ AS=0.0819P AD=0.0567P PS=0.81U PD=0.69U
* device instance $1056 r0 *1 63.735,-111.475 pfet
M$1056 A|A_N|B|D|DOUT0|DOUT7|PH_B6|PH_B9|Q|S|VPB|VPWR \$416 \$417
+ A|A_N|B|D|DOUT0|DOUT7|PH_B6|PH_B9|Q|S|VPB|VPWR pfet L=0.15U W=0.42U
+ AS=0.0567P AD=0.1134P PS=0.69U PD=1.38U
* device instance $1057 r0 *1 61.43,-111.265 pfet
M$1057 \$415 \$413 A|A_N|B|D|DOUT0|DOUT7|PH_B6|PH_B9|Q|S|VPB|VPWR
+ A|A_N|B|D|DOUT0|DOUT7|PH_B6|PH_B9|Q|S|VPB|VPWR pfet L=0.15U W=0.84U
+ AS=0.2184P AD=0.12915P PS=2.2U PD=1.185U
* device instance $1058 r0 *1 64.81,-111.185 pfet
M$1058 B|C|D|PH_B7|Q|S \$417 A|A_N|B|D|DOUT0|DOUT7|PH_B6|PH_B9|Q|S|VPB|VPWR
+ A|A_N|B|D|DOUT0|DOUT7|PH_B6|PH_B9|Q|S|VPB|VPWR pfet L=0.15U W=1U AS=0.3012P
+ AD=0.26P PS=2.66U PD=2.52U
* device instance $1059 r0 *1 27.945,-106.925 pfet
M$1059 \$434 B|D|PH_B0|Q|S A|A_N|B|D|DOUT0|DOUT7|PH_B6|PH_B9|Q|S|VPB|VPWR
+ A|A_N|B|D|DOUT0|DOUT7|PH_B6|PH_B9|Q|S|VPB|VPWR pfet L=0.15U W=0.42U
+ AS=0.1092P AD=0.0651P PS=1.36U PD=0.73U
* device instance $1060 r0 *1 28.405,-106.925 pfet
M$1060 \$435 \$433 \$434 A|A_N|B|D|DOUT0|DOUT7|PH_B6|PH_B9|Q|S|VPB|VPWR pfet
+ L=0.15U W=0.42U AS=0.0651P AD=0.07245P PS=0.73U PD=0.765U
* device instance $1061 r0 *1 28.9,-106.925 pfet
M$1061 \$436 \$432 \$435 A|A_N|B|D|DOUT0|DOUT7|PH_B6|PH_B9|Q|S|VPB|VPWR pfet
+ L=0.15U W=0.42U AS=0.07245P AD=0.1155P PS=0.765U PD=0.97U
* device instance $1062 r0 *1 29.6,-106.925 pfet
M$1062 A|A_N|B|D|DOUT0|DOUT7|PH_B6|PH_B9|Q|S|VPB|VPWR \$437 \$436
+ A|A_N|B|D|DOUT0|DOUT7|PH_B6|PH_B9|Q|S|VPB|VPWR pfet L=0.15U W=0.42U
+ AS=0.1155P AD=0.07035P PS=0.97U PD=0.755U
* device instance $1063 r0 *1 30.085,-106.925 pfet
M$1063 \$436 RESET_B|RST_B|SAMPLE
+ A|A_N|B|D|DOUT0|DOUT7|PH_B6|PH_B9|Q|S|VPB|VPWR
+ A|A_N|B|D|DOUT0|DOUT7|PH_B6|PH_B9|Q|S|VPB|VPWR pfet L=0.15U W=0.42U
+ AS=0.07035P AD=0.1092P PS=0.755U PD=1.36U
* device instance $1064 r0 *1 54.165,-106.925 pfet
M$1064 \$443 A|B|D|PH_B9|Q|S A|A_N|B|D|DOUT0|DOUT7|PH_B6|PH_B9|Q|S|VPB|VPWR
+ A|A_N|B|D|DOUT0|DOUT7|PH_B6|PH_B9|Q|S|VPB|VPWR pfet L=0.15U W=0.42U
+ AS=0.1092P AD=0.0651P PS=1.36U PD=0.73U
* device instance $1065 r0 *1 54.625,-106.925 pfet
M$1065 \$444 \$442 \$443 A|A_N|B|D|DOUT0|DOUT7|PH_B6|PH_B9|Q|S|VPB|VPWR pfet
+ L=0.15U W=0.42U AS=0.0651P AD=0.07245P PS=0.73U PD=0.765U
* device instance $1066 r0 *1 55.12,-106.925 pfet
M$1066 \$445 \$441 \$444 A|A_N|B|D|DOUT0|DOUT7|PH_B6|PH_B9|Q|S|VPB|VPWR pfet
+ L=0.15U W=0.42U AS=0.07245P AD=0.1155P PS=0.765U PD=0.97U
* device instance $1067 r0 *1 55.82,-106.925 pfet
M$1067 A|A_N|B|D|DOUT0|DOUT7|PH_B6|PH_B9|Q|S|VPB|VPWR \$446 \$445
+ A|A_N|B|D|DOUT0|DOUT7|PH_B6|PH_B9|Q|S|VPB|VPWR pfet L=0.15U W=0.42U
+ AS=0.1155P AD=0.07035P PS=0.97U PD=0.755U
* device instance $1068 r0 *1 56.305,-106.925 pfet
M$1068 \$445 RESET_B|RST_B|SAMPLE
+ A|A_N|B|D|DOUT0|DOUT7|PH_B6|PH_B9|Q|S|VPB|VPWR
+ A|A_N|B|D|DOUT0|DOUT7|PH_B6|PH_B9|Q|S|VPB|VPWR pfet L=0.15U W=0.42U
+ AS=0.07035P AD=0.1092P PS=0.755U PD=1.36U
* device instance $1069 r0 *1 98.065,-89.425 pfet
M$1069 \$510 B|Y \$489 A|A_N|B|D|DOUT0|DOUT7|PH_B6|PH_B9|Q|S|VPB|VPWR pfet
+ L=0.15U W=1U AS=0.26P AD=0.135P PS=2.52U PD=1.27U
* device instance $1070 r0 *1 98.485,-89.425 pfet
M$1070 A|A_N|B|D|DOUT0|DOUT7|PH_B6|PH_B9|Q|S|VPB|VPWR
+ A|B|BUSY|DOUT2|GND|VGND|VSS \$510
+ A|A_N|B|D|DOUT0|DOUT7|PH_B6|PH_B9|Q|S|VPB|VPWR pfet L=0.15U W=1U AS=0.135P
+ AD=0.135P PS=1.27U PD=1.27U
* device instance $1071 r0 *1 98.905,-89.425 pfet
M$1071 \$490 A|B|BUSY|DOUT2|GND|VGND|VSS
+ A|A_N|B|D|DOUT0|DOUT7|PH_B6|PH_B9|Q|S|VPB|VPWR
+ A|A_N|B|D|DOUT0|DOUT7|PH_B6|PH_B9|Q|S|VPB|VPWR pfet L=0.15U W=1U AS=0.135P
+ AD=0.135P PS=1.27U PD=1.27U
* device instance $1072 r0 *1 99.325,-89.425 pfet
M$1072 A|A_N|B|D|DOUT0|DOUT7|PH_B6|PH_B9|Q|S|VPB|VPWR B|Y \$490
+ A|A_N|B|D|DOUT0|DOUT7|PH_B6|PH_B9|Q|S|VPB|VPWR pfet L=0.15U W=1U AS=0.135P
+ AD=0.26P PS=1.27U PD=2.52U
* device instance $1073 r0 *1 98.985,-94.865 pfet
M$1073 \$470 B|Y \$462 A|A_N|B|D|DOUT0|DOUT7|PH_B6|PH_B9|Q|S|VPB|VPWR pfet
+ L=0.15U W=1U AS=0.26P AD=0.135P PS=2.52U PD=1.27U
* device instance $1074 r0 *1 99.405,-94.865 pfet
M$1074 A|A_N|B|D|DOUT0|DOUT7|PH_B6|PH_B9|Q|S|VPB|VPWR A|B|DOUT8 \$470
+ A|A_N|B|D|DOUT0|DOUT7|PH_B6|PH_B9|Q|S|VPB|VPWR pfet L=0.15U W=1U AS=0.135P
+ AD=0.135P PS=1.27U PD=1.27U
* device instance $1075 r0 *1 99.825,-94.865 pfet
M$1075 \$465 A|B|DOUT8 A|A_N|B|D|DOUT0|DOUT7|PH_B6|PH_B9|Q|S|VPB|VPWR
+ A|A_N|B|D|DOUT0|DOUT7|PH_B6|PH_B9|Q|S|VPB|VPWR pfet L=0.15U W=1U AS=0.135P
+ AD=0.135P PS=1.27U PD=1.27U
* device instance $1076 r0 *1 100.245,-94.865 pfet
M$1076 A|A_N|B|D|DOUT0|DOUT7|PH_B6|PH_B9|Q|S|VPB|VPWR B|Y \$465
+ A|A_N|B|D|DOUT0|DOUT7|PH_B6|PH_B9|Q|S|VPB|VPWR pfet L=0.15U W=1U AS=0.135P
+ AD=0.26P PS=1.27U PD=2.52U
* device instance $1077 r0 *1 100.265,-89.425 pfet
M$1077 ADCOUT2|X \$489 \$490 A|A_N|B|D|DOUT0|DOUT7|PH_B6|PH_B9|Q|S|VPB|VPWR
+ pfet L=0.15U W=1U AS=0.26P AD=0.3P PS=2.52U PD=2.6U
* device instance $1078 r0 *1 101.185,-94.865 pfet
M$1078 ADCOUT8|X \$462 \$465 A|A_N|B|D|DOUT0|DOUT7|PH_B6|PH_B9|Q|S|VPB|VPWR
+ pfet L=0.15U W=1U AS=0.26P AD=0.3P PS=2.52U PD=2.6U
* device instance $1079 r0 *1 102.205,-89.425 pfet
M$1079 \$511 B|Y \$492 A|A_N|B|D|DOUT0|DOUT7|PH_B6|PH_B9|Q|S|VPB|VPWR pfet
+ L=0.15U W=1U AS=0.26P AD=0.135P PS=2.52U PD=1.27U
* device instance $1080 r0 *1 102.625,-89.425 pfet
M$1080 A|A_N|B|D|DOUT0|DOUT7|PH_B6|PH_B9|Q|S|VPB|VPWR A|B|DOUT3 \$511
+ A|A_N|B|D|DOUT0|DOUT7|PH_B6|PH_B9|Q|S|VPB|VPWR pfet L=0.15U W=1U AS=0.135P
+ AD=0.135P PS=1.27U PD=1.27U
* device instance $1081 r0 *1 103.045,-89.425 pfet
M$1081 \$494 A|B|DOUT3 A|A_N|B|D|DOUT0|DOUT7|PH_B6|PH_B9|Q|S|VPB|VPWR
+ A|A_N|B|D|DOUT0|DOUT7|PH_B6|PH_B9|Q|S|VPB|VPWR pfet L=0.15U W=1U AS=0.135P
+ AD=0.135P PS=1.27U PD=1.27U
* device instance $1082 r0 *1 103.465,-89.425 pfet
M$1082 A|A_N|B|D|DOUT0|DOUT7|PH_B6|PH_B9|Q|S|VPB|VPWR B|Y \$494
+ A|A_N|B|D|DOUT0|DOUT7|PH_B6|PH_B9|Q|S|VPB|VPWR pfet L=0.15U W=1U AS=0.135P
+ AD=0.26P PS=1.27U PD=2.52U
* device instance $1083 r0 *1 104.405,-89.425 pfet
M$1083 ADCOUT3|X \$492 \$494 A|A_N|B|D|DOUT0|DOUT7|PH_B6|PH_B9|Q|S|VPB|VPWR
+ pfet L=0.15U W=1U AS=0.26P AD=0.3P PS=2.52U PD=2.6U
* device instance $1084 r0 *1 107.265,-89.425 pfet
M$1084 \$512 B|Y \$496 A|A_N|B|D|DOUT0|DOUT7|PH_B6|PH_B9|Q|S|VPB|VPWR pfet
+ L=0.15U W=1U AS=0.26P AD=0.135P PS=2.52U PD=1.27U
* device instance $1085 r0 *1 107.685,-89.425 pfet
M$1085 A|A_N|B|D|DOUT0|DOUT7|PH_B6|PH_B9|Q|S|VPB|VPWR
+ A|A_N|B|D|DOUT0|DOUT7|PH_B6|PH_B9|Q|S|VPB|VPWR \$512
+ A|A_N|B|D|DOUT0|DOUT7|PH_B6|PH_B9|Q|S|VPB|VPWR pfet L=0.15U W=1U AS=0.135P
+ AD=0.135P PS=1.27U PD=1.27U
* device instance $1086 r0 *1 108.105,-89.425 pfet
M$1086 \$498 A|A_N|B|D|DOUT0|DOUT7|PH_B6|PH_B9|Q|S|VPB|VPWR
+ A|A_N|B|D|DOUT0|DOUT7|PH_B6|PH_B9|Q|S|VPB|VPWR
+ A|A_N|B|D|DOUT0|DOUT7|PH_B6|PH_B9|Q|S|VPB|VPWR pfet L=0.15U W=1U AS=0.135P
+ AD=0.135P PS=1.27U PD=1.27U
* device instance $1087 r0 *1 108.525,-89.425 pfet
M$1087 A|A_N|B|D|DOUT0|DOUT7|PH_B6|PH_B9|Q|S|VPB|VPWR B|Y \$498
+ A|A_N|B|D|DOUT0|DOUT7|PH_B6|PH_B9|Q|S|VPB|VPWR pfet L=0.15U W=1U AS=0.135P
+ AD=0.26P PS=1.27U PD=2.52U
* device instance $1088 r0 *1 108.785,-90.815 pfet
M$1088 \$474 A|A0|B|DOUT9 A|A_N|B|D|DOUT0|DOUT7|PH_B6|PH_B9|Q|S|VPB|VPWR
+ A|A_N|B|D|DOUT0|DOUT7|PH_B6|PH_B9|Q|S|VPB|VPWR pfet L=0.15U W=0.42U
+ AS=0.1176P AD=0.0567P PS=1.4U PD=0.69U
* device instance $1089 r0 *1 109.205,-90.815 pfet
M$1089 \$474 A|B|DOUT6 A|A_N|B|D|DOUT0|DOUT7|PH_B6|PH_B9|Q|S|VPB|VPWR
+ A|A_N|B|D|DOUT0|DOUT7|PH_B6|PH_B9|Q|S|VPB|VPWR pfet L=0.15U W=0.42U
+ AS=0.16655P AD=0.0567P PS=1.39U PD=0.69U
* device instance $1090 r0 *1 109.745,-90.895 pfet
M$1090 SELp6|X \$474 A|A_N|B|D|DOUT0|DOUT7|PH_B6|PH_B9|Q|S|VPB|VPWR
+ A|A_N|B|D|DOUT0|DOUT7|PH_B6|PH_B9|Q|S|VPB|VPWR pfet L=0.15U W=1U AS=0.16655P
+ AD=0.475P PS=1.39U PD=2.95U
* device instance $1091 r0 *1 109.465,-89.425 pfet
M$1091 ADCOUT7|X \$496 \$498 A|A_N|B|D|DOUT0|DOUT7|PH_B6|PH_B9|Q|S|VPB|VPWR
+ pfet L=0.15U W=1U AS=0.26P AD=0.3P PS=2.52U PD=2.6U
* device instance $1092 r0 *1 115.13,-90.8 pfet
M$1092 \$484 A|A_N|B|D|DOUT0|DOUT7|PH_B6|PH_B9|Q|S|VPB|VPWR
+ A|A_N|B|D|DOUT0|DOUT7|PH_B6|PH_B9|Q|S|VPB|VPWR
+ A|A_N|B|D|DOUT0|DOUT7|PH_B6|PH_B9|Q|S|VPB|VPWR pfet L=0.15U W=0.42U
+ AS=0.15835P AD=0.07665P PS=1.395U PD=0.785U
* device instance $1093 r0 *1 115.645,-90.8 pfet
M$1093 \$478 A|A0|B|DOUT9 \$484 A|A_N|B|D|DOUT0|DOUT7|PH_B6|PH_B9|Q|S|VPB|VPWR
+ pfet L=0.15U W=0.42U AS=0.07665P AD=0.1932P PS=0.785U PD=1.34U
* device instance $1094 r0 *1 116.715,-90.8 pfet
M$1094 \$487 A|A1|OUTN|OUTN_NC \$478
+ A|A_N|B|D|DOUT0|DOUT7|PH_B6|PH_B9|Q|S|VPB|VPWR pfet L=0.15U W=0.42U
+ AS=0.1932P AD=0.0441P PS=1.34U PD=0.63U
* device instance $1095 r0 *1 117.075,-90.8 pfet
M$1095 A|A_N|B|D|DOUT0|DOUT7|PH_B6|PH_B9|Q|S|VPB|VPWR \$479 \$487
+ A|A_N|B|D|DOUT0|DOUT7|PH_B6|PH_B9|Q|S|VPB|VPWR pfet L=0.15U W=0.42U
+ AS=0.0441P AD=0.0693P PS=0.63U PD=0.75U
* device instance $1096 r0 *1 117.555,-90.8 pfet
M$1096 \$479 A|A_N|B|D|DOUT0|DOUT7|PH_B6|PH_B9|Q|S|VPB|VPWR
+ A|A_N|B|D|DOUT0|DOUT7|PH_B6|PH_B9|Q|S|VPB|VPWR
+ A|A_N|B|D|DOUT0|DOUT7|PH_B6|PH_B9|Q|S|VPB|VPWR pfet L=0.15U W=0.42U
+ AS=0.0693P AD=0.1176P PS=0.75U PD=1.4U
* device instance $1097 r0 *1 114.585,-90.895 pfet
M$1097 A|A_N|B|D|DOUT0|DOUT7|PH_B6|PH_B9|Q|S|VPB|VPWR \$478 DUMLOAD_MUX_NC|X
+ A|A_N|B|D|DOUT0|DOUT7|PH_B6|PH_B9|Q|S|VPB|VPWR pfet L=0.15U W=1U AS=0.26P
+ AD=0.15835P PS=2.52U PD=1.395U
* device instance $1098 r0 *1 120.145,-89.425 pfet
M$1098 \$513 B|Y \$503 A|A_N|B|D|DOUT0|DOUT7|PH_B6|PH_B9|Q|S|VPB|VPWR pfet
+ L=0.15U W=1U AS=0.26P AD=0.135P PS=2.52U PD=1.27U
* device instance $1099 r0 *1 120.565,-89.425 pfet
M$1099 A|A_N|B|D|DOUT0|DOUT7|PH_B6|PH_B9|Q|S|VPB|VPWR A|B|DOUT4 \$513
+ A|A_N|B|D|DOUT0|DOUT7|PH_B6|PH_B9|Q|S|VPB|VPWR pfet L=0.15U W=1U AS=0.135P
+ AD=0.135P PS=1.27U PD=1.27U
* device instance $1100 r0 *1 120.985,-89.425 pfet
M$1100 \$504 A|B|DOUT4 A|A_N|B|D|DOUT0|DOUT7|PH_B6|PH_B9|Q|S|VPB|VPWR
+ A|A_N|B|D|DOUT0|DOUT7|PH_B6|PH_B9|Q|S|VPB|VPWR pfet L=0.15U W=1U AS=0.135P
+ AD=0.135P PS=1.27U PD=1.27U
* device instance $1101 r0 *1 121.405,-89.425 pfet
M$1101 A|A_N|B|D|DOUT0|DOUT7|PH_B6|PH_B9|Q|S|VPB|VPWR B|Y \$504
+ A|A_N|B|D|DOUT0|DOUT7|PH_B6|PH_B9|Q|S|VPB|VPWR pfet L=0.15U W=1U AS=0.135P
+ AD=0.26P PS=1.27U PD=2.52U
* device instance $1102 r0 *1 122.345,-89.425 pfet
M$1102 ADCOUT4|X \$503 \$504 A|A_N|B|D|DOUT0|DOUT7|PH_B6|PH_B9|Q|S|VPB|VPWR
+ pfet L=0.15U W=1U AS=0.26P AD=0.3P PS=2.52U PD=2.6U
* device instance $1103 r0 *1 127.645,-94.945 pfet
M$1103 \$468 A|B|DOUT1 A|A_N|B|D|DOUT0|DOUT7|PH_B6|PH_B9|Q|S|VPB|VPWR
+ A|A_N|B|D|DOUT0|DOUT7|PH_B6|PH_B9|Q|S|VPB|VPWR pfet L=0.15U W=0.42U
+ AS=0.1176P AD=0.0567P PS=1.4U PD=0.69U
* device instance $1104 r0 *1 128.065,-94.945 pfet
M$1104 \$468 B|Y A|A_N|B|D|DOUT0|DOUT7|PH_B6|PH_B9|Q|S|VPB|VPWR
+ A|A_N|B|D|DOUT0|DOUT7|PH_B6|PH_B9|Q|S|VPB|VPWR pfet L=0.15U W=0.42U
+ AS=0.16655P AD=0.0567P PS=1.39U PD=0.69U
* device instance $1105 r0 *1 128.605,-94.865 pfet
M$1105 SELn1|X \$468 A|A_N|B|D|DOUT0|DOUT7|PH_B6|PH_B9|Q|S|VPB|VPWR
+ A|A_N|B|D|DOUT0|DOUT7|PH_B6|PH_B9|Q|S|VPB|VPWR pfet L=0.15U W=1U AS=0.16655P
+ AD=0.475P PS=1.39U PD=2.95U
* device instance $1106 r0 *1 135.03,-89.425 pfet
M$1106 B|Y A|A0|B|DOUT9 A|A_N|B|D|DOUT0|DOUT7|PH_B6|PH_B9|Q|S|VPB|VPWR
+ A|A_N|B|D|DOUT0|DOUT7|PH_B6|PH_B9|Q|S|VPB|VPWR pfet L=0.15U W=1U AS=0.26P
+ AD=0.26P PS=2.52U PD=2.52U
* device instance $1107 r0 *1 136.845,-90.815 pfet
M$1107 \$481 A|A0|B|DOUT9 A|A_N|B|D|DOUT0|DOUT7|PH_B6|PH_B9|Q|S|VPB|VPWR
+ A|A_N|B|D|DOUT0|DOUT7|PH_B6|PH_B9|Q|S|VPB|VPWR pfet L=0.15U W=0.42U
+ AS=0.1176P AD=0.0567P PS=1.4U PD=0.69U
* device instance $1108 r0 *1 137.265,-90.815 pfet
M$1108 \$481 A|B|DOUT4 A|A_N|B|D|DOUT0|DOUT7|PH_B6|PH_B9|Q|S|VPB|VPWR
+ A|A_N|B|D|DOUT0|DOUT7|PH_B6|PH_B9|Q|S|VPB|VPWR pfet L=0.15U W=0.42U
+ AS=0.16655P AD=0.0567P PS=1.39U PD=0.69U
* device instance $1109 r0 *1 137.805,-90.895 pfet
M$1109 SELp4|X \$481 A|A_N|B|D|DOUT0|DOUT7|PH_B6|PH_B9|Q|S|VPB|VPWR
+ A|A_N|B|D|DOUT0|DOUT7|PH_B6|PH_B9|Q|S|VPB|VPWR pfet L=0.15U W=1U AS=0.16655P
+ AD=0.475P PS=1.39U PD=2.95U
* device instance $1110 r0 *1 97.145,-85.455 pfet
M$1110 \$555 B|Y \$522 A|A_N|B|D|DOUT0|DOUT7|PH_B6|PH_B9|Q|S|VPB|VPWR pfet
+ L=0.15U W=1U AS=0.26P AD=0.135P PS=2.52U PD=1.27U
* device instance $1111 r0 *1 97.565,-85.455 pfet
M$1111 A|A_N|B|D|DOUT0|DOUT7|PH_B6|PH_B9|Q|S|VPB|VPWR
+ A|A_N|B|D|DOUT0|DOUT7|PH_B6|PH_B9|Q|S|VPB|VPWR \$555
+ A|A_N|B|D|DOUT0|DOUT7|PH_B6|PH_B9|Q|S|VPB|VPWR pfet L=0.15U W=1U AS=0.135P
+ AD=0.135P PS=1.27U PD=1.27U
* device instance $1112 r0 *1 97.985,-85.455 pfet
M$1112 \$553 A|A_N|B|D|DOUT0|DOUT7|PH_B6|PH_B9|Q|S|VPB|VPWR
+ A|A_N|B|D|DOUT0|DOUT7|PH_B6|PH_B9|Q|S|VPB|VPWR
+ A|A_N|B|D|DOUT0|DOUT7|PH_B6|PH_B9|Q|S|VPB|VPWR pfet L=0.15U W=1U AS=0.135P
+ AD=0.135P PS=1.27U PD=1.27U
* device instance $1113 r0 *1 98.405,-85.455 pfet
M$1113 A|A_N|B|D|DOUT0|DOUT7|PH_B6|PH_B9|Q|S|VPB|VPWR B|Y \$553
+ A|A_N|B|D|DOUT0|DOUT7|PH_B6|PH_B9|Q|S|VPB|VPWR pfet L=0.15U W=1U AS=0.135P
+ AD=0.26P PS=1.27U PD=2.52U
* device instance $1114 r0 *1 99.345,-85.455 pfet
M$1114 ADCOUT0|X \$522 \$553 A|A_N|B|D|DOUT0|DOUT7|PH_B6|PH_B9|Q|S|VPB|VPWR
+ pfet L=0.15U W=1U AS=0.26P AD=0.3P PS=2.52U PD=2.6U
* device instance $1115 r0 *1 102.83,-85.455 pfet
M$1115 HALF_LSB_ENN|Y A|HALF_LSB_EN|X
+ A|A_N|B|D|DOUT0|DOUT7|PH_B6|PH_B9|Q|S|VPB|VPWR
+ A|A_N|B|D|DOUT0|DOUT7|PH_B6|PH_B9|Q|S|VPB|VPWR pfet L=0.15U W=1U AS=0.26P
+ AD=0.26P PS=2.52U PD=2.52U
* device instance $1116 r0 *1 110.625,-89.505 pfet
M$1116 \$499 A|A_N|B|D|DOUT0|DOUT7|PH_B6|PH_B9|Q|S|VPB|VPWR
+ A|A_N|B|D|DOUT0|DOUT7|PH_B6|PH_B9|Q|S|VPB|VPWR
+ A|A_N|B|D|DOUT0|DOUT7|PH_B6|PH_B9|Q|S|VPB|VPWR pfet L=0.15U W=0.42U
+ AS=0.1176P AD=0.0567P PS=1.4U PD=0.69U
* device instance $1117 r0 *1 111.045,-89.505 pfet
M$1117 \$499 B|Y A|A_N|B|D|DOUT0|DOUT7|PH_B6|PH_B9|Q|S|VPB|VPWR
+ A|A_N|B|D|DOUT0|DOUT7|PH_B6|PH_B9|Q|S|VPB|VPWR pfet L=0.15U W=0.42U
+ AS=0.16655P AD=0.0567P PS=1.39U PD=0.69U
* device instance $1118 r0 *1 111.585,-89.425 pfet
M$1118 SELn7|X \$499 A|A_N|B|D|DOUT0|DOUT7|PH_B6|PH_B9|Q|S|VPB|VPWR
+ A|A_N|B|D|DOUT0|DOUT7|PH_B6|PH_B9|Q|S|VPB|VPWR pfet L=0.15U W=1U AS=0.16655P
+ AD=0.475P PS=1.39U PD=2.95U
* device instance $1119 r0 *1 113.705,-85.455 pfet
M$1119 \$531 A|A0|B|DOUT9 A|A_N|B|D|DOUT0|DOUT7|PH_B6|PH_B9|Q|S|VPB|VPWR
+ A|A_N|B|D|DOUT0|DOUT7|PH_B6|PH_B9|Q|S|VPB|VPWR pfet L=0.15U W=1U AS=0.3P
+ AD=0.135P PS=2.6U PD=1.27U
* device instance $1120 r0 *1 114.125,-85.455 pfet
M$1120 A|A_N|B|D|DOUT0|DOUT7|PH_B6|PH_B9|Q|S|VPB|VPWR A|A1|OUTN|OUTN_NC \$531
+ A|A_N|B|D|DOUT0|DOUT7|PH_B6|PH_B9|Q|S|VPB|VPWR pfet L=0.15U W=1U AS=0.135P
+ AD=0.365P PS=1.27U PD=1.73U
* device instance $1121 r0 *1 115.005,-85.455 pfet
M$1121 \$556 A|A1|OUTN|OUTN_NC A|A_N|B|D|DOUT0|DOUT7|PH_B6|PH_B9|Q|S|VPB|VPWR
+ A|A_N|B|D|DOUT0|DOUT7|PH_B6|PH_B9|Q|S|VPB|VPWR pfet L=0.15U W=1U AS=0.365P
+ AD=0.105P PS=1.73U PD=1.21U
* device instance $1122 r0 *1 115.365,-85.455 pfet
M$1122 DUMLOAD_XNOR_NC|Y A|A0|B|DOUT9 \$556
+ A|A_N|B|D|DOUT0|DOUT7|PH_B6|PH_B9|Q|S|VPB|VPWR pfet L=0.15U W=1U AS=0.105P
+ AD=0.165P PS=1.21U PD=1.33U
* device instance $1123 r0 *1 115.845,-85.455 pfet
M$1123 A|A_N|B|D|DOUT0|DOUT7|PH_B6|PH_B9|Q|S|VPB|VPWR \$531 DUMLOAD_XNOR_NC|Y
+ A|A_N|B|D|DOUT0|DOUT7|PH_B6|PH_B9|Q|S|VPB|VPWR pfet L=0.15U W=1U AS=0.165P
+ AD=0.36P PS=1.33U PD=2.72U
* device instance $1124 r0 *1 117.525,-89.505 pfet
M$1124 \$501 A|A0|B|DOUT9 A|A_N|B|D|DOUT0|DOUT7|PH_B6|PH_B9|Q|S|VPB|VPWR
+ A|A_N|B|D|DOUT0|DOUT7|PH_B6|PH_B9|Q|S|VPB|VPWR pfet L=0.15U W=0.42U
+ AS=0.1176P AD=0.0567P PS=1.4U PD=0.69U
* device instance $1125 r0 *1 117.945,-89.505 pfet
M$1125 \$501 A|B|DOUT1 A|A_N|B|D|DOUT0|DOUT7|PH_B6|PH_B9|Q|S|VPB|VPWR
+ A|A_N|B|D|DOUT0|DOUT7|PH_B6|PH_B9|Q|S|VPB|VPWR pfet L=0.15U W=0.42U
+ AS=0.16655P AD=0.0567P PS=1.39U PD=0.69U
* device instance $1126 r0 *1 118.485,-89.425 pfet
M$1126 SELp1|X \$501 A|A_N|B|D|DOUT0|DOUT7|PH_B6|PH_B9|Q|S|VPB|VPWR
+ A|A_N|B|D|DOUT0|DOUT7|PH_B6|PH_B9|Q|S|VPB|VPWR pfet L=0.15U W=1U AS=0.16655P
+ AD=0.475P PS=1.39U PD=2.95U
* device instance $1127 r0 *1 121.525,-85.455 pfet
M$1127 \$557 B|Y \$534 A|A_N|B|D|DOUT0|DOUT7|PH_B6|PH_B9|Q|S|VPB|VPWR pfet
+ L=0.15U W=1U AS=0.26P AD=0.135P PS=2.52U PD=1.27U
* device instance $1128 r0 *1 121.945,-85.455 pfet
M$1128 A|A_N|B|D|DOUT0|DOUT7|PH_B6|PH_B9|Q|S|VPB|VPWR A|B|DOUT5 \$557
+ A|A_N|B|D|DOUT0|DOUT7|PH_B6|PH_B9|Q|S|VPB|VPWR pfet L=0.15U W=1U AS=0.135P
+ AD=0.135P PS=1.27U PD=1.27U
* device instance $1129 r0 *1 122.365,-85.455 pfet
M$1129 \$554 A|B|DOUT5 A|A_N|B|D|DOUT0|DOUT7|PH_B6|PH_B9|Q|S|VPB|VPWR
+ A|A_N|B|D|DOUT0|DOUT7|PH_B6|PH_B9|Q|S|VPB|VPWR pfet L=0.15U W=1U AS=0.135P
+ AD=0.135P PS=1.27U PD=1.27U
* device instance $1130 r0 *1 122.785,-85.455 pfet
M$1130 A|A_N|B|D|DOUT0|DOUT7|PH_B6|PH_B9|Q|S|VPB|VPWR B|Y \$554
+ A|A_N|B|D|DOUT0|DOUT7|PH_B6|PH_B9|Q|S|VPB|VPWR pfet L=0.15U W=1U AS=0.135P
+ AD=0.26P PS=1.27U PD=2.52U
* device instance $1131 r0 *1 123.725,-85.455 pfet
M$1131 ADCOUT5|X \$534 \$554 A|A_N|B|D|DOUT0|DOUT7|PH_B6|PH_B9|Q|S|VPB|VPWR
+ pfet L=0.15U W=1U AS=0.26P AD=0.3P PS=2.52U PD=2.6U
* device instance $1132 r0 *1 124.91,-85.455 pfet
M$1132 CLK|CLKN|Y A|CLK$1 A|A_N|B|D|DOUT0|DOUT7|PH_B6|PH_B9|Q|S|VPB|VPWR
+ A|A_N|B|D|DOUT0|DOUT7|PH_B6|PH_B9|Q|S|VPB|VPWR pfet L=0.15U W=1U AS=0.26P
+ AD=0.26P PS=2.52U PD=2.52U
* device instance $1133 r0 *1 127.185,-89.505 pfet
M$1133 \$506 A|A0|B|DOUT9 A|A_N|B|D|DOUT0|DOUT7|PH_B6|PH_B9|Q|S|VPB|VPWR
+ A|A_N|B|D|DOUT0|DOUT7|PH_B6|PH_B9|Q|S|VPB|VPWR pfet L=0.15U W=0.42U
+ AS=0.1176P AD=0.0567P PS=1.4U PD=0.69U
* device instance $1134 r0 *1 127.605,-89.505 pfet
M$1134 \$506 A|A_N|B|D|DOUT0|DOUT7|PH_B6|PH_B9|Q|S|VPB|VPWR
+ A|A_N|B|D|DOUT0|DOUT7|PH_B6|PH_B9|Q|S|VPB|VPWR
+ A|A_N|B|D|DOUT0|DOUT7|PH_B6|PH_B9|Q|S|VPB|VPWR pfet L=0.15U W=0.42U
+ AS=0.16655P AD=0.0567P PS=1.39U PD=0.69U
* device instance $1135 r0 *1 128.145,-89.425 pfet
M$1135 SELp7|X \$506 A|A_N|B|D|DOUT0|DOUT7|PH_B6|PH_B9|Q|S|VPB|VPWR
+ A|A_N|B|D|DOUT0|DOUT7|PH_B6|PH_B9|Q|S|VPB|VPWR pfet L=0.15U W=1U AS=0.16655P
+ AD=0.475P PS=1.39U PD=2.95U
* device instance $1136 r0 *1 136.845,-89.505 pfet
M$1136 \$508 A|B|DOUT6 A|A_N|B|D|DOUT0|DOUT7|PH_B6|PH_B9|Q|S|VPB|VPWR
+ A|A_N|B|D|DOUT0|DOUT7|PH_B6|PH_B9|Q|S|VPB|VPWR pfet L=0.15U W=0.42U
+ AS=0.1176P AD=0.0567P PS=1.4U PD=0.69U
* device instance $1137 r0 *1 137.265,-89.505 pfet
M$1137 \$508 B|Y A|A_N|B|D|DOUT0|DOUT7|PH_B6|PH_B9|Q|S|VPB|VPWR
+ A|A_N|B|D|DOUT0|DOUT7|PH_B6|PH_B9|Q|S|VPB|VPWR pfet L=0.15U W=0.42U
+ AS=0.16655P AD=0.0567P PS=1.39U PD=0.69U
* device instance $1138 r0 *1 137.805,-89.425 pfet
M$1138 SELn6|X \$508 A|A_N|B|D|DOUT0|DOUT7|PH_B6|PH_B9|Q|S|VPB|VPWR
+ A|A_N|B|D|DOUT0|DOUT7|PH_B6|PH_B9|Q|S|VPB|VPWR pfet L=0.15U W=1U AS=0.16655P
+ AD=0.475P PS=1.39U PD=2.95U
* device instance $1139 r0 *1 107.405,-85.375 pfet
M$1139 \$525 A|A0|B|DOUT9 A|A_N|B|D|DOUT0|DOUT7|PH_B6|PH_B9|Q|S|VPB|VPWR
+ A|A_N|B|D|DOUT0|DOUT7|PH_B6|PH_B9|Q|S|VPB|VPWR pfet L=0.15U W=0.42U
+ AS=0.1176P AD=0.0567P PS=1.4U PD=0.69U
* device instance $1140 r0 *1 107.825,-85.375 pfet
M$1140 \$525 A|A_N|B|D|DOUT0|DOUT7|PH_B6|PH_B9|Q|S|VPB|VPWR
+ A|A_N|B|D|DOUT0|DOUT7|PH_B6|PH_B9|Q|S|VPB|VPWR
+ A|A_N|B|D|DOUT0|DOUT7|PH_B6|PH_B9|Q|S|VPB|VPWR pfet L=0.15U W=0.42U
+ AS=0.16655P AD=0.0567P PS=1.39U PD=0.69U
* device instance $1141 r0 *1 108.365,-85.455 pfet
M$1141 SELp0|X \$525 A|A_N|B|D|DOUT0|DOUT7|PH_B6|PH_B9|Q|S|VPB|VPWR
+ A|A_N|B|D|DOUT0|DOUT7|PH_B6|PH_B9|Q|S|VPB|VPWR pfet L=0.15U W=1U AS=0.16655P
+ AD=0.475P PS=1.39U PD=2.95U
* device instance $1142 r0 *1 110.165,-85.375 pfet
M$1142 \$527 A|B|DOUT3 A|A_N|B|D|DOUT0|DOUT7|PH_B6|PH_B9|Q|S|VPB|VPWR
+ A|A_N|B|D|DOUT0|DOUT7|PH_B6|PH_B9|Q|S|VPB|VPWR pfet L=0.15U W=0.42U
+ AS=0.1176P AD=0.0567P PS=1.4U PD=0.69U
* device instance $1143 r0 *1 110.585,-85.375 pfet
M$1143 \$527 B|Y A|A_N|B|D|DOUT0|DOUT7|PH_B6|PH_B9|Q|S|VPB|VPWR
+ A|A_N|B|D|DOUT0|DOUT7|PH_B6|PH_B9|Q|S|VPB|VPWR pfet L=0.15U W=0.42U
+ AS=0.16655P AD=0.0567P PS=1.39U PD=0.69U
* device instance $1144 r0 *1 111.125,-85.455 pfet
M$1144 SELn3|X \$527 A|A_N|B|D|DOUT0|DOUT7|PH_B6|PH_B9|Q|S|VPB|VPWR
+ A|A_N|B|D|DOUT0|DOUT7|PH_B6|PH_B9|Q|S|VPB|VPWR pfet L=0.15U W=1U AS=0.16655P
+ AD=0.475P PS=1.39U PD=2.95U
* device instance $1145 r0 *1 114.585,-84.275 pfet
M$1145 A|A_N|B|D|DOUT0|DOUT7|PH_B6|PH_B9|Q|S|VPB|VPWR
+ A|A_N|B|D|DOUT0|DOUT7|PH_B6|PH_B9|Q|S|VPB|VPWR \$562
+ A|A_N|B|D|DOUT0|DOUT7|PH_B6|PH_B9|Q|S|VPB|VPWR pfet L=0.15U W=0.42U
+ AS=0.1092P AD=0.0714P PS=1.36U PD=0.76U
* device instance $1146 r0 *1 115.075,-84.275 pfet
M$1146 \$563 \$562 A|A_N|B|D|DOUT0|DOUT7|PH_B6|PH_B9|Q|S|VPB|VPWR
+ A|A_N|B|D|DOUT0|DOUT7|PH_B6|PH_B9|Q|S|VPB|VPWR pfet L=0.15U W=0.42U
+ AS=0.0714P AD=0.0609P PS=0.76U PD=0.71U
* device instance $1147 r0 *1 115.515,-84.275 pfet
M$1147 A|A_N|B|D|DOUT0|DOUT7|PH_B6|PH_B9|Q|S|VPB|VPWR
+ A|B|BUSY|DOUT2|GND|VGND|VSS \$563
+ A|A_N|B|D|DOUT0|DOUT7|PH_B6|PH_B9|Q|S|VPB|VPWR pfet L=0.15U W=0.42U
+ AS=0.0609P AD=0.2279P PS=0.71U PD=1.74U
* device instance $1148 r0 *1 116.405,-83.985 pfet
M$1148 A|HALF_LSB_EN|X \$563 A|A_N|B|D|DOUT0|DOUT7|PH_B6|PH_B9|Q|S|VPB|VPWR
+ A|A_N|B|D|DOUT0|DOUT7|PH_B6|PH_B9|Q|S|VPB|VPWR pfet L=0.15U W=1U AS=0.2279P
+ AD=0.26P PS=1.74U PD=2.52U
* device instance $1149 r0 *1 118.305,-83.985 pfet
M$1149 \$576 B|Y \$564 A|A_N|B|D|DOUT0|DOUT7|PH_B6|PH_B9|Q|S|VPB|VPWR pfet
+ L=0.15U W=1U AS=0.26P AD=0.135P PS=2.52U PD=1.27U
* device instance $1150 r0 *1 118.725,-83.985 pfet
M$1150 A|A_N|B|D|DOUT0|DOUT7|PH_B6|PH_B9|Q|S|VPB|VPWR A|B|DOUT1 \$576
+ A|A_N|B|D|DOUT0|DOUT7|PH_B6|PH_B9|Q|S|VPB|VPWR pfet L=0.15U W=1U AS=0.135P
+ AD=0.135P PS=1.27U PD=1.27U
* device instance $1151 r0 *1 119.145,-83.985 pfet
M$1151 \$565 A|B|DOUT1 A|A_N|B|D|DOUT0|DOUT7|PH_B6|PH_B9|Q|S|VPB|VPWR
+ A|A_N|B|D|DOUT0|DOUT7|PH_B6|PH_B9|Q|S|VPB|VPWR pfet L=0.15U W=1U AS=0.135P
+ AD=0.135P PS=1.27U PD=1.27U
* device instance $1152 r0 *1 119.565,-83.985 pfet
M$1152 A|A_N|B|D|DOUT0|DOUT7|PH_B6|PH_B9|Q|S|VPB|VPWR B|Y \$565
+ A|A_N|B|D|DOUT0|DOUT7|PH_B6|PH_B9|Q|S|VPB|VPWR pfet L=0.15U W=1U AS=0.135P
+ AD=0.26P PS=1.27U PD=2.52U
* device instance $1153 r0 *1 119.365,-85.375 pfet
M$1153 \$532 A|B|BUSY|DOUT2|GND|VGND|VSS
+ A|A_N|B|D|DOUT0|DOUT7|PH_B6|PH_B9|Q|S|VPB|VPWR
+ A|A_N|B|D|DOUT0|DOUT7|PH_B6|PH_B9|Q|S|VPB|VPWR pfet L=0.15U W=0.42U
+ AS=0.1176P AD=0.0567P PS=1.4U PD=0.69U
* device instance $1154 r0 *1 119.785,-85.375 pfet
M$1154 \$532 B|Y A|A_N|B|D|DOUT0|DOUT7|PH_B6|PH_B9|Q|S|VPB|VPWR
+ A|A_N|B|D|DOUT0|DOUT7|PH_B6|PH_B9|Q|S|VPB|VPWR pfet L=0.15U W=0.42U
+ AS=0.16655P AD=0.0567P PS=1.39U PD=0.69U
* device instance $1155 r0 *1 120.325,-85.455 pfet
M$1155 SELn2|X \$532 A|A_N|B|D|DOUT0|DOUT7|PH_B6|PH_B9|Q|S|VPB|VPWR
+ A|A_N|B|D|DOUT0|DOUT7|PH_B6|PH_B9|Q|S|VPB|VPWR pfet L=0.15U W=1U AS=0.16655P
+ AD=0.475P PS=1.39U PD=2.95U
* device instance $1156 r0 *1 120.505,-83.985 pfet
M$1156 ADCOUT1|X \$564 \$565 A|A_N|B|D|DOUT0|DOUT7|PH_B6|PH_B9|Q|S|VPB|VPWR
+ pfet L=0.15U W=1U AS=0.26P AD=0.3P PS=2.52U PD=2.6U
* device instance $1157 r0 *1 122.445,-83.985 pfet
M$1157 \$577 B|Y \$567 A|A_N|B|D|DOUT0|DOUT7|PH_B6|PH_B9|Q|S|VPB|VPWR pfet
+ L=0.15U W=1U AS=0.26P AD=0.135P PS=2.52U PD=1.27U
* device instance $1158 r0 *1 122.865,-83.985 pfet
M$1158 A|A_N|B|D|DOUT0|DOUT7|PH_B6|PH_B9|Q|S|VPB|VPWR A|B|DOUT6 \$577
+ A|A_N|B|D|DOUT0|DOUT7|PH_B6|PH_B9|Q|S|VPB|VPWR pfet L=0.15U W=1U AS=0.135P
+ AD=0.135P PS=1.27U PD=1.27U
* device instance $1159 r0 *1 123.285,-83.985 pfet
M$1159 \$568 A|B|DOUT6 A|A_N|B|D|DOUT0|DOUT7|PH_B6|PH_B9|Q|S|VPB|VPWR
+ A|A_N|B|D|DOUT0|DOUT7|PH_B6|PH_B9|Q|S|VPB|VPWR pfet L=0.15U W=1U AS=0.135P
+ AD=0.135P PS=1.27U PD=1.27U
* device instance $1160 r0 *1 123.705,-83.985 pfet
M$1160 A|A_N|B|D|DOUT0|DOUT7|PH_B6|PH_B9|Q|S|VPB|VPWR B|Y \$568
+ A|A_N|B|D|DOUT0|DOUT7|PH_B6|PH_B9|Q|S|VPB|VPWR pfet L=0.15U W=1U AS=0.135P
+ AD=0.26P PS=1.27U PD=2.52U
* device instance $1161 r0 *1 124.645,-83.985 pfet
M$1161 ADCOUT6|X \$567 \$568 A|A_N|B|D|DOUT0|DOUT7|PH_B6|PH_B9|Q|S|VPB|VPWR
+ pfet L=0.15U W=1U AS=0.26P AD=0.3P PS=2.52U PD=2.6U
* device instance $1162 r0 *1 128.565,-85.375 pfet
M$1162 \$538 A|A0|B|DOUT9 A|A_N|B|D|DOUT0|DOUT7|PH_B6|PH_B9|Q|S|VPB|VPWR
+ A|A_N|B|D|DOUT0|DOUT7|PH_B6|PH_B9|Q|S|VPB|VPWR pfet L=0.15U W=0.42U
+ AS=0.1176P AD=0.0567P PS=1.4U PD=0.69U
* device instance $1163 r0 *1 128.985,-85.375 pfet
M$1163 \$538 A|B|DOUT8 A|A_N|B|D|DOUT0|DOUT7|PH_B6|PH_B9|Q|S|VPB|VPWR
+ A|A_N|B|D|DOUT0|DOUT7|PH_B6|PH_B9|Q|S|VPB|VPWR pfet L=0.15U W=0.42U
+ AS=0.16655P AD=0.0567P PS=1.39U PD=0.69U
* device instance $1164 r0 *1 129.525,-85.455 pfet
M$1164 SELp8|X \$538 A|A_N|B|D|DOUT0|DOUT7|PH_B6|PH_B9|Q|S|VPB|VPWR
+ A|A_N|B|D|DOUT0|DOUT7|PH_B6|PH_B9|Q|S|VPB|VPWR pfet L=0.15U W=1U AS=0.16655P
+ AD=0.475P PS=1.39U PD=2.95U
* device instance $1165 r0 *1 132.245,-85.375 pfet
M$1165 \$540 A|A0|B|DOUT9 A|A_N|B|D|DOUT0|DOUT7|PH_B6|PH_B9|Q|S|VPB|VPWR
+ A|A_N|B|D|DOUT0|DOUT7|PH_B6|PH_B9|Q|S|VPB|VPWR pfet L=0.15U W=0.42U
+ AS=0.1176P AD=0.0567P PS=1.4U PD=0.69U
* device instance $1166 r0 *1 132.665,-85.375 pfet
M$1166 \$540 A|B|DOUT3 A|A_N|B|D|DOUT0|DOUT7|PH_B6|PH_B9|Q|S|VPB|VPWR
+ A|A_N|B|D|DOUT0|DOUT7|PH_B6|PH_B9|Q|S|VPB|VPWR pfet L=0.15U W=0.42U
+ AS=0.16655P AD=0.0567P PS=1.39U PD=0.69U
* device instance $1167 r0 *1 133.205,-85.455 pfet
M$1167 SELp3|X \$540 A|A_N|B|D|DOUT0|DOUT7|PH_B6|PH_B9|Q|S|VPB|VPWR
+ A|A_N|B|D|DOUT0|DOUT7|PH_B6|PH_B9|Q|S|VPB|VPWR pfet L=0.15U W=1U AS=0.16655P
+ AD=0.475P PS=1.39U PD=2.95U
* device instance $1168 r0 *1 135.925,-85.375 pfet
M$1168 \$542 A|B|DOUT5 A|A_N|B|D|DOUT0|DOUT7|PH_B6|PH_B9|Q|S|VPB|VPWR
+ A|A_N|B|D|DOUT0|DOUT7|PH_B6|PH_B9|Q|S|VPB|VPWR pfet L=0.15U W=0.42U
+ AS=0.1176P AD=0.0567P PS=1.4U PD=0.69U
* device instance $1169 r0 *1 136.345,-85.375 pfet
M$1169 \$542 B|Y A|A_N|B|D|DOUT0|DOUT7|PH_B6|PH_B9|Q|S|VPB|VPWR
+ A|A_N|B|D|DOUT0|DOUT7|PH_B6|PH_B9|Q|S|VPB|VPWR pfet L=0.15U W=0.42U
+ AS=0.16655P AD=0.0567P PS=1.39U PD=0.69U
* device instance $1170 r0 *1 136.885,-85.455 pfet
M$1170 SELn5|X \$542 A|A_N|B|D|DOUT0|DOUT7|PH_B6|PH_B9|Q|S|VPB|VPWR
+ A|A_N|B|D|DOUT0|DOUT7|PH_B6|PH_B9|Q|S|VPB|VPWR pfet L=0.15U W=1U AS=0.16655P
+ AD=0.475P PS=1.39U PD=2.95U
* device instance $1171 r0 *1 4.545,-26.58 pfet
M$1171 \$589 SELp0|X VREFP VDD pfet L=0.15U W=2U AS=0.94P AD=0.94P PS=4.94U
+ PD=4.94U
* device instance $1172 r0 *1 15.545,-26.58 pfet
M$1172 \$590 SELp1|X VREFP VDD pfet L=0.15U W=2U AS=0.94P AD=0.94P PS=4.94U
+ PD=4.94U
* device instance $1173 r0 *1 26.545,-26.58 pfet
M$1173 \$591 SELp2|X VREFP VDD pfet L=0.15U W=2U AS=0.94P AD=0.94P PS=4.94U
+ PD=4.94U
* device instance $1174 r0 *1 37.545,-26.58 pfet
M$1174 \$592 SELp3|X VREFP VDD pfet L=0.15U W=2U AS=0.94P AD=0.94P PS=4.94U
+ PD=4.94U
* device instance $1175 r0 *1 48.545,-26.58 pfet
M$1175 \$593 SELp4|X VREFP VDD pfet L=0.15U W=2U AS=0.94P AD=0.94P PS=4.94U
+ PD=4.94U
* device instance $1176 r0 *1 59.545,-26.58 pfet
M$1176 \$594 SELp5|X VREFP VDD pfet L=0.15U W=2U AS=0.94P AD=0.94P PS=4.94U
+ PD=4.94U
* device instance $1177 r0 *1 70.545,-26.58 pfet
M$1177 \$607 SELp6|X VREFP VDD pfet L=0.15U W=2U AS=0.94P AD=0.94P PS=4.94U
+ PD=4.94U
* device instance $1178 r0 *1 81.545,-26.58 pfet
M$1178 \$606 SELp7|X VREFP VDD pfet L=0.15U W=2U AS=0.94P AD=0.94P PS=4.94U
+ PD=4.94U
* device instance $1179 r0 *1 92.545,-26.58 pfet
M$1179 \$605 SELp8|X VREFP VDD pfet L=0.15U W=2U AS=0.94P AD=0.94P PS=4.94U
+ PD=4.94U
* device instance $1180 r0 *1 101.885,-84.065 pfet
M$1180 \$558 A|B|DOUT8 A|A_N|B|D|DOUT0|DOUT7|PH_B6|PH_B9|Q|S|VPB|VPWR
+ A|A_N|B|D|DOUT0|DOUT7|PH_B6|PH_B9|Q|S|VPB|VPWR pfet L=0.15U W=0.42U
+ AS=0.1176P AD=0.0567P PS=1.4U PD=0.69U
* device instance $1181 r0 *1 102.305,-84.065 pfet
M$1181 \$558 B|Y A|A_N|B|D|DOUT0|DOUT7|PH_B6|PH_B9|Q|S|VPB|VPWR
+ A|A_N|B|D|DOUT0|DOUT7|PH_B6|PH_B9|Q|S|VPB|VPWR pfet L=0.15U W=0.42U
+ AS=0.16655P AD=0.0567P PS=1.39U PD=0.69U
* device instance $1182 r0 *1 102.845,-83.985 pfet
M$1182 SELn8|X \$558 A|A_N|B|D|DOUT0|DOUT7|PH_B6|PH_B9|Q|S|VPB|VPWR
+ A|A_N|B|D|DOUT0|DOUT7|PH_B6|PH_B9|Q|S|VPB|VPWR pfet L=0.15U W=1U AS=0.16655P
+ AD=0.475P PS=1.39U PD=2.95U
* device instance $1183 r0 *1 103.545,-26.58 pfet
M$1183 \$595 SELn0|X VREFP VDD pfet L=0.15U W=2U AS=0.94P AD=0.94P PS=4.94U
+ PD=4.94U
* device instance $1184 r0 *1 108.325,-84.065 pfet
M$1184 \$560 A|A0|B|DOUT9 A|A_N|B|D|DOUT0|DOUT7|PH_B6|PH_B9|Q|S|VPB|VPWR
+ A|A_N|B|D|DOUT0|DOUT7|PH_B6|PH_B9|Q|S|VPB|VPWR pfet L=0.15U W=0.42U
+ AS=0.1176P AD=0.0567P PS=1.4U PD=0.69U
* device instance $1185 r0 *1 108.745,-84.065 pfet
M$1185 \$560 A|B|BUSY|DOUT2|GND|VGND|VSS
+ A|A_N|B|D|DOUT0|DOUT7|PH_B6|PH_B9|Q|S|VPB|VPWR
+ A|A_N|B|D|DOUT0|DOUT7|PH_B6|PH_B9|Q|S|VPB|VPWR pfet L=0.15U W=0.42U
+ AS=0.16655P AD=0.0567P PS=1.39U PD=0.69U
* device instance $1186 r0 *1 109.285,-83.985 pfet
M$1186 SELp2|X \$560 A|A_N|B|D|DOUT0|DOUT7|PH_B6|PH_B9|Q|S|VPB|VPWR
+ A|A_N|B|D|DOUT0|DOUT7|PH_B6|PH_B9|Q|S|VPB|VPWR pfet L=0.15U W=1U AS=0.16655P
+ AD=0.475P PS=1.39U PD=2.95U
* device instance $1187 r0 *1 114.545,-26.58 pfet
M$1187 \$596 SELn1|X VREFP VDD pfet L=0.15U W=2U AS=0.94P AD=0.94P PS=4.94U
+ PD=4.94U
* device instance $1188 r0 *1 125.545,-26.58 pfet
M$1188 \$597 SELn2|X VREFP VDD pfet L=0.15U W=2U AS=0.94P AD=0.94P PS=4.94U
+ PD=4.94U
* device instance $1189 r0 *1 128.565,-84.065 pfet
M$1189 \$570 A|A0|B|DOUT9 A|A_N|B|D|DOUT0|DOUT7|PH_B6|PH_B9|Q|S|VPB|VPWR
+ A|A_N|B|D|DOUT0|DOUT7|PH_B6|PH_B9|Q|S|VPB|VPWR pfet L=0.15U W=0.42U
+ AS=0.1176P AD=0.0567P PS=1.4U PD=0.69U
* device instance $1190 r0 *1 128.985,-84.065 pfet
M$1190 \$570 A|B|DOUT5 A|A_N|B|D|DOUT0|DOUT7|PH_B6|PH_B9|Q|S|VPB|VPWR
+ A|A_N|B|D|DOUT0|DOUT7|PH_B6|PH_B9|Q|S|VPB|VPWR pfet L=0.15U W=0.42U
+ AS=0.16655P AD=0.0567P PS=1.39U PD=0.69U
* device instance $1191 r0 *1 129.525,-83.985 pfet
M$1191 SELp5|X \$570 A|A_N|B|D|DOUT0|DOUT7|PH_B6|PH_B9|Q|S|VPB|VPWR
+ A|A_N|B|D|DOUT0|DOUT7|PH_B6|PH_B9|Q|S|VPB|VPWR pfet L=0.15U W=1U AS=0.16655P
+ AD=0.475P PS=1.39U PD=2.95U
* device instance $1192 r0 *1 132.245,-84.065 pfet
M$1192 \$572 A|A_N|B|D|DOUT0|DOUT7|PH_B6|PH_B9|Q|S|VPB|VPWR
+ A|A_N|B|D|DOUT0|DOUT7|PH_B6|PH_B9|Q|S|VPB|VPWR
+ A|A_N|B|D|DOUT0|DOUT7|PH_B6|PH_B9|Q|S|VPB|VPWR pfet L=0.15U W=0.42U
+ AS=0.1176P AD=0.0567P PS=1.4U PD=0.69U
* device instance $1193 r0 *1 132.665,-84.065 pfet
M$1193 \$572 B|Y A|A_N|B|D|DOUT0|DOUT7|PH_B6|PH_B9|Q|S|VPB|VPWR
+ A|A_N|B|D|DOUT0|DOUT7|PH_B6|PH_B9|Q|S|VPB|VPWR pfet L=0.15U W=0.42U
+ AS=0.16655P AD=0.0567P PS=1.39U PD=0.69U
* device instance $1194 r0 *1 133.205,-83.985 pfet
M$1194 SELn0|X \$572 A|A_N|B|D|DOUT0|DOUT7|PH_B6|PH_B9|Q|S|VPB|VPWR
+ A|A_N|B|D|DOUT0|DOUT7|PH_B6|PH_B9|Q|S|VPB|VPWR pfet L=0.15U W=1U AS=0.16655P
+ AD=0.475P PS=1.39U PD=2.95U
* device instance $1195 r0 *1 136.385,-84.065 pfet
M$1195 \$574 A|B|DOUT4 A|A_N|B|D|DOUT0|DOUT7|PH_B6|PH_B9|Q|S|VPB|VPWR
+ A|A_N|B|D|DOUT0|DOUT7|PH_B6|PH_B9|Q|S|VPB|VPWR pfet L=0.15U W=0.42U
+ AS=0.1176P AD=0.0567P PS=1.4U PD=0.69U
* device instance $1196 r0 *1 136.805,-84.065 pfet
M$1196 \$574 B|Y A|A_N|B|D|DOUT0|DOUT7|PH_B6|PH_B9|Q|S|VPB|VPWR
+ A|A_N|B|D|DOUT0|DOUT7|PH_B6|PH_B9|Q|S|VPB|VPWR pfet L=0.15U W=0.42U
+ AS=0.16655P AD=0.0567P PS=1.39U PD=0.69U
* device instance $1197 r0 *1 137.345,-83.985 pfet
M$1197 SELn4|X \$574 A|A_N|B|D|DOUT0|DOUT7|PH_B6|PH_B9|Q|S|VPB|VPWR
+ A|A_N|B|D|DOUT0|DOUT7|PH_B6|PH_B9|Q|S|VPB|VPWR pfet L=0.15U W=1U AS=0.16655P
+ AD=0.475P PS=1.39U PD=2.95U
* device instance $1198 r0 *1 136.545,-26.58 pfet
M$1198 \$598 SELn3|X VREFP VDD pfet L=0.15U W=2U AS=0.94P AD=0.94P PS=4.94U
+ PD=4.94U
* device instance $1199 r0 *1 147.545,-26.58 pfet
M$1199 \$599 SELn4|X VREFP VDD pfet L=0.15U W=2U AS=0.94P AD=0.94P PS=4.94U
+ PD=4.94U
* device instance $1200 r0 *1 158.545,-26.58 pfet
M$1200 \$604 SELn5|X VREFP VDD pfet L=0.15U W=2U AS=0.94P AD=0.94P PS=4.94U
+ PD=4.94U
* device instance $1201 r0 *1 169.545,-26.58 pfet
M$1201 \$603 SELn6|X VREFP VDD pfet L=0.15U W=2U AS=0.94P AD=0.94P PS=4.94U
+ PD=4.94U
* device instance $1202 r0 *1 180.545,-26.58 pfet
M$1202 \$602 SELn7|X VREFP VDD pfet L=0.15U W=2U AS=0.94P AD=0.94P PS=4.94U
+ PD=4.94U
* device instance $1203 r0 *1 191.545,-26.58 pfet
M$1203 \$601 SELn8|X VREFP VDD pfet L=0.15U W=2U AS=0.94P AD=0.94P PS=4.94U
+ PD=4.94U
* device instance $1204 r0 *1 66.495,88.75 pfet
M$1204 BOOST_P \$615 VDD BOOST_P pfet L=0.5U W=1U AS=0.42P AD=0.42P PS=2.84U
+ PD=2.84U
* device instance $1205 r0 *1 69.57,88.75 pfet
M$1205 \$615 \$616 BOOST_P BOOST_P pfet L=0.15U W=1U AS=0.47P AD=0.47P PS=2.94U
+ PD=2.94U
* device instance $1206 r0 *1 74.71,88.75 pfet
M$1206 \$618 \$616 VINP VDD pfet L=0.15U W=1U AS=0.47P AD=0.47P PS=2.94U
+ PD=2.94U
* device instance $1207 r0 *1 77.91,96.25 pfet
M$1207 BPREF_P \$616 VCM VDD pfet L=0.15U W=16U AS=7.52P AD=7.52P PS=32.94U
+ PD=32.94U
* device instance $1208 r0 *1 81.11,89.25 pfet
M$1208 \$616 RESET_B|RST_B|SAMPLE VDD VDD pfet L=0.15U W=2U AS=0.94P AD=0.94P
+ PS=4.94U PD=4.94U
* device instance $1209 r0 *1 84.31,96.25 pfet
M$1209 BPREF_N \$616 VCM VDD pfet L=0.15U W=16U AS=7.52P AD=7.52P PS=32.94U
+ PD=32.94U
* device instance $1210 r0 *1 87.51,88.75 pfet
M$1210 \$620 \$616 VINN VDD pfet L=0.15U W=1U AS=0.47P AD=0.47P PS=2.94U
+ PD=2.94U
* device instance $1211 r0 *1 92.65,88.75 pfet
M$1211 \$621 \$616 BOOST_N BOOST_N pfet L=0.15U W=1U AS=0.47P AD=0.47P PS=2.94U
+ PD=2.94U
* device instance $1212 r0 *1 95.975,88.75 pfet
M$1212 BOOST_N \$621 VDD BOOST_N pfet L=0.5U W=1U AS=0.42P AD=0.42P PS=2.84U
+ PD=2.84U
* device instance $1213 r0 *1 115.07,189.19 pfet
M$1213 OUTP A|A1|OUTN|OUTN_NC VDD VDD pfet L=0.5U W=8U AS=3.36P AD=3.36P
+ PS=16.84U PD=16.84U
* device instance $1214 r0 *1 115.07,198.41 pfet
M$1214 A|A1|OUTN|OUTN_NC OUTP VDD VDD pfet L=0.5U W=8U AS=3.36P AD=3.36P
+ PS=16.84U PD=16.84U
* device instance $1215 r0 *1 118.87,202.41 pfet
M$1215 A|A1|OUTN|OUTN_NC CLK|CLKN|Y VDD VDD pfet L=0.5U W=16U AS=6.72P AD=6.72P
+ PS=32.84U PD=32.84U
* device instance $1216 r0 *1 118.87,185.19 pfet
M$1216 OUTP CLK|CLKN|Y VDD VDD pfet L=0.5U W=16U AS=6.72P AD=6.72P PS=32.84U
+ PD=32.84U
* device instance $1217 r0 *1 123.87,191.19 pfet
M$1217 \$624 CLK|CLKN|Y VDD VDD pfet L=0.5U W=4U AS=1.68P AD=1.68P PS=8.84U
+ PD=8.84U
* device instance $1218 r0 *1 123.87,196.41 pfet
M$1218 \$625 CLK|CLKN|Y VDD VDD pfet L=0.5U W=4U AS=1.68P AD=1.68P PS=8.84U
+ PD=8.84U
* device instance $1219 r0 *1 129.885,68 pfet
M$1219 BOT_OFF_N A|HALF_LSB_EN|X VREFP VDD pfet L=0.15U W=2U AS=0.94P AD=0.94P
+ PS=4.94U PD=4.94U
* device instance $1220 r0 *1 133.085,68 pfet
M$1220 BOT_OFF_N HALF_LSB_ENN|Y VCM VDD pfet L=0.15U W=2U AS=0.94P AD=0.94P
+ PS=4.94U PD=4.94U
* device instance $1221 r0 *1 145.885,68 pfet
M$1221 BOT_OFF_P A|B|BUSY|DOUT2|GND|VGND|VSS VREFP VDD pfet L=0.15U W=2U
+ AS=0.94P AD=0.94P PS=4.94U PD=4.94U
* device instance $1222 r0 *1 149.085,68 pfet
M$1222 BOT_OFF_P A|A_N|B|D|DOUT0|DOUT7|PH_B6|PH_B9|Q|S|VPB|VPWR VCM VDD pfet
+ L=0.15U W=2U AS=0.94P AD=0.94P PS=4.94U PD=4.94U
* device instance $1223 r0 *1 219.95,-126.05 sky130_fd_pr__model__cap_mim
C$1223 A|B|BUSY|DOUT2|GND|VGND|VSS
+ A|A_N|B|D|DOUT0|DOUT7|PH_B6|PH_B9|Q|S|VPB|VPWR 4.434864e-12
* device instance $1224 r0 *1 219.95,-74.05 sky130_fd_pr__model__cap_mim
C$1224 A|B|BUSY|DOUT2|GND|VGND|VSS
+ A|A_N|B|D|DOUT0|DOUT7|PH_B6|PH_B9|Q|S|VPB|VPWR 4.434864e-12
* device instance $1225 r0 *1 0,0.35 sky130_fd_pr__model__cap_mim
C$1225 \$605 TOP_P|VINP 8.664e-15
* device instance $1226 r0 *1 3.4,0.35 sky130_fd_pr__model__cap_mim
C$1226 \$606 TOP_P|VINP 8.664e-15
* device instance $1227 r0 *1 6.8,0.35 sky130_fd_pr__model__cap_mim
C$1227 \$605 TOP_P|VINP 8.664e-15
* device instance $1228 r0 *1 10.2,0.35 sky130_fd_pr__model__cap_mim
C$1228 \$607 TOP_P|VINP 8.664e-15
* device instance $1229 r0 *1 13.6,0.35 sky130_fd_pr__model__cap_mim
C$1229 \$605 TOP_P|VINP 8.664e-15
* device instance $1230 r0 *1 17,0.35 sky130_fd_pr__model__cap_mim
C$1230 \$606 TOP_P|VINP 8.664e-15
* device instance $1231 r0 *1 20.4,0.35 sky130_fd_pr__model__cap_mim
C$1231 \$605 TOP_P|VINP 8.664e-15
* device instance $1232 r0 *1 23.8,0.35 sky130_fd_pr__model__cap_mim
C$1232 \$594 TOP_P|VINP 8.664e-15
* device instance $1233 r0 *1 27.2,0.35 sky130_fd_pr__model__cap_mim
C$1233 \$605 TOP_P|VINP 8.664e-15
* device instance $1234 r0 *1 30.6,0.35 sky130_fd_pr__model__cap_mim
C$1234 \$606 TOP_P|VINP 8.664e-15
* device instance $1235 r0 *1 34,0.35 sky130_fd_pr__model__cap_mim
C$1235 \$605 TOP_P|VINP 8.664e-15
* device instance $1236 r0 *1 37.4,0.35 sky130_fd_pr__model__cap_mim
C$1236 \$607 TOP_P|VINP 8.664e-15
* device instance $1237 r0 *1 40.8,0.35 sky130_fd_pr__model__cap_mim
C$1237 \$605 TOP_P|VINP 8.664e-15
* device instance $1238 r0 *1 44.2,0.35 sky130_fd_pr__model__cap_mim
C$1238 \$606 TOP_P|VINP 8.664e-15
* device instance $1239 r0 *1 47.6,0.35 sky130_fd_pr__model__cap_mim
C$1239 \$605 TOP_P|VINP 8.664e-15
* device instance $1240 r0 *1 51,0.35 sky130_fd_pr__model__cap_mim
C$1240 \$593 TOP_P|VINP 8.664e-15
* device instance $1241 r0 *1 54.4,0.35 sky130_fd_pr__model__cap_mim
C$1241 \$605 TOP_P|VINP 8.664e-15
* device instance $1242 r0 *1 57.8,0.35 sky130_fd_pr__model__cap_mim
C$1242 \$606 TOP_P|VINP 8.664e-15
* device instance $1243 r0 *1 61.2,0.35 sky130_fd_pr__model__cap_mim
C$1243 \$605 TOP_P|VINP 8.664e-15
* device instance $1244 r0 *1 64.6,0.35 sky130_fd_pr__model__cap_mim
C$1244 \$607 TOP_P|VINP 8.664e-15
* device instance $1245 r0 *1 68,0.35 sky130_fd_pr__model__cap_mim
C$1245 \$605 TOP_P|VINP 8.664e-15
* device instance $1246 r0 *1 71.4,0.35 sky130_fd_pr__model__cap_mim
C$1246 \$606 TOP_P|VINP 8.664e-15
* device instance $1247 r0 *1 74.8,0.35 sky130_fd_pr__model__cap_mim
C$1247 \$605 TOP_P|VINP 8.664e-15
* device instance $1248 r0 *1 78.2,0.35 sky130_fd_pr__model__cap_mim
C$1248 \$594 TOP_P|VINP 8.664e-15
* device instance $1249 r0 *1 81.6,0.35 sky130_fd_pr__model__cap_mim
C$1249 \$605 TOP_P|VINP 8.664e-15
* device instance $1250 r0 *1 85,0.35 sky130_fd_pr__model__cap_mim
C$1250 \$606 TOP_P|VINP 8.664e-15
* device instance $1251 r0 *1 88.4,0.35 sky130_fd_pr__model__cap_mim
C$1251 \$605 TOP_P|VINP 8.664e-15
* device instance $1252 r0 *1 91.8,0.35 sky130_fd_pr__model__cap_mim
C$1252 \$607 TOP_P|VINP 8.664e-15
* device instance $1253 r0 *1 95.2,0.35 sky130_fd_pr__model__cap_mim
C$1253 \$605 TOP_P|VINP 8.664e-15
* device instance $1254 r0 *1 98.6,0.35 sky130_fd_pr__model__cap_mim
C$1254 \$606 TOP_P|VINP 8.664e-15
* device instance $1255 r0 *1 102,0.35 sky130_fd_pr__model__cap_mim
C$1255 \$605 TOP_P|VINP 8.664e-15
* device instance $1256 r0 *1 105.4,0.35 sky130_fd_pr__model__cap_mim
C$1256 \$592 TOP_P|VINP 8.664e-15
* device instance $1257 r0 *1 108.8,0.35 sky130_fd_pr__model__cap_mim
C$1257 \$589 TOP_P|VINP 8.664e-15
* device instance $1258 r0 *1 112.2,0.35 sky130_fd_pr__model__cap_mim
C$1258 \$605 TOP_P|VINP 8.664e-15
* device instance $1259 r0 *1 115.6,0.35 sky130_fd_pr__model__cap_mim
C$1259 \$606 TOP_P|VINP 8.664e-15
* device instance $1260 r0 *1 119,0.35 sky130_fd_pr__model__cap_mim
C$1260 \$605 TOP_P|VINP 8.664e-15
* device instance $1261 r0 *1 122.4,0.35 sky130_fd_pr__model__cap_mim
C$1261 \$607 TOP_P|VINP 8.664e-15
* device instance $1262 r0 *1 125.8,0.35 sky130_fd_pr__model__cap_mim
C$1262 \$605 TOP_P|VINP 8.664e-15
* device instance $1263 r0 *1 129.2,0.35 sky130_fd_pr__model__cap_mim
C$1263 \$606 TOP_P|VINP 8.664e-15
* device instance $1264 r0 *1 132.6,0.35 sky130_fd_pr__model__cap_mim
C$1264 \$605 TOP_P|VINP 8.664e-15
* device instance $1265 r0 *1 136,0.35 sky130_fd_pr__model__cap_mim
C$1265 \$594 TOP_P|VINP 8.664e-15
* device instance $1266 r0 *1 139.4,0.35 sky130_fd_pr__model__cap_mim
C$1266 \$605 TOP_P|VINP 8.664e-15
* device instance $1267 r0 *1 142.8,0.35 sky130_fd_pr__model__cap_mim
C$1267 \$606 TOP_P|VINP 8.664e-15
* device instance $1268 r0 *1 146.2,0.35 sky130_fd_pr__model__cap_mim
C$1268 \$605 TOP_P|VINP 8.664e-15
* device instance $1269 r0 *1 149.6,0.35 sky130_fd_pr__model__cap_mim
C$1269 \$607 TOP_P|VINP 8.664e-15
* device instance $1270 r0 *1 153,0.35 sky130_fd_pr__model__cap_mim
C$1270 \$605 TOP_P|VINP 8.664e-15
* device instance $1271 r0 *1 156.4,0.35 sky130_fd_pr__model__cap_mim
C$1271 \$606 TOP_P|VINP 8.664e-15
* device instance $1272 r0 *1 159.8,0.35 sky130_fd_pr__model__cap_mim
C$1272 \$605 TOP_P|VINP 8.664e-15
* device instance $1273 r0 *1 163.2,0.35 sky130_fd_pr__model__cap_mim
C$1273 \$593 TOP_P|VINP 8.664e-15
* device instance $1274 r0 *1 166.6,0.35 sky130_fd_pr__model__cap_mim
C$1274 \$605 TOP_P|VINP 8.664e-15
* device instance $1275 r0 *1 170,0.35 sky130_fd_pr__model__cap_mim
C$1275 \$606 TOP_P|VINP 8.664e-15
* device instance $1276 r0 *1 173.4,0.35 sky130_fd_pr__model__cap_mim
C$1276 \$605 TOP_P|VINP 8.664e-15
* device instance $1277 r0 *1 176.8,0.35 sky130_fd_pr__model__cap_mim
C$1277 \$607 TOP_P|VINP 8.664e-15
* device instance $1278 r0 *1 180.2,0.35 sky130_fd_pr__model__cap_mim
C$1278 \$605 TOP_P|VINP 8.664e-15
* device instance $1279 r0 *1 183.6,0.35 sky130_fd_pr__model__cap_mim
C$1279 \$606 TOP_P|VINP 8.664e-15
* device instance $1280 r0 *1 187,0.35 sky130_fd_pr__model__cap_mim
C$1280 \$605 TOP_P|VINP 8.664e-15
* device instance $1281 r0 *1 190.4,0.35 sky130_fd_pr__model__cap_mim
C$1281 \$594 TOP_P|VINP 8.664e-15
* device instance $1282 r0 *1 193.8,0.35 sky130_fd_pr__model__cap_mim
C$1282 \$605 TOP_P|VINP 8.664e-15
* device instance $1283 r0 *1 197.2,0.35 sky130_fd_pr__model__cap_mim
C$1283 \$606 TOP_P|VINP 8.664e-15
* device instance $1284 r0 *1 200.6,0.35 sky130_fd_pr__model__cap_mim
C$1284 \$605 TOP_P|VINP 8.664e-15
* device instance $1285 r0 *1 204,0.35 sky130_fd_pr__model__cap_mim
C$1285 \$607 TOP_P|VINP 8.664e-15
* device instance $1286 r0 *1 207.4,0.35 sky130_fd_pr__model__cap_mim
C$1286 \$605 TOP_P|VINP 8.664e-15
* device instance $1287 r0 *1 210.8,0.35 sky130_fd_pr__model__cap_mim
C$1287 \$606 TOP_P|VINP 8.664e-15
* device instance $1288 r0 *1 214.2,0.35 sky130_fd_pr__model__cap_mim
C$1288 \$605 TOP_P|VINP 8.664e-15
* device instance $1289 r0 *1 0,3.75 sky130_fd_pr__model__cap_mim
C$1289 \$601 TOP_N|VINN 8.664e-15
* device instance $1290 r0 *1 3.4,3.75 sky130_fd_pr__model__cap_mim
C$1290 \$602 TOP_N|VINN 8.664e-15
* device instance $1291 r0 *1 6.8,3.75 sky130_fd_pr__model__cap_mim
C$1291 \$601 TOP_N|VINN 8.664e-15
* device instance $1292 r0 *1 10.2,3.75 sky130_fd_pr__model__cap_mim
C$1292 \$603 TOP_N|VINN 8.664e-15
* device instance $1293 r0 *1 13.6,3.75 sky130_fd_pr__model__cap_mim
C$1293 \$601 TOP_N|VINN 8.664e-15
* device instance $1294 r0 *1 17,3.75 sky130_fd_pr__model__cap_mim
C$1294 \$602 TOP_N|VINN 8.664e-15
* device instance $1295 r0 *1 20.4,3.75 sky130_fd_pr__model__cap_mim
C$1295 \$601 TOP_N|VINN 8.664e-15
* device instance $1296 r0 *1 23.8,3.75 sky130_fd_pr__model__cap_mim
C$1296 \$604 TOP_N|VINN 8.664e-15
* device instance $1297 r0 *1 27.2,3.75 sky130_fd_pr__model__cap_mim
C$1297 \$601 TOP_N|VINN 8.664e-15
* device instance $1298 r0 *1 30.6,3.75 sky130_fd_pr__model__cap_mim
C$1298 \$602 TOP_N|VINN 8.664e-15
* device instance $1299 r0 *1 34,3.75 sky130_fd_pr__model__cap_mim
C$1299 \$601 TOP_N|VINN 8.664e-15
* device instance $1300 r0 *1 37.4,3.75 sky130_fd_pr__model__cap_mim
C$1300 \$603 TOP_N|VINN 8.664e-15
* device instance $1301 r0 *1 40.8,3.75 sky130_fd_pr__model__cap_mim
C$1301 \$601 TOP_N|VINN 8.664e-15
* device instance $1302 r0 *1 44.2,3.75 sky130_fd_pr__model__cap_mim
C$1302 \$602 TOP_N|VINN 8.664e-15
* device instance $1303 r0 *1 47.6,3.75 sky130_fd_pr__model__cap_mim
C$1303 \$601 TOP_N|VINN 8.664e-15
* device instance $1304 r0 *1 51,3.75 sky130_fd_pr__model__cap_mim
C$1304 \$599 TOP_N|VINN 8.664e-15
* device instance $1305 r0 *1 54.4,3.75 sky130_fd_pr__model__cap_mim
C$1305 \$601 TOP_N|VINN 8.664e-15
* device instance $1306 r0 *1 57.8,3.75 sky130_fd_pr__model__cap_mim
C$1306 \$602 TOP_N|VINN 8.664e-15
* device instance $1307 r0 *1 61.2,3.75 sky130_fd_pr__model__cap_mim
C$1307 \$601 TOP_N|VINN 8.664e-15
* device instance $1308 r0 *1 64.6,3.75 sky130_fd_pr__model__cap_mim
C$1308 \$603 TOP_N|VINN 8.664e-15
* device instance $1309 r0 *1 68,3.75 sky130_fd_pr__model__cap_mim
C$1309 \$601 TOP_N|VINN 8.664e-15
* device instance $1310 r0 *1 71.4,3.75 sky130_fd_pr__model__cap_mim
C$1310 \$602 TOP_N|VINN 8.664e-15
* device instance $1311 r0 *1 74.8,3.75 sky130_fd_pr__model__cap_mim
C$1311 \$601 TOP_N|VINN 8.664e-15
* device instance $1312 r0 *1 78.2,3.75 sky130_fd_pr__model__cap_mim
C$1312 \$604 TOP_N|VINN 8.664e-15
* device instance $1313 r0 *1 81.6,3.75 sky130_fd_pr__model__cap_mim
C$1313 \$601 TOP_N|VINN 8.664e-15
* device instance $1314 r0 *1 85,3.75 sky130_fd_pr__model__cap_mim
C$1314 \$602 TOP_N|VINN 8.664e-15
* device instance $1315 r0 *1 88.4,3.75 sky130_fd_pr__model__cap_mim
C$1315 \$601 TOP_N|VINN 8.664e-15
* device instance $1316 r0 *1 91.8,3.75 sky130_fd_pr__model__cap_mim
C$1316 \$603 TOP_N|VINN 8.664e-15
* device instance $1317 r0 *1 95.2,3.75 sky130_fd_pr__model__cap_mim
C$1317 \$601 TOP_N|VINN 8.664e-15
* device instance $1318 r0 *1 98.6,3.75 sky130_fd_pr__model__cap_mim
C$1318 \$602 TOP_N|VINN 8.664e-15
* device instance $1319 r0 *1 102,3.75 sky130_fd_pr__model__cap_mim
C$1319 \$601 TOP_N|VINN 8.664e-15
* device instance $1320 r0 *1 105.4,3.75 sky130_fd_pr__model__cap_mim
C$1320 \$598 TOP_N|VINN 8.664e-15
* device instance $1321 r0 *1 108.8,3.75 sky130_fd_pr__model__cap_mim
C$1321 \$595 TOP_N|VINN 8.664e-15
* device instance $1322 r0 *1 112.2,3.75 sky130_fd_pr__model__cap_mim
C$1322 \$601 TOP_N|VINN 8.664e-15
* device instance $1323 r0 *1 115.6,3.75 sky130_fd_pr__model__cap_mim
C$1323 \$602 TOP_N|VINN 8.664e-15
* device instance $1324 r0 *1 119,3.75 sky130_fd_pr__model__cap_mim
C$1324 \$601 TOP_N|VINN 8.664e-15
* device instance $1325 r0 *1 122.4,3.75 sky130_fd_pr__model__cap_mim
C$1325 \$603 TOP_N|VINN 8.664e-15
* device instance $1326 r0 *1 125.8,3.75 sky130_fd_pr__model__cap_mim
C$1326 \$601 TOP_N|VINN 8.664e-15
* device instance $1327 r0 *1 129.2,3.75 sky130_fd_pr__model__cap_mim
C$1327 \$602 TOP_N|VINN 8.664e-15
* device instance $1328 r0 *1 132.6,3.75 sky130_fd_pr__model__cap_mim
C$1328 \$601 TOP_N|VINN 8.664e-15
* device instance $1329 r0 *1 136,3.75 sky130_fd_pr__model__cap_mim
C$1329 \$604 TOP_N|VINN 8.664e-15
* device instance $1330 r0 *1 139.4,3.75 sky130_fd_pr__model__cap_mim
C$1330 \$601 TOP_N|VINN 8.664e-15
* device instance $1331 r0 *1 142.8,3.75 sky130_fd_pr__model__cap_mim
C$1331 \$602 TOP_N|VINN 8.664e-15
* device instance $1332 r0 *1 146.2,3.75 sky130_fd_pr__model__cap_mim
C$1332 \$601 TOP_N|VINN 8.664e-15
* device instance $1333 r0 *1 149.6,3.75 sky130_fd_pr__model__cap_mim
C$1333 \$603 TOP_N|VINN 8.664e-15
* device instance $1334 r0 *1 153,3.75 sky130_fd_pr__model__cap_mim
C$1334 \$601 TOP_N|VINN 8.664e-15
* device instance $1335 r0 *1 156.4,3.75 sky130_fd_pr__model__cap_mim
C$1335 \$602 TOP_N|VINN 8.664e-15
* device instance $1336 r0 *1 159.8,3.75 sky130_fd_pr__model__cap_mim
C$1336 \$601 TOP_N|VINN 8.664e-15
* device instance $1337 r0 *1 163.2,3.75 sky130_fd_pr__model__cap_mim
C$1337 \$599 TOP_N|VINN 8.664e-15
* device instance $1338 r0 *1 166.6,3.75 sky130_fd_pr__model__cap_mim
C$1338 \$601 TOP_N|VINN 8.664e-15
* device instance $1339 r0 *1 170,3.75 sky130_fd_pr__model__cap_mim
C$1339 \$602 TOP_N|VINN 8.664e-15
* device instance $1340 r0 *1 173.4,3.75 sky130_fd_pr__model__cap_mim
C$1340 \$601 TOP_N|VINN 8.664e-15
* device instance $1341 r0 *1 176.8,3.75 sky130_fd_pr__model__cap_mim
C$1341 \$603 TOP_N|VINN 8.664e-15
* device instance $1342 r0 *1 180.2,3.75 sky130_fd_pr__model__cap_mim
C$1342 \$601 TOP_N|VINN 8.664e-15
* device instance $1343 r0 *1 183.6,3.75 sky130_fd_pr__model__cap_mim
C$1343 \$602 TOP_N|VINN 8.664e-15
* device instance $1344 r0 *1 187,3.75 sky130_fd_pr__model__cap_mim
C$1344 \$601 TOP_N|VINN 8.664e-15
* device instance $1345 r0 *1 190.4,3.75 sky130_fd_pr__model__cap_mim
C$1345 \$604 TOP_N|VINN 8.664e-15
* device instance $1346 r0 *1 193.8,3.75 sky130_fd_pr__model__cap_mim
C$1346 \$601 TOP_N|VINN 8.664e-15
* device instance $1347 r0 *1 197.2,3.75 sky130_fd_pr__model__cap_mim
C$1347 \$602 TOP_N|VINN 8.664e-15
* device instance $1348 r0 *1 200.6,3.75 sky130_fd_pr__model__cap_mim
C$1348 \$601 TOP_N|VINN 8.664e-15
* device instance $1349 r0 *1 204,3.75 sky130_fd_pr__model__cap_mim
C$1349 \$603 TOP_N|VINN 8.664e-15
* device instance $1350 r0 *1 207.4,3.75 sky130_fd_pr__model__cap_mim
C$1350 \$601 TOP_N|VINN 8.664e-15
* device instance $1351 r0 *1 210.8,3.75 sky130_fd_pr__model__cap_mim
C$1351 \$602 TOP_N|VINN 8.664e-15
* device instance $1352 r0 *1 214.2,3.75 sky130_fd_pr__model__cap_mim
C$1352 \$601 TOP_N|VINN 8.664e-15
* device instance $1353 r0 *1 0,7.15 sky130_fd_pr__model__cap_mim
C$1353 \$605 TOP_P|VINP 8.664e-15
* device instance $1354 r0 *1 3.4,7.15 sky130_fd_pr__model__cap_mim
C$1354 \$606 TOP_P|VINP 8.664e-15
* device instance $1355 r0 *1 6.8,7.15 sky130_fd_pr__model__cap_mim
C$1355 \$605 TOP_P|VINP 8.664e-15
* device instance $1356 r0 *1 10.2,7.15 sky130_fd_pr__model__cap_mim
C$1356 \$607 TOP_P|VINP 8.664e-15
* device instance $1357 r0 *1 13.6,7.15 sky130_fd_pr__model__cap_mim
C$1357 \$605 TOP_P|VINP 8.664e-15
* device instance $1358 r0 *1 17,7.15 sky130_fd_pr__model__cap_mim
C$1358 \$606 TOP_P|VINP 8.664e-15
* device instance $1359 r0 *1 20.4,7.15 sky130_fd_pr__model__cap_mim
C$1359 \$605 TOP_P|VINP 8.664e-15
* device instance $1360 r0 *1 23.8,7.15 sky130_fd_pr__model__cap_mim
C$1360 \$594 TOP_P|VINP 8.664e-15
* device instance $1361 r0 *1 27.2,7.15 sky130_fd_pr__model__cap_mim
C$1361 \$605 TOP_P|VINP 8.664e-15
* device instance $1362 r0 *1 30.6,7.15 sky130_fd_pr__model__cap_mim
C$1362 \$606 TOP_P|VINP 8.664e-15
* device instance $1363 r0 *1 34,7.15 sky130_fd_pr__model__cap_mim
C$1363 \$605 TOP_P|VINP 8.664e-15
* device instance $1364 r0 *1 37.4,7.15 sky130_fd_pr__model__cap_mim
C$1364 \$607 TOP_P|VINP 8.664e-15
* device instance $1365 r0 *1 40.8,7.15 sky130_fd_pr__model__cap_mim
C$1365 \$605 TOP_P|VINP 8.664e-15
* device instance $1366 r0 *1 44.2,7.15 sky130_fd_pr__model__cap_mim
C$1366 \$606 TOP_P|VINP 8.664e-15
* device instance $1367 r0 *1 47.6,7.15 sky130_fd_pr__model__cap_mim
C$1367 \$605 TOP_P|VINP 8.664e-15
* device instance $1368 r0 *1 51,7.15 sky130_fd_pr__model__cap_mim
C$1368 \$593 TOP_P|VINP 8.664e-15
* device instance $1369 r0 *1 54.4,7.15 sky130_fd_pr__model__cap_mim
C$1369 \$605 TOP_P|VINP 8.664e-15
* device instance $1370 r0 *1 57.8,7.15 sky130_fd_pr__model__cap_mim
C$1370 \$606 TOP_P|VINP 8.664e-15
* device instance $1371 r0 *1 61.2,7.15 sky130_fd_pr__model__cap_mim
C$1371 \$605 TOP_P|VINP 8.664e-15
* device instance $1372 r0 *1 64.6,7.15 sky130_fd_pr__model__cap_mim
C$1372 \$607 TOP_P|VINP 8.664e-15
* device instance $1373 r0 *1 68,7.15 sky130_fd_pr__model__cap_mim
C$1373 \$605 TOP_P|VINP 8.664e-15
* device instance $1374 r0 *1 71.4,7.15 sky130_fd_pr__model__cap_mim
C$1374 \$606 TOP_P|VINP 8.664e-15
* device instance $1375 r0 *1 74.8,7.15 sky130_fd_pr__model__cap_mim
C$1375 \$605 TOP_P|VINP 8.664e-15
* device instance $1376 r0 *1 78.2,7.15 sky130_fd_pr__model__cap_mim
C$1376 \$594 TOP_P|VINP 8.664e-15
* device instance $1377 r0 *1 81.6,7.15 sky130_fd_pr__model__cap_mim
C$1377 \$605 TOP_P|VINP 8.664e-15
* device instance $1378 r0 *1 85,7.15 sky130_fd_pr__model__cap_mim
C$1378 \$606 TOP_P|VINP 8.664e-15
* device instance $1379 r0 *1 88.4,7.15 sky130_fd_pr__model__cap_mim
C$1379 \$605 TOP_P|VINP 8.664e-15
* device instance $1380 r0 *1 91.8,7.15 sky130_fd_pr__model__cap_mim
C$1380 \$607 TOP_P|VINP 8.664e-15
* device instance $1381 r0 *1 95.2,7.15 sky130_fd_pr__model__cap_mim
C$1381 \$605 TOP_P|VINP 8.664e-15
* device instance $1382 r0 *1 98.6,7.15 sky130_fd_pr__model__cap_mim
C$1382 \$606 TOP_P|VINP 8.664e-15
* device instance $1383 r0 *1 102,7.15 sky130_fd_pr__model__cap_mim
C$1383 \$605 TOP_P|VINP 8.664e-15
* device instance $1384 r0 *1 105.4,7.15 sky130_fd_pr__model__cap_mim
C$1384 \$592 TOP_P|VINP 8.664e-15
* device instance $1385 r0 *1 108.8,7.15 sky130_fd_pr__model__cap_mim
C$1385 \$591 TOP_P|VINP 8.664e-15
* device instance $1386 r0 *1 112.2,7.15 sky130_fd_pr__model__cap_mim
C$1386 \$605 TOP_P|VINP 8.664e-15
* device instance $1387 r0 *1 115.6,7.15 sky130_fd_pr__model__cap_mim
C$1387 \$606 TOP_P|VINP 8.664e-15
* device instance $1388 r0 *1 119,7.15 sky130_fd_pr__model__cap_mim
C$1388 \$605 TOP_P|VINP 8.664e-15
* device instance $1389 r0 *1 122.4,7.15 sky130_fd_pr__model__cap_mim
C$1389 \$607 TOP_P|VINP 8.664e-15
* device instance $1390 r0 *1 125.8,7.15 sky130_fd_pr__model__cap_mim
C$1390 \$605 TOP_P|VINP 8.664e-15
* device instance $1391 r0 *1 129.2,7.15 sky130_fd_pr__model__cap_mim
C$1391 \$606 TOP_P|VINP 8.664e-15
* device instance $1392 r0 *1 132.6,7.15 sky130_fd_pr__model__cap_mim
C$1392 \$605 TOP_P|VINP 8.664e-15
* device instance $1393 r0 *1 136,7.15 sky130_fd_pr__model__cap_mim
C$1393 \$594 TOP_P|VINP 8.664e-15
* device instance $1394 r0 *1 139.4,7.15 sky130_fd_pr__model__cap_mim
C$1394 \$605 TOP_P|VINP 8.664e-15
* device instance $1395 r0 *1 142.8,7.15 sky130_fd_pr__model__cap_mim
C$1395 \$606 TOP_P|VINP 8.664e-15
* device instance $1396 r0 *1 146.2,7.15 sky130_fd_pr__model__cap_mim
C$1396 \$605 TOP_P|VINP 8.664e-15
* device instance $1397 r0 *1 149.6,7.15 sky130_fd_pr__model__cap_mim
C$1397 \$607 TOP_P|VINP 8.664e-15
* device instance $1398 r0 *1 153,7.15 sky130_fd_pr__model__cap_mim
C$1398 \$605 TOP_P|VINP 8.664e-15
* device instance $1399 r0 *1 156.4,7.15 sky130_fd_pr__model__cap_mim
C$1399 \$606 TOP_P|VINP 8.664e-15
* device instance $1400 r0 *1 159.8,7.15 sky130_fd_pr__model__cap_mim
C$1400 \$605 TOP_P|VINP 8.664e-15
* device instance $1401 r0 *1 163.2,7.15 sky130_fd_pr__model__cap_mim
C$1401 \$593 TOP_P|VINP 8.664e-15
* device instance $1402 r0 *1 166.6,7.15 sky130_fd_pr__model__cap_mim
C$1402 \$605 TOP_P|VINP 8.664e-15
* device instance $1403 r0 *1 170,7.15 sky130_fd_pr__model__cap_mim
C$1403 \$606 TOP_P|VINP 8.664e-15
* device instance $1404 r0 *1 173.4,7.15 sky130_fd_pr__model__cap_mim
C$1404 \$605 TOP_P|VINP 8.664e-15
* device instance $1405 r0 *1 176.8,7.15 sky130_fd_pr__model__cap_mim
C$1405 \$607 TOP_P|VINP 8.664e-15
* device instance $1406 r0 *1 180.2,7.15 sky130_fd_pr__model__cap_mim
C$1406 \$605 TOP_P|VINP 8.664e-15
* device instance $1407 r0 *1 183.6,7.15 sky130_fd_pr__model__cap_mim
C$1407 \$606 TOP_P|VINP 8.664e-15
* device instance $1408 r0 *1 187,7.15 sky130_fd_pr__model__cap_mim
C$1408 \$605 TOP_P|VINP 8.664e-15
* device instance $1409 r0 *1 190.4,7.15 sky130_fd_pr__model__cap_mim
C$1409 \$594 TOP_P|VINP 8.664e-15
* device instance $1410 r0 *1 193.8,7.15 sky130_fd_pr__model__cap_mim
C$1410 \$605 TOP_P|VINP 8.664e-15
* device instance $1411 r0 *1 197.2,7.15 sky130_fd_pr__model__cap_mim
C$1411 \$606 TOP_P|VINP 8.664e-15
* device instance $1412 r0 *1 200.6,7.15 sky130_fd_pr__model__cap_mim
C$1412 \$605 TOP_P|VINP 8.664e-15
* device instance $1413 r0 *1 204,7.15 sky130_fd_pr__model__cap_mim
C$1413 \$607 TOP_P|VINP 8.664e-15
* device instance $1414 r0 *1 207.4,7.15 sky130_fd_pr__model__cap_mim
C$1414 \$605 TOP_P|VINP 8.664e-15
* device instance $1415 r0 *1 210.8,7.15 sky130_fd_pr__model__cap_mim
C$1415 \$606 TOP_P|VINP 8.664e-15
* device instance $1416 r0 *1 214.2,7.15 sky130_fd_pr__model__cap_mim
C$1416 \$605 TOP_P|VINP 8.664e-15
* device instance $1417 r0 *1 0,10.55 sky130_fd_pr__model__cap_mim
C$1417 \$601 TOP_N|VINN 8.664e-15
* device instance $1418 r0 *1 3.4,10.55 sky130_fd_pr__model__cap_mim
C$1418 \$602 TOP_N|VINN 8.664e-15
* device instance $1419 r0 *1 6.8,10.55 sky130_fd_pr__model__cap_mim
C$1419 \$601 TOP_N|VINN 8.664e-15
* device instance $1420 r0 *1 10.2,10.55 sky130_fd_pr__model__cap_mim
C$1420 \$603 TOP_N|VINN 8.664e-15
* device instance $1421 r0 *1 13.6,10.55 sky130_fd_pr__model__cap_mim
C$1421 \$601 TOP_N|VINN 8.664e-15
* device instance $1422 r0 *1 17,10.55 sky130_fd_pr__model__cap_mim
C$1422 \$602 TOP_N|VINN 8.664e-15
* device instance $1423 r0 *1 20.4,10.55 sky130_fd_pr__model__cap_mim
C$1423 \$601 TOP_N|VINN 8.664e-15
* device instance $1424 r0 *1 23.8,10.55 sky130_fd_pr__model__cap_mim
C$1424 \$604 TOP_N|VINN 8.664e-15
* device instance $1425 r0 *1 27.2,10.55 sky130_fd_pr__model__cap_mim
C$1425 \$601 TOP_N|VINN 8.664e-15
* device instance $1426 r0 *1 30.6,10.55 sky130_fd_pr__model__cap_mim
C$1426 \$602 TOP_N|VINN 8.664e-15
* device instance $1427 r0 *1 34,10.55 sky130_fd_pr__model__cap_mim
C$1427 \$601 TOP_N|VINN 8.664e-15
* device instance $1428 r0 *1 37.4,10.55 sky130_fd_pr__model__cap_mim
C$1428 \$603 TOP_N|VINN 8.664e-15
* device instance $1429 r0 *1 40.8,10.55 sky130_fd_pr__model__cap_mim
C$1429 \$601 TOP_N|VINN 8.664e-15
* device instance $1430 r0 *1 44.2,10.55 sky130_fd_pr__model__cap_mim
C$1430 \$602 TOP_N|VINN 8.664e-15
* device instance $1431 r0 *1 47.6,10.55 sky130_fd_pr__model__cap_mim
C$1431 \$601 TOP_N|VINN 8.664e-15
* device instance $1432 r0 *1 51,10.55 sky130_fd_pr__model__cap_mim
C$1432 \$599 TOP_N|VINN 8.664e-15
* device instance $1433 r0 *1 54.4,10.55 sky130_fd_pr__model__cap_mim
C$1433 \$601 TOP_N|VINN 8.664e-15
* device instance $1434 r0 *1 57.8,10.55 sky130_fd_pr__model__cap_mim
C$1434 \$602 TOP_N|VINN 8.664e-15
* device instance $1435 r0 *1 61.2,10.55 sky130_fd_pr__model__cap_mim
C$1435 \$601 TOP_N|VINN 8.664e-15
* device instance $1436 r0 *1 64.6,10.55 sky130_fd_pr__model__cap_mim
C$1436 \$603 TOP_N|VINN 8.664e-15
* device instance $1437 r0 *1 68,10.55 sky130_fd_pr__model__cap_mim
C$1437 \$601 TOP_N|VINN 8.664e-15
* device instance $1438 r0 *1 71.4,10.55 sky130_fd_pr__model__cap_mim
C$1438 \$602 TOP_N|VINN 8.664e-15
* device instance $1439 r0 *1 74.8,10.55 sky130_fd_pr__model__cap_mim
C$1439 \$601 TOP_N|VINN 8.664e-15
* device instance $1440 r0 *1 78.2,10.55 sky130_fd_pr__model__cap_mim
C$1440 \$604 TOP_N|VINN 8.664e-15
* device instance $1441 r0 *1 81.6,10.55 sky130_fd_pr__model__cap_mim
C$1441 \$601 TOP_N|VINN 8.664e-15
* device instance $1442 r0 *1 85,10.55 sky130_fd_pr__model__cap_mim
C$1442 \$602 TOP_N|VINN 8.664e-15
* device instance $1443 r0 *1 88.4,10.55 sky130_fd_pr__model__cap_mim
C$1443 \$601 TOP_N|VINN 8.664e-15
* device instance $1444 r0 *1 91.8,10.55 sky130_fd_pr__model__cap_mim
C$1444 \$603 TOP_N|VINN 8.664e-15
* device instance $1445 r0 *1 95.2,10.55 sky130_fd_pr__model__cap_mim
C$1445 \$601 TOP_N|VINN 8.664e-15
* device instance $1446 r0 *1 98.6,10.55 sky130_fd_pr__model__cap_mim
C$1446 \$602 TOP_N|VINN 8.664e-15
* device instance $1447 r0 *1 102,10.55 sky130_fd_pr__model__cap_mim
C$1447 \$601 TOP_N|VINN 8.664e-15
* device instance $1448 r0 *1 105.4,10.55 sky130_fd_pr__model__cap_mim
C$1448 \$598 TOP_N|VINN 8.664e-15
* device instance $1449 r0 *1 108.8,10.55 sky130_fd_pr__model__cap_mim
C$1449 \$597 TOP_N|VINN 8.664e-15
* device instance $1450 r0 *1 112.2,10.55 sky130_fd_pr__model__cap_mim
C$1450 \$601 TOP_N|VINN 8.664e-15
* device instance $1451 r0 *1 115.6,10.55 sky130_fd_pr__model__cap_mim
C$1451 \$602 TOP_N|VINN 8.664e-15
* device instance $1452 r0 *1 119,10.55 sky130_fd_pr__model__cap_mim
C$1452 \$601 TOP_N|VINN 8.664e-15
* device instance $1453 r0 *1 122.4,10.55 sky130_fd_pr__model__cap_mim
C$1453 \$603 TOP_N|VINN 8.664e-15
* device instance $1454 r0 *1 125.8,10.55 sky130_fd_pr__model__cap_mim
C$1454 \$601 TOP_N|VINN 8.664e-15
* device instance $1455 r0 *1 129.2,10.55 sky130_fd_pr__model__cap_mim
C$1455 \$602 TOP_N|VINN 8.664e-15
* device instance $1456 r0 *1 132.6,10.55 sky130_fd_pr__model__cap_mim
C$1456 \$601 TOP_N|VINN 8.664e-15
* device instance $1457 r0 *1 136,10.55 sky130_fd_pr__model__cap_mim
C$1457 \$604 TOP_N|VINN 8.664e-15
* device instance $1458 r0 *1 139.4,10.55 sky130_fd_pr__model__cap_mim
C$1458 \$601 TOP_N|VINN 8.664e-15
* device instance $1459 r0 *1 142.8,10.55 sky130_fd_pr__model__cap_mim
C$1459 \$602 TOP_N|VINN 8.664e-15
* device instance $1460 r0 *1 146.2,10.55 sky130_fd_pr__model__cap_mim
C$1460 \$601 TOP_N|VINN 8.664e-15
* device instance $1461 r0 *1 149.6,10.55 sky130_fd_pr__model__cap_mim
C$1461 \$603 TOP_N|VINN 8.664e-15
* device instance $1462 r0 *1 153,10.55 sky130_fd_pr__model__cap_mim
C$1462 \$601 TOP_N|VINN 8.664e-15
* device instance $1463 r0 *1 156.4,10.55 sky130_fd_pr__model__cap_mim
C$1463 \$602 TOP_N|VINN 8.664e-15
* device instance $1464 r0 *1 159.8,10.55 sky130_fd_pr__model__cap_mim
C$1464 \$601 TOP_N|VINN 8.664e-15
* device instance $1465 r0 *1 163.2,10.55 sky130_fd_pr__model__cap_mim
C$1465 \$599 TOP_N|VINN 8.664e-15
* device instance $1466 r0 *1 166.6,10.55 sky130_fd_pr__model__cap_mim
C$1466 \$601 TOP_N|VINN 8.664e-15
* device instance $1467 r0 *1 170,10.55 sky130_fd_pr__model__cap_mim
C$1467 \$602 TOP_N|VINN 8.664e-15
* device instance $1468 r0 *1 173.4,10.55 sky130_fd_pr__model__cap_mim
C$1468 \$601 TOP_N|VINN 8.664e-15
* device instance $1469 r0 *1 176.8,10.55 sky130_fd_pr__model__cap_mim
C$1469 \$603 TOP_N|VINN 8.664e-15
* device instance $1470 r0 *1 180.2,10.55 sky130_fd_pr__model__cap_mim
C$1470 \$601 TOP_N|VINN 8.664e-15
* device instance $1471 r0 *1 183.6,10.55 sky130_fd_pr__model__cap_mim
C$1471 \$602 TOP_N|VINN 8.664e-15
* device instance $1472 r0 *1 187,10.55 sky130_fd_pr__model__cap_mim
C$1472 \$601 TOP_N|VINN 8.664e-15
* device instance $1473 r0 *1 190.4,10.55 sky130_fd_pr__model__cap_mim
C$1473 \$604 TOP_N|VINN 8.664e-15
* device instance $1474 r0 *1 193.8,10.55 sky130_fd_pr__model__cap_mim
C$1474 \$601 TOP_N|VINN 8.664e-15
* device instance $1475 r0 *1 197.2,10.55 sky130_fd_pr__model__cap_mim
C$1475 \$602 TOP_N|VINN 8.664e-15
* device instance $1476 r0 *1 200.6,10.55 sky130_fd_pr__model__cap_mim
C$1476 \$601 TOP_N|VINN 8.664e-15
* device instance $1477 r0 *1 204,10.55 sky130_fd_pr__model__cap_mim
C$1477 \$603 TOP_N|VINN 8.664e-15
* device instance $1478 r0 *1 207.4,10.55 sky130_fd_pr__model__cap_mim
C$1478 \$601 TOP_N|VINN 8.664e-15
* device instance $1479 r0 *1 210.8,10.55 sky130_fd_pr__model__cap_mim
C$1479 \$602 TOP_N|VINN 8.664e-15
* device instance $1480 r0 *1 214.2,10.55 sky130_fd_pr__model__cap_mim
C$1480 \$601 TOP_N|VINN 8.664e-15
* device instance $1481 r0 *1 0,13.95 sky130_fd_pr__model__cap_mim
C$1481 \$605 TOP_P|VINP 8.664e-15
* device instance $1482 r0 *1 3.4,13.95 sky130_fd_pr__model__cap_mim
C$1482 \$606 TOP_P|VINP 8.664e-15
* device instance $1483 r0 *1 6.8,13.95 sky130_fd_pr__model__cap_mim
C$1483 \$605 TOP_P|VINP 8.664e-15
* device instance $1484 r0 *1 10.2,13.95 sky130_fd_pr__model__cap_mim
C$1484 \$607 TOP_P|VINP 8.664e-15
* device instance $1485 r0 *1 13.6,13.95 sky130_fd_pr__model__cap_mim
C$1485 \$605 TOP_P|VINP 8.664e-15
* device instance $1486 r0 *1 17,13.95 sky130_fd_pr__model__cap_mim
C$1486 \$606 TOP_P|VINP 8.664e-15
* device instance $1487 r0 *1 20.4,13.95 sky130_fd_pr__model__cap_mim
C$1487 \$605 TOP_P|VINP 8.664e-15
* device instance $1488 r0 *1 23.8,13.95 sky130_fd_pr__model__cap_mim
C$1488 \$594 TOP_P|VINP 8.664e-15
* device instance $1489 r0 *1 27.2,13.95 sky130_fd_pr__model__cap_mim
C$1489 \$605 TOP_P|VINP 8.664e-15
* device instance $1490 r0 *1 30.6,13.95 sky130_fd_pr__model__cap_mim
C$1490 \$606 TOP_P|VINP 8.664e-15
* device instance $1491 r0 *1 34,13.95 sky130_fd_pr__model__cap_mim
C$1491 \$605 TOP_P|VINP 8.664e-15
* device instance $1492 r0 *1 37.4,13.95 sky130_fd_pr__model__cap_mim
C$1492 \$607 TOP_P|VINP 8.664e-15
* device instance $1493 r0 *1 40.8,13.95 sky130_fd_pr__model__cap_mim
C$1493 \$605 TOP_P|VINP 8.664e-15
* device instance $1494 r0 *1 44.2,13.95 sky130_fd_pr__model__cap_mim
C$1494 \$606 TOP_P|VINP 8.664e-15
* device instance $1495 r0 *1 47.6,13.95 sky130_fd_pr__model__cap_mim
C$1495 \$605 TOP_P|VINP 8.664e-15
* device instance $1496 r0 *1 51,13.95 sky130_fd_pr__model__cap_mim
C$1496 \$593 TOP_P|VINP 8.664e-15
* device instance $1497 r0 *1 54.4,13.95 sky130_fd_pr__model__cap_mim
C$1497 \$605 TOP_P|VINP 8.664e-15
* device instance $1498 r0 *1 57.8,13.95 sky130_fd_pr__model__cap_mim
C$1498 \$606 TOP_P|VINP 8.664e-15
* device instance $1499 r0 *1 61.2,13.95 sky130_fd_pr__model__cap_mim
C$1499 \$605 TOP_P|VINP 8.664e-15
* device instance $1500 r0 *1 64.6,13.95 sky130_fd_pr__model__cap_mim
C$1500 \$607 TOP_P|VINP 8.664e-15
* device instance $1501 r0 *1 68,13.95 sky130_fd_pr__model__cap_mim
C$1501 \$605 TOP_P|VINP 8.664e-15
* device instance $1502 r0 *1 71.4,13.95 sky130_fd_pr__model__cap_mim
C$1502 \$606 TOP_P|VINP 8.664e-15
* device instance $1503 r0 *1 74.8,13.95 sky130_fd_pr__model__cap_mim
C$1503 \$605 TOP_P|VINP 8.664e-15
* device instance $1504 r0 *1 78.2,13.95 sky130_fd_pr__model__cap_mim
C$1504 \$594 TOP_P|VINP 8.664e-15
* device instance $1505 r0 *1 81.6,13.95 sky130_fd_pr__model__cap_mim
C$1505 \$605 TOP_P|VINP 8.664e-15
* device instance $1506 r0 *1 85,13.95 sky130_fd_pr__model__cap_mim
C$1506 \$606 TOP_P|VINP 8.664e-15
* device instance $1507 r0 *1 88.4,13.95 sky130_fd_pr__model__cap_mim
C$1507 \$605 TOP_P|VINP 8.664e-15
* device instance $1508 r0 *1 91.8,13.95 sky130_fd_pr__model__cap_mim
C$1508 \$607 TOP_P|VINP 8.664e-15
* device instance $1509 r0 *1 95.2,13.95 sky130_fd_pr__model__cap_mim
C$1509 \$605 TOP_P|VINP 8.664e-15
* device instance $1510 r0 *1 98.6,13.95 sky130_fd_pr__model__cap_mim
C$1510 \$606 TOP_P|VINP 8.664e-15
* device instance $1511 r0 *1 102,13.95 sky130_fd_pr__model__cap_mim
C$1511 \$605 TOP_P|VINP 8.664e-15
* device instance $1512 r0 *1 105.4,13.95 sky130_fd_pr__model__cap_mim
C$1512 \$592 TOP_P|VINP 8.664e-15
* device instance $1513 r0 *1 108.8,13.95 sky130_fd_pr__model__cap_mim
C$1513 \$590 TOP_P|VINP 8.664e-15
* device instance $1514 r0 *1 112.2,13.95 sky130_fd_pr__model__cap_mim
C$1514 \$605 TOP_P|VINP 8.664e-15
* device instance $1515 r0 *1 115.6,13.95 sky130_fd_pr__model__cap_mim
C$1515 \$606 TOP_P|VINP 8.664e-15
* device instance $1516 r0 *1 119,13.95 sky130_fd_pr__model__cap_mim
C$1516 \$605 TOP_P|VINP 8.664e-15
* device instance $1517 r0 *1 122.4,13.95 sky130_fd_pr__model__cap_mim
C$1517 \$607 TOP_P|VINP 8.664e-15
* device instance $1518 r0 *1 125.8,13.95 sky130_fd_pr__model__cap_mim
C$1518 \$605 TOP_P|VINP 8.664e-15
* device instance $1519 r0 *1 129.2,13.95 sky130_fd_pr__model__cap_mim
C$1519 \$606 TOP_P|VINP 8.664e-15
* device instance $1520 r0 *1 132.6,13.95 sky130_fd_pr__model__cap_mim
C$1520 \$605 TOP_P|VINP 8.664e-15
* device instance $1521 r0 *1 136,13.95 sky130_fd_pr__model__cap_mim
C$1521 \$594 TOP_P|VINP 8.664e-15
* device instance $1522 r0 *1 139.4,13.95 sky130_fd_pr__model__cap_mim
C$1522 \$605 TOP_P|VINP 8.664e-15
* device instance $1523 r0 *1 142.8,13.95 sky130_fd_pr__model__cap_mim
C$1523 \$606 TOP_P|VINP 8.664e-15
* device instance $1524 r0 *1 146.2,13.95 sky130_fd_pr__model__cap_mim
C$1524 \$605 TOP_P|VINP 8.664e-15
* device instance $1525 r0 *1 149.6,13.95 sky130_fd_pr__model__cap_mim
C$1525 \$607 TOP_P|VINP 8.664e-15
* device instance $1526 r0 *1 153,13.95 sky130_fd_pr__model__cap_mim
C$1526 \$605 TOP_P|VINP 8.664e-15
* device instance $1527 r0 *1 156.4,13.95 sky130_fd_pr__model__cap_mim
C$1527 \$606 TOP_P|VINP 8.664e-15
* device instance $1528 r0 *1 159.8,13.95 sky130_fd_pr__model__cap_mim
C$1528 \$605 TOP_P|VINP 8.664e-15
* device instance $1529 r0 *1 163.2,13.95 sky130_fd_pr__model__cap_mim
C$1529 \$593 TOP_P|VINP 8.664e-15
* device instance $1530 r0 *1 166.6,13.95 sky130_fd_pr__model__cap_mim
C$1530 \$605 TOP_P|VINP 8.664e-15
* device instance $1531 r0 *1 170,13.95 sky130_fd_pr__model__cap_mim
C$1531 \$606 TOP_P|VINP 8.664e-15
* device instance $1532 r0 *1 173.4,13.95 sky130_fd_pr__model__cap_mim
C$1532 \$605 TOP_P|VINP 8.664e-15
* device instance $1533 r0 *1 176.8,13.95 sky130_fd_pr__model__cap_mim
C$1533 \$607 TOP_P|VINP 8.664e-15
* device instance $1534 r0 *1 180.2,13.95 sky130_fd_pr__model__cap_mim
C$1534 \$605 TOP_P|VINP 8.664e-15
* device instance $1535 r0 *1 183.6,13.95 sky130_fd_pr__model__cap_mim
C$1535 \$606 TOP_P|VINP 8.664e-15
* device instance $1536 r0 *1 187,13.95 sky130_fd_pr__model__cap_mim
C$1536 \$605 TOP_P|VINP 8.664e-15
* device instance $1537 r0 *1 190.4,13.95 sky130_fd_pr__model__cap_mim
C$1537 \$594 TOP_P|VINP 8.664e-15
* device instance $1538 r0 *1 193.8,13.95 sky130_fd_pr__model__cap_mim
C$1538 \$605 TOP_P|VINP 8.664e-15
* device instance $1539 r0 *1 197.2,13.95 sky130_fd_pr__model__cap_mim
C$1539 \$606 TOP_P|VINP 8.664e-15
* device instance $1540 r0 *1 200.6,13.95 sky130_fd_pr__model__cap_mim
C$1540 \$605 TOP_P|VINP 8.664e-15
* device instance $1541 r0 *1 204,13.95 sky130_fd_pr__model__cap_mim
C$1541 \$607 TOP_P|VINP 8.664e-15
* device instance $1542 r0 *1 207.4,13.95 sky130_fd_pr__model__cap_mim
C$1542 \$605 TOP_P|VINP 8.664e-15
* device instance $1543 r0 *1 210.8,13.95 sky130_fd_pr__model__cap_mim
C$1543 \$606 TOP_P|VINP 8.664e-15
* device instance $1544 r0 *1 214.2,13.95 sky130_fd_pr__model__cap_mim
C$1544 \$605 TOP_P|VINP 8.664e-15
* device instance $1545 r0 *1 0,17.35 sky130_fd_pr__model__cap_mim
C$1545 \$601 TOP_N|VINN 8.664e-15
* device instance $1546 r0 *1 3.4,17.35 sky130_fd_pr__model__cap_mim
C$1546 \$602 TOP_N|VINN 8.664e-15
* device instance $1547 r0 *1 6.8,17.35 sky130_fd_pr__model__cap_mim
C$1547 \$601 TOP_N|VINN 8.664e-15
* device instance $1548 r0 *1 10.2,17.35 sky130_fd_pr__model__cap_mim
C$1548 \$603 TOP_N|VINN 8.664e-15
* device instance $1549 r0 *1 13.6,17.35 sky130_fd_pr__model__cap_mim
C$1549 \$601 TOP_N|VINN 8.664e-15
* device instance $1550 r0 *1 17,17.35 sky130_fd_pr__model__cap_mim
C$1550 \$602 TOP_N|VINN 8.664e-15
* device instance $1551 r0 *1 20.4,17.35 sky130_fd_pr__model__cap_mim
C$1551 \$601 TOP_N|VINN 8.664e-15
* device instance $1552 r0 *1 23.8,17.35 sky130_fd_pr__model__cap_mim
C$1552 \$604 TOP_N|VINN 8.664e-15
* device instance $1553 r0 *1 27.2,17.35 sky130_fd_pr__model__cap_mim
C$1553 \$601 TOP_N|VINN 8.664e-15
* device instance $1554 r0 *1 30.6,17.35 sky130_fd_pr__model__cap_mim
C$1554 \$602 TOP_N|VINN 8.664e-15
* device instance $1555 r0 *1 34,17.35 sky130_fd_pr__model__cap_mim
C$1555 \$601 TOP_N|VINN 8.664e-15
* device instance $1556 r0 *1 37.4,17.35 sky130_fd_pr__model__cap_mim
C$1556 \$603 TOP_N|VINN 8.664e-15
* device instance $1557 r0 *1 40.8,17.35 sky130_fd_pr__model__cap_mim
C$1557 \$601 TOP_N|VINN 8.664e-15
* device instance $1558 r0 *1 44.2,17.35 sky130_fd_pr__model__cap_mim
C$1558 \$602 TOP_N|VINN 8.664e-15
* device instance $1559 r0 *1 47.6,17.35 sky130_fd_pr__model__cap_mim
C$1559 \$601 TOP_N|VINN 8.664e-15
* device instance $1560 r0 *1 51,17.35 sky130_fd_pr__model__cap_mim
C$1560 \$599 TOP_N|VINN 8.664e-15
* device instance $1561 r0 *1 54.4,17.35 sky130_fd_pr__model__cap_mim
C$1561 \$601 TOP_N|VINN 8.664e-15
* device instance $1562 r0 *1 57.8,17.35 sky130_fd_pr__model__cap_mim
C$1562 \$602 TOP_N|VINN 8.664e-15
* device instance $1563 r0 *1 61.2,17.35 sky130_fd_pr__model__cap_mim
C$1563 \$601 TOP_N|VINN 8.664e-15
* device instance $1564 r0 *1 64.6,17.35 sky130_fd_pr__model__cap_mim
C$1564 \$603 TOP_N|VINN 8.664e-15
* device instance $1565 r0 *1 68,17.35 sky130_fd_pr__model__cap_mim
C$1565 \$601 TOP_N|VINN 8.664e-15
* device instance $1566 r0 *1 71.4,17.35 sky130_fd_pr__model__cap_mim
C$1566 \$602 TOP_N|VINN 8.664e-15
* device instance $1567 r0 *1 74.8,17.35 sky130_fd_pr__model__cap_mim
C$1567 \$601 TOP_N|VINN 8.664e-15
* device instance $1568 r0 *1 78.2,17.35 sky130_fd_pr__model__cap_mim
C$1568 \$604 TOP_N|VINN 8.664e-15
* device instance $1569 r0 *1 81.6,17.35 sky130_fd_pr__model__cap_mim
C$1569 \$601 TOP_N|VINN 8.664e-15
* device instance $1570 r0 *1 85,17.35 sky130_fd_pr__model__cap_mim
C$1570 \$602 TOP_N|VINN 8.664e-15
* device instance $1571 r0 *1 88.4,17.35 sky130_fd_pr__model__cap_mim
C$1571 \$601 TOP_N|VINN 8.664e-15
* device instance $1572 r0 *1 91.8,17.35 sky130_fd_pr__model__cap_mim
C$1572 \$603 TOP_N|VINN 8.664e-15
* device instance $1573 r0 *1 95.2,17.35 sky130_fd_pr__model__cap_mim
C$1573 \$601 TOP_N|VINN 8.664e-15
* device instance $1574 r0 *1 98.6,17.35 sky130_fd_pr__model__cap_mim
C$1574 \$602 TOP_N|VINN 8.664e-15
* device instance $1575 r0 *1 102,17.35 sky130_fd_pr__model__cap_mim
C$1575 \$601 TOP_N|VINN 8.664e-15
* device instance $1576 r0 *1 105.4,17.35 sky130_fd_pr__model__cap_mim
C$1576 \$598 TOP_N|VINN 8.664e-15
* device instance $1577 r0 *1 108.8,17.35 sky130_fd_pr__model__cap_mim
C$1577 \$596 TOP_N|VINN 8.664e-15
* device instance $1578 r0 *1 112.2,17.35 sky130_fd_pr__model__cap_mim
C$1578 \$601 TOP_N|VINN 8.664e-15
* device instance $1579 r0 *1 115.6,17.35 sky130_fd_pr__model__cap_mim
C$1579 \$602 TOP_N|VINN 8.664e-15
* device instance $1580 r0 *1 119,17.35 sky130_fd_pr__model__cap_mim
C$1580 \$601 TOP_N|VINN 8.664e-15
* device instance $1581 r0 *1 122.4,17.35 sky130_fd_pr__model__cap_mim
C$1581 \$603 TOP_N|VINN 8.664e-15
* device instance $1582 r0 *1 125.8,17.35 sky130_fd_pr__model__cap_mim
C$1582 \$601 TOP_N|VINN 8.664e-15
* device instance $1583 r0 *1 129.2,17.35 sky130_fd_pr__model__cap_mim
C$1583 \$602 TOP_N|VINN 8.664e-15
* device instance $1584 r0 *1 132.6,17.35 sky130_fd_pr__model__cap_mim
C$1584 \$601 TOP_N|VINN 8.664e-15
* device instance $1585 r0 *1 136,17.35 sky130_fd_pr__model__cap_mim
C$1585 \$604 TOP_N|VINN 8.664e-15
* device instance $1586 r0 *1 139.4,17.35 sky130_fd_pr__model__cap_mim
C$1586 \$601 TOP_N|VINN 8.664e-15
* device instance $1587 r0 *1 142.8,17.35 sky130_fd_pr__model__cap_mim
C$1587 \$602 TOP_N|VINN 8.664e-15
* device instance $1588 r0 *1 146.2,17.35 sky130_fd_pr__model__cap_mim
C$1588 \$601 TOP_N|VINN 8.664e-15
* device instance $1589 r0 *1 149.6,17.35 sky130_fd_pr__model__cap_mim
C$1589 \$603 TOP_N|VINN 8.664e-15
* device instance $1590 r0 *1 153,17.35 sky130_fd_pr__model__cap_mim
C$1590 \$601 TOP_N|VINN 8.664e-15
* device instance $1591 r0 *1 156.4,17.35 sky130_fd_pr__model__cap_mim
C$1591 \$602 TOP_N|VINN 8.664e-15
* device instance $1592 r0 *1 159.8,17.35 sky130_fd_pr__model__cap_mim
C$1592 \$601 TOP_N|VINN 8.664e-15
* device instance $1593 r0 *1 163.2,17.35 sky130_fd_pr__model__cap_mim
C$1593 \$599 TOP_N|VINN 8.664e-15
* device instance $1594 r0 *1 166.6,17.35 sky130_fd_pr__model__cap_mim
C$1594 \$601 TOP_N|VINN 8.664e-15
* device instance $1595 r0 *1 170,17.35 sky130_fd_pr__model__cap_mim
C$1595 \$602 TOP_N|VINN 8.664e-15
* device instance $1596 r0 *1 173.4,17.35 sky130_fd_pr__model__cap_mim
C$1596 \$601 TOP_N|VINN 8.664e-15
* device instance $1597 r0 *1 176.8,17.35 sky130_fd_pr__model__cap_mim
C$1597 \$603 TOP_N|VINN 8.664e-15
* device instance $1598 r0 *1 180.2,17.35 sky130_fd_pr__model__cap_mim
C$1598 \$601 TOP_N|VINN 8.664e-15
* device instance $1599 r0 *1 183.6,17.35 sky130_fd_pr__model__cap_mim
C$1599 \$602 TOP_N|VINN 8.664e-15
* device instance $1600 r0 *1 187,17.35 sky130_fd_pr__model__cap_mim
C$1600 \$601 TOP_N|VINN 8.664e-15
* device instance $1601 r0 *1 190.4,17.35 sky130_fd_pr__model__cap_mim
C$1601 \$604 TOP_N|VINN 8.664e-15
* device instance $1602 r0 *1 193.8,17.35 sky130_fd_pr__model__cap_mim
C$1602 \$601 TOP_N|VINN 8.664e-15
* device instance $1603 r0 *1 197.2,17.35 sky130_fd_pr__model__cap_mim
C$1603 \$602 TOP_N|VINN 8.664e-15
* device instance $1604 r0 *1 200.6,17.35 sky130_fd_pr__model__cap_mim
C$1604 \$601 TOP_N|VINN 8.664e-15
* device instance $1605 r0 *1 204,17.35 sky130_fd_pr__model__cap_mim
C$1605 \$603 TOP_N|VINN 8.664e-15
* device instance $1606 r0 *1 207.4,17.35 sky130_fd_pr__model__cap_mim
C$1606 \$601 TOP_N|VINN 8.664e-15
* device instance $1607 r0 *1 210.8,17.35 sky130_fd_pr__model__cap_mim
C$1607 \$602 TOP_N|VINN 8.664e-15
* device instance $1608 r0 *1 214.2,17.35 sky130_fd_pr__model__cap_mim
C$1608 \$601 TOP_N|VINN 8.664e-15
* device instance $1609 r0 *1 0,20.75 sky130_fd_pr__model__cap_mim
C$1609 \$605 TOP_P|VINP 8.664e-15
* device instance $1610 r0 *1 3.4,20.75 sky130_fd_pr__model__cap_mim
C$1610 \$606 TOP_P|VINP 8.664e-15
* device instance $1611 r0 *1 6.8,20.75 sky130_fd_pr__model__cap_mim
C$1611 \$605 TOP_P|VINP 8.664e-15
* device instance $1612 r0 *1 10.2,20.75 sky130_fd_pr__model__cap_mim
C$1612 \$607 TOP_P|VINP 8.664e-15
* device instance $1613 r0 *1 13.6,20.75 sky130_fd_pr__model__cap_mim
C$1613 \$605 TOP_P|VINP 8.664e-15
* device instance $1614 r0 *1 17,20.75 sky130_fd_pr__model__cap_mim
C$1614 \$606 TOP_P|VINP 8.664e-15
* device instance $1615 r0 *1 20.4,20.75 sky130_fd_pr__model__cap_mim
C$1615 \$605 TOP_P|VINP 8.664e-15
* device instance $1616 r0 *1 23.8,20.75 sky130_fd_pr__model__cap_mim
C$1616 \$594 TOP_P|VINP 8.664e-15
* device instance $1617 r0 *1 27.2,20.75 sky130_fd_pr__model__cap_mim
C$1617 \$605 TOP_P|VINP 8.664e-15
* device instance $1618 r0 *1 30.6,20.75 sky130_fd_pr__model__cap_mim
C$1618 \$606 TOP_P|VINP 8.664e-15
* device instance $1619 r0 *1 34,20.75 sky130_fd_pr__model__cap_mim
C$1619 \$605 TOP_P|VINP 8.664e-15
* device instance $1620 r0 *1 37.4,20.75 sky130_fd_pr__model__cap_mim
C$1620 \$607 TOP_P|VINP 8.664e-15
* device instance $1621 r0 *1 40.8,20.75 sky130_fd_pr__model__cap_mim
C$1621 \$605 TOP_P|VINP 8.664e-15
* device instance $1622 r0 *1 44.2,20.75 sky130_fd_pr__model__cap_mim
C$1622 \$606 TOP_P|VINP 8.664e-15
* device instance $1623 r0 *1 47.6,20.75 sky130_fd_pr__model__cap_mim
C$1623 \$605 TOP_P|VINP 8.664e-15
* device instance $1624 r0 *1 51,20.75 sky130_fd_pr__model__cap_mim
C$1624 \$593 TOP_P|VINP 8.664e-15
* device instance $1625 r0 *1 54.4,20.75 sky130_fd_pr__model__cap_mim
C$1625 \$605 TOP_P|VINP 8.664e-15
* device instance $1626 r0 *1 57.8,20.75 sky130_fd_pr__model__cap_mim
C$1626 \$606 TOP_P|VINP 8.664e-15
* device instance $1627 r0 *1 61.2,20.75 sky130_fd_pr__model__cap_mim
C$1627 \$605 TOP_P|VINP 8.664e-15
* device instance $1628 r0 *1 64.6,20.75 sky130_fd_pr__model__cap_mim
C$1628 \$607 TOP_P|VINP 8.664e-15
* device instance $1629 r0 *1 68,20.75 sky130_fd_pr__model__cap_mim
C$1629 \$605 TOP_P|VINP 8.664e-15
* device instance $1630 r0 *1 71.4,20.75 sky130_fd_pr__model__cap_mim
C$1630 \$606 TOP_P|VINP 8.664e-15
* device instance $1631 r0 *1 74.8,20.75 sky130_fd_pr__model__cap_mim
C$1631 \$605 TOP_P|VINP 8.664e-15
* device instance $1632 r0 *1 78.2,20.75 sky130_fd_pr__model__cap_mim
C$1632 \$594 TOP_P|VINP 8.664e-15
* device instance $1633 r0 *1 81.6,20.75 sky130_fd_pr__model__cap_mim
C$1633 \$605 TOP_P|VINP 8.664e-15
* device instance $1634 r0 *1 85,20.75 sky130_fd_pr__model__cap_mim
C$1634 \$606 TOP_P|VINP 8.664e-15
* device instance $1635 r0 *1 88.4,20.75 sky130_fd_pr__model__cap_mim
C$1635 \$605 TOP_P|VINP 8.664e-15
* device instance $1636 r0 *1 91.8,20.75 sky130_fd_pr__model__cap_mim
C$1636 \$607 TOP_P|VINP 8.664e-15
* device instance $1637 r0 *1 95.2,20.75 sky130_fd_pr__model__cap_mim
C$1637 \$605 TOP_P|VINP 8.664e-15
* device instance $1638 r0 *1 98.6,20.75 sky130_fd_pr__model__cap_mim
C$1638 \$606 TOP_P|VINP 8.664e-15
* device instance $1639 r0 *1 102,20.75 sky130_fd_pr__model__cap_mim
C$1639 \$605 TOP_P|VINP 8.664e-15
* device instance $1640 r0 *1 105.4,20.75 sky130_fd_pr__model__cap_mim
C$1640 \$592 TOP_P|VINP 8.664e-15
* device instance $1641 r0 *1 108.8,20.75 sky130_fd_pr__model__cap_mim
C$1641 \$591 TOP_P|VINP 8.664e-15
* device instance $1642 r0 *1 112.2,20.75 sky130_fd_pr__model__cap_mim
C$1642 \$605 TOP_P|VINP 8.664e-15
* device instance $1643 r0 *1 115.6,20.75 sky130_fd_pr__model__cap_mim
C$1643 \$606 TOP_P|VINP 8.664e-15
* device instance $1644 r0 *1 119,20.75 sky130_fd_pr__model__cap_mim
C$1644 \$605 TOP_P|VINP 8.664e-15
* device instance $1645 r0 *1 122.4,20.75 sky130_fd_pr__model__cap_mim
C$1645 \$607 TOP_P|VINP 8.664e-15
* device instance $1646 r0 *1 125.8,20.75 sky130_fd_pr__model__cap_mim
C$1646 \$605 TOP_P|VINP 8.664e-15
* device instance $1647 r0 *1 129.2,20.75 sky130_fd_pr__model__cap_mim
C$1647 \$606 TOP_P|VINP 8.664e-15
* device instance $1648 r0 *1 132.6,20.75 sky130_fd_pr__model__cap_mim
C$1648 \$605 TOP_P|VINP 8.664e-15
* device instance $1649 r0 *1 136,20.75 sky130_fd_pr__model__cap_mim
C$1649 \$594 TOP_P|VINP 8.664e-15
* device instance $1650 r0 *1 139.4,20.75 sky130_fd_pr__model__cap_mim
C$1650 \$605 TOP_P|VINP 8.664e-15
* device instance $1651 r0 *1 142.8,20.75 sky130_fd_pr__model__cap_mim
C$1651 \$606 TOP_P|VINP 8.664e-15
* device instance $1652 r0 *1 146.2,20.75 sky130_fd_pr__model__cap_mim
C$1652 \$605 TOP_P|VINP 8.664e-15
* device instance $1653 r0 *1 149.6,20.75 sky130_fd_pr__model__cap_mim
C$1653 \$607 TOP_P|VINP 8.664e-15
* device instance $1654 r0 *1 153,20.75 sky130_fd_pr__model__cap_mim
C$1654 \$605 TOP_P|VINP 8.664e-15
* device instance $1655 r0 *1 156.4,20.75 sky130_fd_pr__model__cap_mim
C$1655 \$606 TOP_P|VINP 8.664e-15
* device instance $1656 r0 *1 159.8,20.75 sky130_fd_pr__model__cap_mim
C$1656 \$605 TOP_P|VINP 8.664e-15
* device instance $1657 r0 *1 163.2,20.75 sky130_fd_pr__model__cap_mim
C$1657 \$593 TOP_P|VINP 8.664e-15
* device instance $1658 r0 *1 166.6,20.75 sky130_fd_pr__model__cap_mim
C$1658 \$605 TOP_P|VINP 8.664e-15
* device instance $1659 r0 *1 170,20.75 sky130_fd_pr__model__cap_mim
C$1659 \$606 TOP_P|VINP 8.664e-15
* device instance $1660 r0 *1 173.4,20.75 sky130_fd_pr__model__cap_mim
C$1660 \$605 TOP_P|VINP 8.664e-15
* device instance $1661 r0 *1 176.8,20.75 sky130_fd_pr__model__cap_mim
C$1661 \$607 TOP_P|VINP 8.664e-15
* device instance $1662 r0 *1 180.2,20.75 sky130_fd_pr__model__cap_mim
C$1662 \$605 TOP_P|VINP 8.664e-15
* device instance $1663 r0 *1 183.6,20.75 sky130_fd_pr__model__cap_mim
C$1663 \$606 TOP_P|VINP 8.664e-15
* device instance $1664 r0 *1 187,20.75 sky130_fd_pr__model__cap_mim
C$1664 \$605 TOP_P|VINP 8.664e-15
* device instance $1665 r0 *1 190.4,20.75 sky130_fd_pr__model__cap_mim
C$1665 \$594 TOP_P|VINP 8.664e-15
* device instance $1666 r0 *1 193.8,20.75 sky130_fd_pr__model__cap_mim
C$1666 \$605 TOP_P|VINP 8.664e-15
* device instance $1667 r0 *1 197.2,20.75 sky130_fd_pr__model__cap_mim
C$1667 \$606 TOP_P|VINP 8.664e-15
* device instance $1668 r0 *1 200.6,20.75 sky130_fd_pr__model__cap_mim
C$1668 \$605 TOP_P|VINP 8.664e-15
* device instance $1669 r0 *1 204,20.75 sky130_fd_pr__model__cap_mim
C$1669 \$607 TOP_P|VINP 8.664e-15
* device instance $1670 r0 *1 207.4,20.75 sky130_fd_pr__model__cap_mim
C$1670 \$605 TOP_P|VINP 8.664e-15
* device instance $1671 r0 *1 210.8,20.75 sky130_fd_pr__model__cap_mim
C$1671 \$606 TOP_P|VINP 8.664e-15
* device instance $1672 r0 *1 214.2,20.75 sky130_fd_pr__model__cap_mim
C$1672 \$605 TOP_P|VINP 8.664e-15
* device instance $1673 r0 *1 0,24.15 sky130_fd_pr__model__cap_mim
C$1673 \$601 TOP_N|VINN 8.664e-15
* device instance $1674 r0 *1 3.4,24.15 sky130_fd_pr__model__cap_mim
C$1674 \$602 TOP_N|VINN 8.664e-15
* device instance $1675 r0 *1 6.8,24.15 sky130_fd_pr__model__cap_mim
C$1675 \$601 TOP_N|VINN 8.664e-15
* device instance $1676 r0 *1 10.2,24.15 sky130_fd_pr__model__cap_mim
C$1676 \$603 TOP_N|VINN 8.664e-15
* device instance $1677 r0 *1 13.6,24.15 sky130_fd_pr__model__cap_mim
C$1677 \$601 TOP_N|VINN 8.664e-15
* device instance $1678 r0 *1 17,24.15 sky130_fd_pr__model__cap_mim
C$1678 \$602 TOP_N|VINN 8.664e-15
* device instance $1679 r0 *1 20.4,24.15 sky130_fd_pr__model__cap_mim
C$1679 \$601 TOP_N|VINN 8.664e-15
* device instance $1680 r0 *1 23.8,24.15 sky130_fd_pr__model__cap_mim
C$1680 \$604 TOP_N|VINN 8.664e-15
* device instance $1681 r0 *1 27.2,24.15 sky130_fd_pr__model__cap_mim
C$1681 \$601 TOP_N|VINN 8.664e-15
* device instance $1682 r0 *1 30.6,24.15 sky130_fd_pr__model__cap_mim
C$1682 \$602 TOP_N|VINN 8.664e-15
* device instance $1683 r0 *1 34,24.15 sky130_fd_pr__model__cap_mim
C$1683 \$601 TOP_N|VINN 8.664e-15
* device instance $1684 r0 *1 37.4,24.15 sky130_fd_pr__model__cap_mim
C$1684 \$603 TOP_N|VINN 8.664e-15
* device instance $1685 r0 *1 40.8,24.15 sky130_fd_pr__model__cap_mim
C$1685 \$601 TOP_N|VINN 8.664e-15
* device instance $1686 r0 *1 44.2,24.15 sky130_fd_pr__model__cap_mim
C$1686 \$602 TOP_N|VINN 8.664e-15
* device instance $1687 r0 *1 47.6,24.15 sky130_fd_pr__model__cap_mim
C$1687 \$601 TOP_N|VINN 8.664e-15
* device instance $1688 r0 *1 51,24.15 sky130_fd_pr__model__cap_mim
C$1688 \$599 TOP_N|VINN 8.664e-15
* device instance $1689 r0 *1 54.4,24.15 sky130_fd_pr__model__cap_mim
C$1689 \$601 TOP_N|VINN 8.664e-15
* device instance $1690 r0 *1 57.8,24.15 sky130_fd_pr__model__cap_mim
C$1690 \$602 TOP_N|VINN 8.664e-15
* device instance $1691 r0 *1 61.2,24.15 sky130_fd_pr__model__cap_mim
C$1691 \$601 TOP_N|VINN 8.664e-15
* device instance $1692 r0 *1 64.6,24.15 sky130_fd_pr__model__cap_mim
C$1692 \$603 TOP_N|VINN 8.664e-15
* device instance $1693 r0 *1 68,24.15 sky130_fd_pr__model__cap_mim
C$1693 \$601 TOP_N|VINN 8.664e-15
* device instance $1694 r0 *1 71.4,24.15 sky130_fd_pr__model__cap_mim
C$1694 \$602 TOP_N|VINN 8.664e-15
* device instance $1695 r0 *1 74.8,24.15 sky130_fd_pr__model__cap_mim
C$1695 \$601 TOP_N|VINN 8.664e-15
* device instance $1696 r0 *1 78.2,24.15 sky130_fd_pr__model__cap_mim
C$1696 \$604 TOP_N|VINN 8.664e-15
* device instance $1697 r0 *1 81.6,24.15 sky130_fd_pr__model__cap_mim
C$1697 \$601 TOP_N|VINN 8.664e-15
* device instance $1698 r0 *1 85,24.15 sky130_fd_pr__model__cap_mim
C$1698 \$602 TOP_N|VINN 8.664e-15
* device instance $1699 r0 *1 88.4,24.15 sky130_fd_pr__model__cap_mim
C$1699 \$601 TOP_N|VINN 8.664e-15
* device instance $1700 r0 *1 91.8,24.15 sky130_fd_pr__model__cap_mim
C$1700 \$603 TOP_N|VINN 8.664e-15
* device instance $1701 r0 *1 95.2,24.15 sky130_fd_pr__model__cap_mim
C$1701 \$601 TOP_N|VINN 8.664e-15
* device instance $1702 r0 *1 98.6,24.15 sky130_fd_pr__model__cap_mim
C$1702 \$602 TOP_N|VINN 8.664e-15
* device instance $1703 r0 *1 102,24.15 sky130_fd_pr__model__cap_mim
C$1703 \$601 TOP_N|VINN 8.664e-15
* device instance $1704 r0 *1 105.4,24.15 sky130_fd_pr__model__cap_mim
C$1704 \$598 TOP_N|VINN 8.664e-15
* device instance $1705 r0 *1 108.8,24.15 sky130_fd_pr__model__cap_mim
C$1705 \$597 TOP_N|VINN 8.664e-15
* device instance $1706 r0 *1 112.2,24.15 sky130_fd_pr__model__cap_mim
C$1706 \$601 TOP_N|VINN 8.664e-15
* device instance $1707 r0 *1 115.6,24.15 sky130_fd_pr__model__cap_mim
C$1707 \$602 TOP_N|VINN 8.664e-15
* device instance $1708 r0 *1 119,24.15 sky130_fd_pr__model__cap_mim
C$1708 \$601 TOP_N|VINN 8.664e-15
* device instance $1709 r0 *1 122.4,24.15 sky130_fd_pr__model__cap_mim
C$1709 \$603 TOP_N|VINN 8.664e-15
* device instance $1710 r0 *1 125.8,24.15 sky130_fd_pr__model__cap_mim
C$1710 \$601 TOP_N|VINN 8.664e-15
* device instance $1711 r0 *1 129.2,24.15 sky130_fd_pr__model__cap_mim
C$1711 \$602 TOP_N|VINN 8.664e-15
* device instance $1712 r0 *1 132.6,24.15 sky130_fd_pr__model__cap_mim
C$1712 \$601 TOP_N|VINN 8.664e-15
* device instance $1713 r0 *1 136,24.15 sky130_fd_pr__model__cap_mim
C$1713 \$604 TOP_N|VINN 8.664e-15
* device instance $1714 r0 *1 139.4,24.15 sky130_fd_pr__model__cap_mim
C$1714 \$601 TOP_N|VINN 8.664e-15
* device instance $1715 r0 *1 142.8,24.15 sky130_fd_pr__model__cap_mim
C$1715 \$602 TOP_N|VINN 8.664e-15
* device instance $1716 r0 *1 146.2,24.15 sky130_fd_pr__model__cap_mim
C$1716 \$601 TOP_N|VINN 8.664e-15
* device instance $1717 r0 *1 149.6,24.15 sky130_fd_pr__model__cap_mim
C$1717 \$603 TOP_N|VINN 8.664e-15
* device instance $1718 r0 *1 153,24.15 sky130_fd_pr__model__cap_mim
C$1718 \$601 TOP_N|VINN 8.664e-15
* device instance $1719 r0 *1 156.4,24.15 sky130_fd_pr__model__cap_mim
C$1719 \$602 TOP_N|VINN 8.664e-15
* device instance $1720 r0 *1 159.8,24.15 sky130_fd_pr__model__cap_mim
C$1720 \$601 TOP_N|VINN 8.664e-15
* device instance $1721 r0 *1 163.2,24.15 sky130_fd_pr__model__cap_mim
C$1721 \$599 TOP_N|VINN 8.664e-15
* device instance $1722 r0 *1 166.6,24.15 sky130_fd_pr__model__cap_mim
C$1722 \$601 TOP_N|VINN 8.664e-15
* device instance $1723 r0 *1 170,24.15 sky130_fd_pr__model__cap_mim
C$1723 \$602 TOP_N|VINN 8.664e-15
* device instance $1724 r0 *1 173.4,24.15 sky130_fd_pr__model__cap_mim
C$1724 \$601 TOP_N|VINN 8.664e-15
* device instance $1725 r0 *1 176.8,24.15 sky130_fd_pr__model__cap_mim
C$1725 \$603 TOP_N|VINN 8.664e-15
* device instance $1726 r0 *1 180.2,24.15 sky130_fd_pr__model__cap_mim
C$1726 \$601 TOP_N|VINN 8.664e-15
* device instance $1727 r0 *1 183.6,24.15 sky130_fd_pr__model__cap_mim
C$1727 \$602 TOP_N|VINN 8.664e-15
* device instance $1728 r0 *1 187,24.15 sky130_fd_pr__model__cap_mim
C$1728 \$601 TOP_N|VINN 8.664e-15
* device instance $1729 r0 *1 190.4,24.15 sky130_fd_pr__model__cap_mim
C$1729 \$604 TOP_N|VINN 8.664e-15
* device instance $1730 r0 *1 193.8,24.15 sky130_fd_pr__model__cap_mim
C$1730 \$601 TOP_N|VINN 8.664e-15
* device instance $1731 r0 *1 197.2,24.15 sky130_fd_pr__model__cap_mim
C$1731 \$602 TOP_N|VINN 8.664e-15
* device instance $1732 r0 *1 200.6,24.15 sky130_fd_pr__model__cap_mim
C$1732 \$601 TOP_N|VINN 8.664e-15
* device instance $1733 r0 *1 204,24.15 sky130_fd_pr__model__cap_mim
C$1733 \$603 TOP_N|VINN 8.664e-15
* device instance $1734 r0 *1 207.4,24.15 sky130_fd_pr__model__cap_mim
C$1734 \$601 TOP_N|VINN 8.664e-15
* device instance $1735 r0 *1 210.8,24.15 sky130_fd_pr__model__cap_mim
C$1735 \$602 TOP_N|VINN 8.664e-15
* device instance $1736 r0 *1 214.2,24.15 sky130_fd_pr__model__cap_mim
C$1736 \$601 TOP_N|VINN 8.664e-15
* device instance $1737 r0 *1 0,27.55 sky130_fd_pr__model__cap_mim
C$1737 \$601 TOP_N|VINN 8.664e-15
* device instance $1738 r0 *1 3.4,27.55 sky130_fd_pr__model__cap_mim
C$1738 \$602 TOP_N|VINN 8.664e-15
* device instance $1739 r0 *1 6.8,27.55 sky130_fd_pr__model__cap_mim
C$1739 \$601 TOP_N|VINN 8.664e-15
* device instance $1740 r0 *1 10.2,27.55 sky130_fd_pr__model__cap_mim
C$1740 \$603 TOP_N|VINN 8.664e-15
* device instance $1741 r0 *1 13.6,27.55 sky130_fd_pr__model__cap_mim
C$1741 \$601 TOP_N|VINN 8.664e-15
* device instance $1742 r0 *1 17,27.55 sky130_fd_pr__model__cap_mim
C$1742 \$602 TOP_N|VINN 8.664e-15
* device instance $1743 r0 *1 20.4,27.55 sky130_fd_pr__model__cap_mim
C$1743 \$601 TOP_N|VINN 8.664e-15
* device instance $1744 r0 *1 23.8,27.55 sky130_fd_pr__model__cap_mim
C$1744 \$604 TOP_N|VINN 8.664e-15
* device instance $1745 r0 *1 27.2,27.55 sky130_fd_pr__model__cap_mim
C$1745 \$601 TOP_N|VINN 8.664e-15
* device instance $1746 r0 *1 30.6,27.55 sky130_fd_pr__model__cap_mim
C$1746 \$602 TOP_N|VINN 8.664e-15
* device instance $1747 r0 *1 34,27.55 sky130_fd_pr__model__cap_mim
C$1747 \$601 TOP_N|VINN 8.664e-15
* device instance $1748 r0 *1 37.4,27.55 sky130_fd_pr__model__cap_mim
C$1748 \$603 TOP_N|VINN 8.664e-15
* device instance $1749 r0 *1 40.8,27.55 sky130_fd_pr__model__cap_mim
C$1749 \$601 TOP_N|VINN 8.664e-15
* device instance $1750 r0 *1 44.2,27.55 sky130_fd_pr__model__cap_mim
C$1750 \$602 TOP_N|VINN 8.664e-15
* device instance $1751 r0 *1 47.6,27.55 sky130_fd_pr__model__cap_mim
C$1751 \$601 TOP_N|VINN 8.664e-15
* device instance $1752 r0 *1 51,27.55 sky130_fd_pr__model__cap_mim
C$1752 \$599 TOP_N|VINN 8.664e-15
* device instance $1753 r0 *1 54.4,27.55 sky130_fd_pr__model__cap_mim
C$1753 \$601 TOP_N|VINN 8.664e-15
* device instance $1754 r0 *1 57.8,27.55 sky130_fd_pr__model__cap_mim
C$1754 \$602 TOP_N|VINN 8.664e-15
* device instance $1755 r0 *1 61.2,27.55 sky130_fd_pr__model__cap_mim
C$1755 \$601 TOP_N|VINN 8.664e-15
* device instance $1756 r0 *1 64.6,27.55 sky130_fd_pr__model__cap_mim
C$1756 \$603 TOP_N|VINN 8.664e-15
* device instance $1757 r0 *1 68,27.55 sky130_fd_pr__model__cap_mim
C$1757 \$601 TOP_N|VINN 8.664e-15
* device instance $1758 r0 *1 71.4,27.55 sky130_fd_pr__model__cap_mim
C$1758 \$602 TOP_N|VINN 8.664e-15
* device instance $1759 r0 *1 74.8,27.55 sky130_fd_pr__model__cap_mim
C$1759 \$601 TOP_N|VINN 8.664e-15
* device instance $1760 r0 *1 78.2,27.55 sky130_fd_pr__model__cap_mim
C$1760 \$604 TOP_N|VINN 8.664e-15
* device instance $1761 r0 *1 81.6,27.55 sky130_fd_pr__model__cap_mim
C$1761 \$601 TOP_N|VINN 8.664e-15
* device instance $1762 r0 *1 85,27.55 sky130_fd_pr__model__cap_mim
C$1762 \$602 TOP_N|VINN 8.664e-15
* device instance $1763 r0 *1 88.4,27.55 sky130_fd_pr__model__cap_mim
C$1763 \$601 TOP_N|VINN 8.664e-15
* device instance $1764 r0 *1 91.8,27.55 sky130_fd_pr__model__cap_mim
C$1764 \$603 TOP_N|VINN 8.664e-15
* device instance $1765 r0 *1 95.2,27.55 sky130_fd_pr__model__cap_mim
C$1765 \$601 TOP_N|VINN 8.664e-15
* device instance $1766 r0 *1 98.6,27.55 sky130_fd_pr__model__cap_mim
C$1766 \$602 TOP_N|VINN 8.664e-15
* device instance $1767 r0 *1 102,27.55 sky130_fd_pr__model__cap_mim
C$1767 \$601 TOP_N|VINN 8.664e-15
* device instance $1768 r0 *1 105.4,27.55 sky130_fd_pr__model__cap_mim
C$1768 \$598 TOP_N|VINN 8.664e-15
* device instance $1769 r0 *1 108.8,27.55 sky130_fd_pr__model__cap_mim
C$1769 \$597 TOP_N|VINN 8.664e-15
* device instance $1770 r0 *1 112.2,27.55 sky130_fd_pr__model__cap_mim
C$1770 \$601 TOP_N|VINN 8.664e-15
* device instance $1771 r0 *1 115.6,27.55 sky130_fd_pr__model__cap_mim
C$1771 \$602 TOP_N|VINN 8.664e-15
* device instance $1772 r0 *1 119,27.55 sky130_fd_pr__model__cap_mim
C$1772 \$601 TOP_N|VINN 8.664e-15
* device instance $1773 r0 *1 122.4,27.55 sky130_fd_pr__model__cap_mim
C$1773 \$603 TOP_N|VINN 8.664e-15
* device instance $1774 r0 *1 125.8,27.55 sky130_fd_pr__model__cap_mim
C$1774 \$601 TOP_N|VINN 8.664e-15
* device instance $1775 r0 *1 129.2,27.55 sky130_fd_pr__model__cap_mim
C$1775 \$602 TOP_N|VINN 8.664e-15
* device instance $1776 r0 *1 132.6,27.55 sky130_fd_pr__model__cap_mim
C$1776 \$601 TOP_N|VINN 8.664e-15
* device instance $1777 r0 *1 136,27.55 sky130_fd_pr__model__cap_mim
C$1777 \$604 TOP_N|VINN 8.664e-15
* device instance $1778 r0 *1 139.4,27.55 sky130_fd_pr__model__cap_mim
C$1778 \$601 TOP_N|VINN 8.664e-15
* device instance $1779 r0 *1 142.8,27.55 sky130_fd_pr__model__cap_mim
C$1779 \$602 TOP_N|VINN 8.664e-15
* device instance $1780 r0 *1 146.2,27.55 sky130_fd_pr__model__cap_mim
C$1780 \$601 TOP_N|VINN 8.664e-15
* device instance $1781 r0 *1 149.6,27.55 sky130_fd_pr__model__cap_mim
C$1781 \$603 TOP_N|VINN 8.664e-15
* device instance $1782 r0 *1 153,27.55 sky130_fd_pr__model__cap_mim
C$1782 \$601 TOP_N|VINN 8.664e-15
* device instance $1783 r0 *1 156.4,27.55 sky130_fd_pr__model__cap_mim
C$1783 \$602 TOP_N|VINN 8.664e-15
* device instance $1784 r0 *1 159.8,27.55 sky130_fd_pr__model__cap_mim
C$1784 \$601 TOP_N|VINN 8.664e-15
* device instance $1785 r0 *1 163.2,27.55 sky130_fd_pr__model__cap_mim
C$1785 \$599 TOP_N|VINN 8.664e-15
* device instance $1786 r0 *1 166.6,27.55 sky130_fd_pr__model__cap_mim
C$1786 \$601 TOP_N|VINN 8.664e-15
* device instance $1787 r0 *1 170,27.55 sky130_fd_pr__model__cap_mim
C$1787 \$602 TOP_N|VINN 8.664e-15
* device instance $1788 r0 *1 173.4,27.55 sky130_fd_pr__model__cap_mim
C$1788 \$601 TOP_N|VINN 8.664e-15
* device instance $1789 r0 *1 176.8,27.55 sky130_fd_pr__model__cap_mim
C$1789 \$603 TOP_N|VINN 8.664e-15
* device instance $1790 r0 *1 180.2,27.55 sky130_fd_pr__model__cap_mim
C$1790 \$601 TOP_N|VINN 8.664e-15
* device instance $1791 r0 *1 183.6,27.55 sky130_fd_pr__model__cap_mim
C$1791 \$602 TOP_N|VINN 8.664e-15
* device instance $1792 r0 *1 187,27.55 sky130_fd_pr__model__cap_mim
C$1792 \$601 TOP_N|VINN 8.664e-15
* device instance $1793 r0 *1 190.4,27.55 sky130_fd_pr__model__cap_mim
C$1793 \$604 TOP_N|VINN 8.664e-15
* device instance $1794 r0 *1 193.8,27.55 sky130_fd_pr__model__cap_mim
C$1794 \$601 TOP_N|VINN 8.664e-15
* device instance $1795 r0 *1 197.2,27.55 sky130_fd_pr__model__cap_mim
C$1795 \$602 TOP_N|VINN 8.664e-15
* device instance $1796 r0 *1 200.6,27.55 sky130_fd_pr__model__cap_mim
C$1796 \$601 TOP_N|VINN 8.664e-15
* device instance $1797 r0 *1 204,27.55 sky130_fd_pr__model__cap_mim
C$1797 \$603 TOP_N|VINN 8.664e-15
* device instance $1798 r0 *1 207.4,27.55 sky130_fd_pr__model__cap_mim
C$1798 \$601 TOP_N|VINN 8.664e-15
* device instance $1799 r0 *1 210.8,27.55 sky130_fd_pr__model__cap_mim
C$1799 \$602 TOP_N|VINN 8.664e-15
* device instance $1800 r0 *1 214.2,27.55 sky130_fd_pr__model__cap_mim
C$1800 \$601 TOP_N|VINN 8.664e-15
* device instance $1801 r0 *1 0,30.95 sky130_fd_pr__model__cap_mim
C$1801 \$605 TOP_P|VINP 8.664e-15
* device instance $1802 r0 *1 3.4,30.95 sky130_fd_pr__model__cap_mim
C$1802 \$606 TOP_P|VINP 8.664e-15
* device instance $1803 r0 *1 6.8,30.95 sky130_fd_pr__model__cap_mim
C$1803 \$605 TOP_P|VINP 8.664e-15
* device instance $1804 r0 *1 10.2,30.95 sky130_fd_pr__model__cap_mim
C$1804 \$607 TOP_P|VINP 8.664e-15
* device instance $1805 r0 *1 13.6,30.95 sky130_fd_pr__model__cap_mim
C$1805 \$605 TOP_P|VINP 8.664e-15
* device instance $1806 r0 *1 17,30.95 sky130_fd_pr__model__cap_mim
C$1806 \$606 TOP_P|VINP 8.664e-15
* device instance $1807 r0 *1 20.4,30.95 sky130_fd_pr__model__cap_mim
C$1807 \$605 TOP_P|VINP 8.664e-15
* device instance $1808 r0 *1 23.8,30.95 sky130_fd_pr__model__cap_mim
C$1808 \$594 TOP_P|VINP 8.664e-15
* device instance $1809 r0 *1 27.2,30.95 sky130_fd_pr__model__cap_mim
C$1809 \$605 TOP_P|VINP 8.664e-15
* device instance $1810 r0 *1 30.6,30.95 sky130_fd_pr__model__cap_mim
C$1810 \$606 TOP_P|VINP 8.664e-15
* device instance $1811 r0 *1 34,30.95 sky130_fd_pr__model__cap_mim
C$1811 \$605 TOP_P|VINP 8.664e-15
* device instance $1812 r0 *1 37.4,30.95 sky130_fd_pr__model__cap_mim
C$1812 \$607 TOP_P|VINP 8.664e-15
* device instance $1813 r0 *1 40.8,30.95 sky130_fd_pr__model__cap_mim
C$1813 \$605 TOP_P|VINP 8.664e-15
* device instance $1814 r0 *1 44.2,30.95 sky130_fd_pr__model__cap_mim
C$1814 \$606 TOP_P|VINP 8.664e-15
* device instance $1815 r0 *1 47.6,30.95 sky130_fd_pr__model__cap_mim
C$1815 \$605 TOP_P|VINP 8.664e-15
* device instance $1816 r0 *1 51,30.95 sky130_fd_pr__model__cap_mim
C$1816 \$593 TOP_P|VINP 8.664e-15
* device instance $1817 r0 *1 54.4,30.95 sky130_fd_pr__model__cap_mim
C$1817 \$605 TOP_P|VINP 8.664e-15
* device instance $1818 r0 *1 57.8,30.95 sky130_fd_pr__model__cap_mim
C$1818 \$606 TOP_P|VINP 8.664e-15
* device instance $1819 r0 *1 61.2,30.95 sky130_fd_pr__model__cap_mim
C$1819 \$605 TOP_P|VINP 8.664e-15
* device instance $1820 r0 *1 64.6,30.95 sky130_fd_pr__model__cap_mim
C$1820 \$607 TOP_P|VINP 8.664e-15
* device instance $1821 r0 *1 68,30.95 sky130_fd_pr__model__cap_mim
C$1821 \$605 TOP_P|VINP 8.664e-15
* device instance $1822 r0 *1 71.4,30.95 sky130_fd_pr__model__cap_mim
C$1822 \$606 TOP_P|VINP 8.664e-15
* device instance $1823 r0 *1 74.8,30.95 sky130_fd_pr__model__cap_mim
C$1823 \$605 TOP_P|VINP 8.664e-15
* device instance $1824 r0 *1 78.2,30.95 sky130_fd_pr__model__cap_mim
C$1824 \$594 TOP_P|VINP 8.664e-15
* device instance $1825 r0 *1 81.6,30.95 sky130_fd_pr__model__cap_mim
C$1825 \$605 TOP_P|VINP 8.664e-15
* device instance $1826 r0 *1 85,30.95 sky130_fd_pr__model__cap_mim
C$1826 \$606 TOP_P|VINP 8.664e-15
* device instance $1827 r0 *1 88.4,30.95 sky130_fd_pr__model__cap_mim
C$1827 \$605 TOP_P|VINP 8.664e-15
* device instance $1828 r0 *1 91.8,30.95 sky130_fd_pr__model__cap_mim
C$1828 \$607 TOP_P|VINP 8.664e-15
* device instance $1829 r0 *1 95.2,30.95 sky130_fd_pr__model__cap_mim
C$1829 \$605 TOP_P|VINP 8.664e-15
* device instance $1830 r0 *1 98.6,30.95 sky130_fd_pr__model__cap_mim
C$1830 \$606 TOP_P|VINP 8.664e-15
* device instance $1831 r0 *1 102,30.95 sky130_fd_pr__model__cap_mim
C$1831 \$605 TOP_P|VINP 8.664e-15
* device instance $1832 r0 *1 105.4,30.95 sky130_fd_pr__model__cap_mim
C$1832 \$592 TOP_P|VINP 8.664e-15
* device instance $1833 r0 *1 108.8,30.95 sky130_fd_pr__model__cap_mim
C$1833 \$591 TOP_P|VINP 8.664e-15
* device instance $1834 r0 *1 112.2,30.95 sky130_fd_pr__model__cap_mim
C$1834 \$605 TOP_P|VINP 8.664e-15
* device instance $1835 r0 *1 115.6,30.95 sky130_fd_pr__model__cap_mim
C$1835 \$606 TOP_P|VINP 8.664e-15
* device instance $1836 r0 *1 119,30.95 sky130_fd_pr__model__cap_mim
C$1836 \$605 TOP_P|VINP 8.664e-15
* device instance $1837 r0 *1 122.4,30.95 sky130_fd_pr__model__cap_mim
C$1837 \$607 TOP_P|VINP 8.664e-15
* device instance $1838 r0 *1 125.8,30.95 sky130_fd_pr__model__cap_mim
C$1838 \$605 TOP_P|VINP 8.664e-15
* device instance $1839 r0 *1 129.2,30.95 sky130_fd_pr__model__cap_mim
C$1839 \$606 TOP_P|VINP 8.664e-15
* device instance $1840 r0 *1 132.6,30.95 sky130_fd_pr__model__cap_mim
C$1840 \$605 TOP_P|VINP 8.664e-15
* device instance $1841 r0 *1 136,30.95 sky130_fd_pr__model__cap_mim
C$1841 \$594 TOP_P|VINP 8.664e-15
* device instance $1842 r0 *1 139.4,30.95 sky130_fd_pr__model__cap_mim
C$1842 \$605 TOP_P|VINP 8.664e-15
* device instance $1843 r0 *1 142.8,30.95 sky130_fd_pr__model__cap_mim
C$1843 \$606 TOP_P|VINP 8.664e-15
* device instance $1844 r0 *1 146.2,30.95 sky130_fd_pr__model__cap_mim
C$1844 \$605 TOP_P|VINP 8.664e-15
* device instance $1845 r0 *1 149.6,30.95 sky130_fd_pr__model__cap_mim
C$1845 \$607 TOP_P|VINP 8.664e-15
* device instance $1846 r0 *1 153,30.95 sky130_fd_pr__model__cap_mim
C$1846 \$605 TOP_P|VINP 8.664e-15
* device instance $1847 r0 *1 156.4,30.95 sky130_fd_pr__model__cap_mim
C$1847 \$606 TOP_P|VINP 8.664e-15
* device instance $1848 r0 *1 159.8,30.95 sky130_fd_pr__model__cap_mim
C$1848 \$605 TOP_P|VINP 8.664e-15
* device instance $1849 r0 *1 163.2,30.95 sky130_fd_pr__model__cap_mim
C$1849 \$593 TOP_P|VINP 8.664e-15
* device instance $1850 r0 *1 166.6,30.95 sky130_fd_pr__model__cap_mim
C$1850 \$605 TOP_P|VINP 8.664e-15
* device instance $1851 r0 *1 170,30.95 sky130_fd_pr__model__cap_mim
C$1851 \$606 TOP_P|VINP 8.664e-15
* device instance $1852 r0 *1 173.4,30.95 sky130_fd_pr__model__cap_mim
C$1852 \$605 TOP_P|VINP 8.664e-15
* device instance $1853 r0 *1 176.8,30.95 sky130_fd_pr__model__cap_mim
C$1853 \$607 TOP_P|VINP 8.664e-15
* device instance $1854 r0 *1 180.2,30.95 sky130_fd_pr__model__cap_mim
C$1854 \$605 TOP_P|VINP 8.664e-15
* device instance $1855 r0 *1 183.6,30.95 sky130_fd_pr__model__cap_mim
C$1855 \$606 TOP_P|VINP 8.664e-15
* device instance $1856 r0 *1 187,30.95 sky130_fd_pr__model__cap_mim
C$1856 \$605 TOP_P|VINP 8.664e-15
* device instance $1857 r0 *1 190.4,30.95 sky130_fd_pr__model__cap_mim
C$1857 \$594 TOP_P|VINP 8.664e-15
* device instance $1858 r0 *1 193.8,30.95 sky130_fd_pr__model__cap_mim
C$1858 \$605 TOP_P|VINP 8.664e-15
* device instance $1859 r0 *1 197.2,30.95 sky130_fd_pr__model__cap_mim
C$1859 \$606 TOP_P|VINP 8.664e-15
* device instance $1860 r0 *1 200.6,30.95 sky130_fd_pr__model__cap_mim
C$1860 \$605 TOP_P|VINP 8.664e-15
* device instance $1861 r0 *1 204,30.95 sky130_fd_pr__model__cap_mim
C$1861 \$607 TOP_P|VINP 8.664e-15
* device instance $1862 r0 *1 207.4,30.95 sky130_fd_pr__model__cap_mim
C$1862 \$605 TOP_P|VINP 8.664e-15
* device instance $1863 r0 *1 210.8,30.95 sky130_fd_pr__model__cap_mim
C$1863 \$606 TOP_P|VINP 8.664e-15
* device instance $1864 r0 *1 214.2,30.95 sky130_fd_pr__model__cap_mim
C$1864 \$605 TOP_P|VINP 8.664e-15
* device instance $1865 r0 *1 0,34.35 sky130_fd_pr__model__cap_mim
C$1865 \$601 TOP_N|VINN 8.664e-15
* device instance $1866 r0 *1 3.4,34.35 sky130_fd_pr__model__cap_mim
C$1866 \$602 TOP_N|VINN 8.664e-15
* device instance $1867 r0 *1 6.8,34.35 sky130_fd_pr__model__cap_mim
C$1867 \$601 TOP_N|VINN 8.664e-15
* device instance $1868 r0 *1 10.2,34.35 sky130_fd_pr__model__cap_mim
C$1868 \$603 TOP_N|VINN 8.664e-15
* device instance $1869 r0 *1 13.6,34.35 sky130_fd_pr__model__cap_mim
C$1869 \$601 TOP_N|VINN 8.664e-15
* device instance $1870 r0 *1 17,34.35 sky130_fd_pr__model__cap_mim
C$1870 \$602 TOP_N|VINN 8.664e-15
* device instance $1871 r0 *1 20.4,34.35 sky130_fd_pr__model__cap_mim
C$1871 \$601 TOP_N|VINN 8.664e-15
* device instance $1872 r0 *1 23.8,34.35 sky130_fd_pr__model__cap_mim
C$1872 \$604 TOP_N|VINN 8.664e-15
* device instance $1873 r0 *1 27.2,34.35 sky130_fd_pr__model__cap_mim
C$1873 \$601 TOP_N|VINN 8.664e-15
* device instance $1874 r0 *1 30.6,34.35 sky130_fd_pr__model__cap_mim
C$1874 \$602 TOP_N|VINN 8.664e-15
* device instance $1875 r0 *1 34,34.35 sky130_fd_pr__model__cap_mim
C$1875 \$601 TOP_N|VINN 8.664e-15
* device instance $1876 r0 *1 37.4,34.35 sky130_fd_pr__model__cap_mim
C$1876 \$603 TOP_N|VINN 8.664e-15
* device instance $1877 r0 *1 40.8,34.35 sky130_fd_pr__model__cap_mim
C$1877 \$601 TOP_N|VINN 8.664e-15
* device instance $1878 r0 *1 44.2,34.35 sky130_fd_pr__model__cap_mim
C$1878 \$602 TOP_N|VINN 8.664e-15
* device instance $1879 r0 *1 47.6,34.35 sky130_fd_pr__model__cap_mim
C$1879 \$601 TOP_N|VINN 8.664e-15
* device instance $1880 r0 *1 51,34.35 sky130_fd_pr__model__cap_mim
C$1880 \$599 TOP_N|VINN 8.664e-15
* device instance $1881 r0 *1 54.4,34.35 sky130_fd_pr__model__cap_mim
C$1881 \$601 TOP_N|VINN 8.664e-15
* device instance $1882 r0 *1 57.8,34.35 sky130_fd_pr__model__cap_mim
C$1882 \$602 TOP_N|VINN 8.664e-15
* device instance $1883 r0 *1 61.2,34.35 sky130_fd_pr__model__cap_mim
C$1883 \$601 TOP_N|VINN 8.664e-15
* device instance $1884 r0 *1 64.6,34.35 sky130_fd_pr__model__cap_mim
C$1884 \$603 TOP_N|VINN 8.664e-15
* device instance $1885 r0 *1 68,34.35 sky130_fd_pr__model__cap_mim
C$1885 \$601 TOP_N|VINN 8.664e-15
* device instance $1886 r0 *1 71.4,34.35 sky130_fd_pr__model__cap_mim
C$1886 \$602 TOP_N|VINN 8.664e-15
* device instance $1887 r0 *1 74.8,34.35 sky130_fd_pr__model__cap_mim
C$1887 \$601 TOP_N|VINN 8.664e-15
* device instance $1888 r0 *1 78.2,34.35 sky130_fd_pr__model__cap_mim
C$1888 \$604 TOP_N|VINN 8.664e-15
* device instance $1889 r0 *1 81.6,34.35 sky130_fd_pr__model__cap_mim
C$1889 \$601 TOP_N|VINN 8.664e-15
* device instance $1890 r0 *1 85,34.35 sky130_fd_pr__model__cap_mim
C$1890 \$602 TOP_N|VINN 8.664e-15
* device instance $1891 r0 *1 88.4,34.35 sky130_fd_pr__model__cap_mim
C$1891 \$601 TOP_N|VINN 8.664e-15
* device instance $1892 r0 *1 91.8,34.35 sky130_fd_pr__model__cap_mim
C$1892 \$603 TOP_N|VINN 8.664e-15
* device instance $1893 r0 *1 95.2,34.35 sky130_fd_pr__model__cap_mim
C$1893 \$601 TOP_N|VINN 8.664e-15
* device instance $1894 r0 *1 98.6,34.35 sky130_fd_pr__model__cap_mim
C$1894 \$602 TOP_N|VINN 8.664e-15
* device instance $1895 r0 *1 102,34.35 sky130_fd_pr__model__cap_mim
C$1895 \$601 TOP_N|VINN 8.664e-15
* device instance $1896 r0 *1 105.4,34.35 sky130_fd_pr__model__cap_mim
C$1896 \$598 TOP_N|VINN 8.664e-15
* device instance $1897 r0 *1 108.8,34.35 sky130_fd_pr__model__cap_mim
C$1897 \$596 TOP_N|VINN 8.664e-15
* device instance $1898 r0 *1 112.2,34.35 sky130_fd_pr__model__cap_mim
C$1898 \$601 TOP_N|VINN 8.664e-15
* device instance $1899 r0 *1 115.6,34.35 sky130_fd_pr__model__cap_mim
C$1899 \$602 TOP_N|VINN 8.664e-15
* device instance $1900 r0 *1 119,34.35 sky130_fd_pr__model__cap_mim
C$1900 \$601 TOP_N|VINN 8.664e-15
* device instance $1901 r0 *1 122.4,34.35 sky130_fd_pr__model__cap_mim
C$1901 \$603 TOP_N|VINN 8.664e-15
* device instance $1902 r0 *1 125.8,34.35 sky130_fd_pr__model__cap_mim
C$1902 \$601 TOP_N|VINN 8.664e-15
* device instance $1903 r0 *1 129.2,34.35 sky130_fd_pr__model__cap_mim
C$1903 \$602 TOP_N|VINN 8.664e-15
* device instance $1904 r0 *1 132.6,34.35 sky130_fd_pr__model__cap_mim
C$1904 \$601 TOP_N|VINN 8.664e-15
* device instance $1905 r0 *1 136,34.35 sky130_fd_pr__model__cap_mim
C$1905 \$604 TOP_N|VINN 8.664e-15
* device instance $1906 r0 *1 139.4,34.35 sky130_fd_pr__model__cap_mim
C$1906 \$601 TOP_N|VINN 8.664e-15
* device instance $1907 r0 *1 142.8,34.35 sky130_fd_pr__model__cap_mim
C$1907 \$602 TOP_N|VINN 8.664e-15
* device instance $1908 r0 *1 146.2,34.35 sky130_fd_pr__model__cap_mim
C$1908 \$601 TOP_N|VINN 8.664e-15
* device instance $1909 r0 *1 149.6,34.35 sky130_fd_pr__model__cap_mim
C$1909 \$603 TOP_N|VINN 8.664e-15
* device instance $1910 r0 *1 153,34.35 sky130_fd_pr__model__cap_mim
C$1910 \$601 TOP_N|VINN 8.664e-15
* device instance $1911 r0 *1 156.4,34.35 sky130_fd_pr__model__cap_mim
C$1911 \$602 TOP_N|VINN 8.664e-15
* device instance $1912 r0 *1 159.8,34.35 sky130_fd_pr__model__cap_mim
C$1912 \$601 TOP_N|VINN 8.664e-15
* device instance $1913 r0 *1 163.2,34.35 sky130_fd_pr__model__cap_mim
C$1913 \$599 TOP_N|VINN 8.664e-15
* device instance $1914 r0 *1 166.6,34.35 sky130_fd_pr__model__cap_mim
C$1914 \$601 TOP_N|VINN 8.664e-15
* device instance $1915 r0 *1 170,34.35 sky130_fd_pr__model__cap_mim
C$1915 \$602 TOP_N|VINN 8.664e-15
* device instance $1916 r0 *1 173.4,34.35 sky130_fd_pr__model__cap_mim
C$1916 \$601 TOP_N|VINN 8.664e-15
* device instance $1917 r0 *1 176.8,34.35 sky130_fd_pr__model__cap_mim
C$1917 \$603 TOP_N|VINN 8.664e-15
* device instance $1918 r0 *1 180.2,34.35 sky130_fd_pr__model__cap_mim
C$1918 \$601 TOP_N|VINN 8.664e-15
* device instance $1919 r0 *1 183.6,34.35 sky130_fd_pr__model__cap_mim
C$1919 \$602 TOP_N|VINN 8.664e-15
* device instance $1920 r0 *1 187,34.35 sky130_fd_pr__model__cap_mim
C$1920 \$601 TOP_N|VINN 8.664e-15
* device instance $1921 r0 *1 190.4,34.35 sky130_fd_pr__model__cap_mim
C$1921 \$604 TOP_N|VINN 8.664e-15
* device instance $1922 r0 *1 193.8,34.35 sky130_fd_pr__model__cap_mim
C$1922 \$601 TOP_N|VINN 8.664e-15
* device instance $1923 r0 *1 197.2,34.35 sky130_fd_pr__model__cap_mim
C$1923 \$602 TOP_N|VINN 8.664e-15
* device instance $1924 r0 *1 200.6,34.35 sky130_fd_pr__model__cap_mim
C$1924 \$601 TOP_N|VINN 8.664e-15
* device instance $1925 r0 *1 204,34.35 sky130_fd_pr__model__cap_mim
C$1925 \$603 TOP_N|VINN 8.664e-15
* device instance $1926 r0 *1 207.4,34.35 sky130_fd_pr__model__cap_mim
C$1926 \$601 TOP_N|VINN 8.664e-15
* device instance $1927 r0 *1 210.8,34.35 sky130_fd_pr__model__cap_mim
C$1927 \$602 TOP_N|VINN 8.664e-15
* device instance $1928 r0 *1 214.2,34.35 sky130_fd_pr__model__cap_mim
C$1928 \$601 TOP_N|VINN 8.664e-15
* device instance $1929 r0 *1 0,37.75 sky130_fd_pr__model__cap_mim
C$1929 \$605 TOP_P|VINP 8.664e-15
* device instance $1930 r0 *1 3.4,37.75 sky130_fd_pr__model__cap_mim
C$1930 \$606 TOP_P|VINP 8.664e-15
* device instance $1931 r0 *1 6.8,37.75 sky130_fd_pr__model__cap_mim
C$1931 \$605 TOP_P|VINP 8.664e-15
* device instance $1932 r0 *1 10.2,37.75 sky130_fd_pr__model__cap_mim
C$1932 \$607 TOP_P|VINP 8.664e-15
* device instance $1933 r0 *1 13.6,37.75 sky130_fd_pr__model__cap_mim
C$1933 \$605 TOP_P|VINP 8.664e-15
* device instance $1934 r0 *1 17,37.75 sky130_fd_pr__model__cap_mim
C$1934 \$606 TOP_P|VINP 8.664e-15
* device instance $1935 r0 *1 20.4,37.75 sky130_fd_pr__model__cap_mim
C$1935 \$605 TOP_P|VINP 8.664e-15
* device instance $1936 r0 *1 23.8,37.75 sky130_fd_pr__model__cap_mim
C$1936 \$594 TOP_P|VINP 8.664e-15
* device instance $1937 r0 *1 27.2,37.75 sky130_fd_pr__model__cap_mim
C$1937 \$605 TOP_P|VINP 8.664e-15
* device instance $1938 r0 *1 30.6,37.75 sky130_fd_pr__model__cap_mim
C$1938 \$606 TOP_P|VINP 8.664e-15
* device instance $1939 r0 *1 34,37.75 sky130_fd_pr__model__cap_mim
C$1939 \$605 TOP_P|VINP 8.664e-15
* device instance $1940 r0 *1 37.4,37.75 sky130_fd_pr__model__cap_mim
C$1940 \$607 TOP_P|VINP 8.664e-15
* device instance $1941 r0 *1 40.8,37.75 sky130_fd_pr__model__cap_mim
C$1941 \$605 TOP_P|VINP 8.664e-15
* device instance $1942 r0 *1 44.2,37.75 sky130_fd_pr__model__cap_mim
C$1942 \$606 TOP_P|VINP 8.664e-15
* device instance $1943 r0 *1 47.6,37.75 sky130_fd_pr__model__cap_mim
C$1943 \$605 TOP_P|VINP 8.664e-15
* device instance $1944 r0 *1 51,37.75 sky130_fd_pr__model__cap_mim
C$1944 \$593 TOP_P|VINP 8.664e-15
* device instance $1945 r0 *1 54.4,37.75 sky130_fd_pr__model__cap_mim
C$1945 \$605 TOP_P|VINP 8.664e-15
* device instance $1946 r0 *1 57.8,37.75 sky130_fd_pr__model__cap_mim
C$1946 \$606 TOP_P|VINP 8.664e-15
* device instance $1947 r0 *1 61.2,37.75 sky130_fd_pr__model__cap_mim
C$1947 \$605 TOP_P|VINP 8.664e-15
* device instance $1948 r0 *1 64.6,37.75 sky130_fd_pr__model__cap_mim
C$1948 \$607 TOP_P|VINP 8.664e-15
* device instance $1949 r0 *1 68,37.75 sky130_fd_pr__model__cap_mim
C$1949 \$605 TOP_P|VINP 8.664e-15
* device instance $1950 r0 *1 71.4,37.75 sky130_fd_pr__model__cap_mim
C$1950 \$606 TOP_P|VINP 8.664e-15
* device instance $1951 r0 *1 74.8,37.75 sky130_fd_pr__model__cap_mim
C$1951 \$605 TOP_P|VINP 8.664e-15
* device instance $1952 r0 *1 78.2,37.75 sky130_fd_pr__model__cap_mim
C$1952 \$594 TOP_P|VINP 8.664e-15
* device instance $1953 r0 *1 81.6,37.75 sky130_fd_pr__model__cap_mim
C$1953 \$605 TOP_P|VINP 8.664e-15
* device instance $1954 r0 *1 85,37.75 sky130_fd_pr__model__cap_mim
C$1954 \$606 TOP_P|VINP 8.664e-15
* device instance $1955 r0 *1 88.4,37.75 sky130_fd_pr__model__cap_mim
C$1955 \$605 TOP_P|VINP 8.664e-15
* device instance $1956 r0 *1 91.8,37.75 sky130_fd_pr__model__cap_mim
C$1956 \$607 TOP_P|VINP 8.664e-15
* device instance $1957 r0 *1 95.2,37.75 sky130_fd_pr__model__cap_mim
C$1957 \$605 TOP_P|VINP 8.664e-15
* device instance $1958 r0 *1 98.6,37.75 sky130_fd_pr__model__cap_mim
C$1958 \$606 TOP_P|VINP 8.664e-15
* device instance $1959 r0 *1 102,37.75 sky130_fd_pr__model__cap_mim
C$1959 \$605 TOP_P|VINP 8.664e-15
* device instance $1960 r0 *1 105.4,37.75 sky130_fd_pr__model__cap_mim
C$1960 \$592 TOP_P|VINP 8.664e-15
* device instance $1961 r0 *1 108.8,37.75 sky130_fd_pr__model__cap_mim
C$1961 \$590 TOP_P|VINP 8.664e-15
* device instance $1962 r0 *1 112.2,37.75 sky130_fd_pr__model__cap_mim
C$1962 \$605 TOP_P|VINP 8.664e-15
* device instance $1963 r0 *1 115.6,37.75 sky130_fd_pr__model__cap_mim
C$1963 \$606 TOP_P|VINP 8.664e-15
* device instance $1964 r0 *1 119,37.75 sky130_fd_pr__model__cap_mim
C$1964 \$605 TOP_P|VINP 8.664e-15
* device instance $1965 r0 *1 122.4,37.75 sky130_fd_pr__model__cap_mim
C$1965 \$607 TOP_P|VINP 8.664e-15
* device instance $1966 r0 *1 125.8,37.75 sky130_fd_pr__model__cap_mim
C$1966 \$605 TOP_P|VINP 8.664e-15
* device instance $1967 r0 *1 129.2,37.75 sky130_fd_pr__model__cap_mim
C$1967 \$606 TOP_P|VINP 8.664e-15
* device instance $1968 r0 *1 132.6,37.75 sky130_fd_pr__model__cap_mim
C$1968 \$605 TOP_P|VINP 8.664e-15
* device instance $1969 r0 *1 136,37.75 sky130_fd_pr__model__cap_mim
C$1969 \$594 TOP_P|VINP 8.664e-15
* device instance $1970 r0 *1 139.4,37.75 sky130_fd_pr__model__cap_mim
C$1970 \$605 TOP_P|VINP 8.664e-15
* device instance $1971 r0 *1 142.8,37.75 sky130_fd_pr__model__cap_mim
C$1971 \$606 TOP_P|VINP 8.664e-15
* device instance $1972 r0 *1 146.2,37.75 sky130_fd_pr__model__cap_mim
C$1972 \$605 TOP_P|VINP 8.664e-15
* device instance $1973 r0 *1 149.6,37.75 sky130_fd_pr__model__cap_mim
C$1973 \$607 TOP_P|VINP 8.664e-15
* device instance $1974 r0 *1 153,37.75 sky130_fd_pr__model__cap_mim
C$1974 \$605 TOP_P|VINP 8.664e-15
* device instance $1975 r0 *1 156.4,37.75 sky130_fd_pr__model__cap_mim
C$1975 \$606 TOP_P|VINP 8.664e-15
* device instance $1976 r0 *1 159.8,37.75 sky130_fd_pr__model__cap_mim
C$1976 \$605 TOP_P|VINP 8.664e-15
* device instance $1977 r0 *1 163.2,37.75 sky130_fd_pr__model__cap_mim
C$1977 \$593 TOP_P|VINP 8.664e-15
* device instance $1978 r0 *1 166.6,37.75 sky130_fd_pr__model__cap_mim
C$1978 \$605 TOP_P|VINP 8.664e-15
* device instance $1979 r0 *1 170,37.75 sky130_fd_pr__model__cap_mim
C$1979 \$606 TOP_P|VINP 8.664e-15
* device instance $1980 r0 *1 173.4,37.75 sky130_fd_pr__model__cap_mim
C$1980 \$605 TOP_P|VINP 8.664e-15
* device instance $1981 r0 *1 176.8,37.75 sky130_fd_pr__model__cap_mim
C$1981 \$607 TOP_P|VINP 8.664e-15
* device instance $1982 r0 *1 180.2,37.75 sky130_fd_pr__model__cap_mim
C$1982 \$605 TOP_P|VINP 8.664e-15
* device instance $1983 r0 *1 183.6,37.75 sky130_fd_pr__model__cap_mim
C$1983 \$606 TOP_P|VINP 8.664e-15
* device instance $1984 r0 *1 187,37.75 sky130_fd_pr__model__cap_mim
C$1984 \$605 TOP_P|VINP 8.664e-15
* device instance $1985 r0 *1 190.4,37.75 sky130_fd_pr__model__cap_mim
C$1985 \$594 TOP_P|VINP 8.664e-15
* device instance $1986 r0 *1 193.8,37.75 sky130_fd_pr__model__cap_mim
C$1986 \$605 TOP_P|VINP 8.664e-15
* device instance $1987 r0 *1 197.2,37.75 sky130_fd_pr__model__cap_mim
C$1987 \$606 TOP_P|VINP 8.664e-15
* device instance $1988 r0 *1 200.6,37.75 sky130_fd_pr__model__cap_mim
C$1988 \$605 TOP_P|VINP 8.664e-15
* device instance $1989 r0 *1 204,37.75 sky130_fd_pr__model__cap_mim
C$1989 \$607 TOP_P|VINP 8.664e-15
* device instance $1990 r0 *1 207.4,37.75 sky130_fd_pr__model__cap_mim
C$1990 \$605 TOP_P|VINP 8.664e-15
* device instance $1991 r0 *1 210.8,37.75 sky130_fd_pr__model__cap_mim
C$1991 \$606 TOP_P|VINP 8.664e-15
* device instance $1992 r0 *1 214.2,37.75 sky130_fd_pr__model__cap_mim
C$1992 \$605 TOP_P|VINP 8.664e-15
* device instance $1993 r0 *1 0,41.15 sky130_fd_pr__model__cap_mim
C$1993 \$601 TOP_N|VINN 8.664e-15
* device instance $1994 r0 *1 3.4,41.15 sky130_fd_pr__model__cap_mim
C$1994 \$602 TOP_N|VINN 8.664e-15
* device instance $1995 r0 *1 6.8,41.15 sky130_fd_pr__model__cap_mim
C$1995 \$601 TOP_N|VINN 8.664e-15
* device instance $1996 r0 *1 10.2,41.15 sky130_fd_pr__model__cap_mim
C$1996 \$603 TOP_N|VINN 8.664e-15
* device instance $1997 r0 *1 13.6,41.15 sky130_fd_pr__model__cap_mim
C$1997 \$601 TOP_N|VINN 8.664e-15
* device instance $1998 r0 *1 17,41.15 sky130_fd_pr__model__cap_mim
C$1998 \$602 TOP_N|VINN 8.664e-15
* device instance $1999 r0 *1 20.4,41.15 sky130_fd_pr__model__cap_mim
C$1999 \$601 TOP_N|VINN 8.664e-15
* device instance $2000 r0 *1 23.8,41.15 sky130_fd_pr__model__cap_mim
C$2000 \$604 TOP_N|VINN 8.664e-15
* device instance $2001 r0 *1 27.2,41.15 sky130_fd_pr__model__cap_mim
C$2001 \$601 TOP_N|VINN 8.664e-15
* device instance $2002 r0 *1 30.6,41.15 sky130_fd_pr__model__cap_mim
C$2002 \$602 TOP_N|VINN 8.664e-15
* device instance $2003 r0 *1 34,41.15 sky130_fd_pr__model__cap_mim
C$2003 \$601 TOP_N|VINN 8.664e-15
* device instance $2004 r0 *1 37.4,41.15 sky130_fd_pr__model__cap_mim
C$2004 \$603 TOP_N|VINN 8.664e-15
* device instance $2005 r0 *1 40.8,41.15 sky130_fd_pr__model__cap_mim
C$2005 \$601 TOP_N|VINN 8.664e-15
* device instance $2006 r0 *1 44.2,41.15 sky130_fd_pr__model__cap_mim
C$2006 \$602 TOP_N|VINN 8.664e-15
* device instance $2007 r0 *1 47.6,41.15 sky130_fd_pr__model__cap_mim
C$2007 \$601 TOP_N|VINN 8.664e-15
* device instance $2008 r0 *1 51,41.15 sky130_fd_pr__model__cap_mim
C$2008 \$599 TOP_N|VINN 8.664e-15
* device instance $2009 r0 *1 54.4,41.15 sky130_fd_pr__model__cap_mim
C$2009 \$601 TOP_N|VINN 8.664e-15
* device instance $2010 r0 *1 57.8,41.15 sky130_fd_pr__model__cap_mim
C$2010 \$602 TOP_N|VINN 8.664e-15
* device instance $2011 r0 *1 61.2,41.15 sky130_fd_pr__model__cap_mim
C$2011 \$601 TOP_N|VINN 8.664e-15
* device instance $2012 r0 *1 64.6,41.15 sky130_fd_pr__model__cap_mim
C$2012 \$603 TOP_N|VINN 8.664e-15
* device instance $2013 r0 *1 68,41.15 sky130_fd_pr__model__cap_mim
C$2013 \$601 TOP_N|VINN 8.664e-15
* device instance $2014 r0 *1 71.4,41.15 sky130_fd_pr__model__cap_mim
C$2014 \$602 TOP_N|VINN 8.664e-15
* device instance $2015 r0 *1 74.8,41.15 sky130_fd_pr__model__cap_mim
C$2015 \$601 TOP_N|VINN 8.664e-15
* device instance $2016 r0 *1 78.2,41.15 sky130_fd_pr__model__cap_mim
C$2016 \$604 TOP_N|VINN 8.664e-15
* device instance $2017 r0 *1 81.6,41.15 sky130_fd_pr__model__cap_mim
C$2017 \$601 TOP_N|VINN 8.664e-15
* device instance $2018 r0 *1 85,41.15 sky130_fd_pr__model__cap_mim
C$2018 \$602 TOP_N|VINN 8.664e-15
* device instance $2019 r0 *1 88.4,41.15 sky130_fd_pr__model__cap_mim
C$2019 \$601 TOP_N|VINN 8.664e-15
* device instance $2020 r0 *1 91.8,41.15 sky130_fd_pr__model__cap_mim
C$2020 \$603 TOP_N|VINN 8.664e-15
* device instance $2021 r0 *1 95.2,41.15 sky130_fd_pr__model__cap_mim
C$2021 \$601 TOP_N|VINN 8.664e-15
* device instance $2022 r0 *1 98.6,41.15 sky130_fd_pr__model__cap_mim
C$2022 \$602 TOP_N|VINN 8.664e-15
* device instance $2023 r0 *1 102,41.15 sky130_fd_pr__model__cap_mim
C$2023 \$601 TOP_N|VINN 8.664e-15
* device instance $2024 r0 *1 105.4,41.15 sky130_fd_pr__model__cap_mim
C$2024 \$598 TOP_N|VINN 8.664e-15
* device instance $2025 r0 *1 108.8,41.15 sky130_fd_pr__model__cap_mim
C$2025 \$597 TOP_N|VINN 8.664e-15
* device instance $2026 r0 *1 112.2,41.15 sky130_fd_pr__model__cap_mim
C$2026 \$601 TOP_N|VINN 8.664e-15
* device instance $2027 r0 *1 115.6,41.15 sky130_fd_pr__model__cap_mim
C$2027 \$602 TOP_N|VINN 8.664e-15
* device instance $2028 r0 *1 119,41.15 sky130_fd_pr__model__cap_mim
C$2028 \$601 TOP_N|VINN 8.664e-15
* device instance $2029 r0 *1 122.4,41.15 sky130_fd_pr__model__cap_mim
C$2029 \$603 TOP_N|VINN 8.664e-15
* device instance $2030 r0 *1 125.8,41.15 sky130_fd_pr__model__cap_mim
C$2030 \$601 TOP_N|VINN 8.664e-15
* device instance $2031 r0 *1 129.2,41.15 sky130_fd_pr__model__cap_mim
C$2031 \$602 TOP_N|VINN 8.664e-15
* device instance $2032 r0 *1 132.6,41.15 sky130_fd_pr__model__cap_mim
C$2032 \$601 TOP_N|VINN 8.664e-15
* device instance $2033 r0 *1 136,41.15 sky130_fd_pr__model__cap_mim
C$2033 \$604 TOP_N|VINN 8.664e-15
* device instance $2034 r0 *1 139.4,41.15 sky130_fd_pr__model__cap_mim
C$2034 \$601 TOP_N|VINN 8.664e-15
* device instance $2035 r0 *1 142.8,41.15 sky130_fd_pr__model__cap_mim
C$2035 \$602 TOP_N|VINN 8.664e-15
* device instance $2036 r0 *1 146.2,41.15 sky130_fd_pr__model__cap_mim
C$2036 \$601 TOP_N|VINN 8.664e-15
* device instance $2037 r0 *1 149.6,41.15 sky130_fd_pr__model__cap_mim
C$2037 \$603 TOP_N|VINN 8.664e-15
* device instance $2038 r0 *1 153,41.15 sky130_fd_pr__model__cap_mim
C$2038 \$601 TOP_N|VINN 8.664e-15
* device instance $2039 r0 *1 156.4,41.15 sky130_fd_pr__model__cap_mim
C$2039 \$602 TOP_N|VINN 8.664e-15
* device instance $2040 r0 *1 159.8,41.15 sky130_fd_pr__model__cap_mim
C$2040 \$601 TOP_N|VINN 8.664e-15
* device instance $2041 r0 *1 163.2,41.15 sky130_fd_pr__model__cap_mim
C$2041 \$599 TOP_N|VINN 8.664e-15
* device instance $2042 r0 *1 166.6,41.15 sky130_fd_pr__model__cap_mim
C$2042 \$601 TOP_N|VINN 8.664e-15
* device instance $2043 r0 *1 170,41.15 sky130_fd_pr__model__cap_mim
C$2043 \$602 TOP_N|VINN 8.664e-15
* device instance $2044 r0 *1 173.4,41.15 sky130_fd_pr__model__cap_mim
C$2044 \$601 TOP_N|VINN 8.664e-15
* device instance $2045 r0 *1 176.8,41.15 sky130_fd_pr__model__cap_mim
C$2045 \$603 TOP_N|VINN 8.664e-15
* device instance $2046 r0 *1 180.2,41.15 sky130_fd_pr__model__cap_mim
C$2046 \$601 TOP_N|VINN 8.664e-15
* device instance $2047 r0 *1 183.6,41.15 sky130_fd_pr__model__cap_mim
C$2047 \$602 TOP_N|VINN 8.664e-15
* device instance $2048 r0 *1 187,41.15 sky130_fd_pr__model__cap_mim
C$2048 \$601 TOP_N|VINN 8.664e-15
* device instance $2049 r0 *1 190.4,41.15 sky130_fd_pr__model__cap_mim
C$2049 \$604 TOP_N|VINN 8.664e-15
* device instance $2050 r0 *1 193.8,41.15 sky130_fd_pr__model__cap_mim
C$2050 \$601 TOP_N|VINN 8.664e-15
* device instance $2051 r0 *1 197.2,41.15 sky130_fd_pr__model__cap_mim
C$2051 \$602 TOP_N|VINN 8.664e-15
* device instance $2052 r0 *1 200.6,41.15 sky130_fd_pr__model__cap_mim
C$2052 \$601 TOP_N|VINN 8.664e-15
* device instance $2053 r0 *1 204,41.15 sky130_fd_pr__model__cap_mim
C$2053 \$603 TOP_N|VINN 8.664e-15
* device instance $2054 r0 *1 207.4,41.15 sky130_fd_pr__model__cap_mim
C$2054 \$601 TOP_N|VINN 8.664e-15
* device instance $2055 r0 *1 210.8,41.15 sky130_fd_pr__model__cap_mim
C$2055 \$602 TOP_N|VINN 8.664e-15
* device instance $2056 r0 *1 214.2,41.15 sky130_fd_pr__model__cap_mim
C$2056 \$601 TOP_N|VINN 8.664e-15
* device instance $2057 r0 *1 0,44.55 sky130_fd_pr__model__cap_mim
C$2057 \$605 TOP_P|VINP 8.664e-15
* device instance $2058 r0 *1 3.4,44.55 sky130_fd_pr__model__cap_mim
C$2058 \$606 TOP_P|VINP 8.664e-15
* device instance $2059 r0 *1 6.8,44.55 sky130_fd_pr__model__cap_mim
C$2059 \$605 TOP_P|VINP 8.664e-15
* device instance $2060 r0 *1 10.2,44.55 sky130_fd_pr__model__cap_mim
C$2060 \$607 TOP_P|VINP 8.664e-15
* device instance $2061 r0 *1 13.6,44.55 sky130_fd_pr__model__cap_mim
C$2061 \$605 TOP_P|VINP 8.664e-15
* device instance $2062 r0 *1 17,44.55 sky130_fd_pr__model__cap_mim
C$2062 \$606 TOP_P|VINP 8.664e-15
* device instance $2063 r0 *1 20.4,44.55 sky130_fd_pr__model__cap_mim
C$2063 \$605 TOP_P|VINP 8.664e-15
* device instance $2064 r0 *1 23.8,44.55 sky130_fd_pr__model__cap_mim
C$2064 \$594 TOP_P|VINP 8.664e-15
* device instance $2065 r0 *1 27.2,44.55 sky130_fd_pr__model__cap_mim
C$2065 \$605 TOP_P|VINP 8.664e-15
* device instance $2066 r0 *1 30.6,44.55 sky130_fd_pr__model__cap_mim
C$2066 \$606 TOP_P|VINP 8.664e-15
* device instance $2067 r0 *1 34,44.55 sky130_fd_pr__model__cap_mim
C$2067 \$605 TOP_P|VINP 8.664e-15
* device instance $2068 r0 *1 37.4,44.55 sky130_fd_pr__model__cap_mim
C$2068 \$607 TOP_P|VINP 8.664e-15
* device instance $2069 r0 *1 40.8,44.55 sky130_fd_pr__model__cap_mim
C$2069 \$605 TOP_P|VINP 8.664e-15
* device instance $2070 r0 *1 44.2,44.55 sky130_fd_pr__model__cap_mim
C$2070 \$606 TOP_P|VINP 8.664e-15
* device instance $2071 r0 *1 47.6,44.55 sky130_fd_pr__model__cap_mim
C$2071 \$605 TOP_P|VINP 8.664e-15
* device instance $2072 r0 *1 51,44.55 sky130_fd_pr__model__cap_mim
C$2072 \$593 TOP_P|VINP 8.664e-15
* device instance $2073 r0 *1 54.4,44.55 sky130_fd_pr__model__cap_mim
C$2073 \$605 TOP_P|VINP 8.664e-15
* device instance $2074 r0 *1 57.8,44.55 sky130_fd_pr__model__cap_mim
C$2074 \$606 TOP_P|VINP 8.664e-15
* device instance $2075 r0 *1 61.2,44.55 sky130_fd_pr__model__cap_mim
C$2075 \$605 TOP_P|VINP 8.664e-15
* device instance $2076 r0 *1 64.6,44.55 sky130_fd_pr__model__cap_mim
C$2076 \$607 TOP_P|VINP 8.664e-15
* device instance $2077 r0 *1 68,44.55 sky130_fd_pr__model__cap_mim
C$2077 \$605 TOP_P|VINP 8.664e-15
* device instance $2078 r0 *1 71.4,44.55 sky130_fd_pr__model__cap_mim
C$2078 \$606 TOP_P|VINP 8.664e-15
* device instance $2079 r0 *1 74.8,44.55 sky130_fd_pr__model__cap_mim
C$2079 \$605 TOP_P|VINP 8.664e-15
* device instance $2080 r0 *1 78.2,44.55 sky130_fd_pr__model__cap_mim
C$2080 \$594 TOP_P|VINP 8.664e-15
* device instance $2081 r0 *1 81.6,44.55 sky130_fd_pr__model__cap_mim
C$2081 \$605 TOP_P|VINP 8.664e-15
* device instance $2082 r0 *1 85,44.55 sky130_fd_pr__model__cap_mim
C$2082 \$606 TOP_P|VINP 8.664e-15
* device instance $2083 r0 *1 88.4,44.55 sky130_fd_pr__model__cap_mim
C$2083 \$605 TOP_P|VINP 8.664e-15
* device instance $2084 r0 *1 91.8,44.55 sky130_fd_pr__model__cap_mim
C$2084 \$607 TOP_P|VINP 8.664e-15
* device instance $2085 r0 *1 95.2,44.55 sky130_fd_pr__model__cap_mim
C$2085 \$605 TOP_P|VINP 8.664e-15
* device instance $2086 r0 *1 98.6,44.55 sky130_fd_pr__model__cap_mim
C$2086 \$606 TOP_P|VINP 8.664e-15
* device instance $2087 r0 *1 102,44.55 sky130_fd_pr__model__cap_mim
C$2087 \$605 TOP_P|VINP 8.664e-15
* device instance $2088 r0 *1 105.4,44.55 sky130_fd_pr__model__cap_mim
C$2088 \$592 TOP_P|VINP 8.664e-15
* device instance $2089 r0 *1 108.8,44.55 sky130_fd_pr__model__cap_mim
C$2089 \$591 TOP_P|VINP 8.664e-15
* device instance $2090 r0 *1 112.2,44.55 sky130_fd_pr__model__cap_mim
C$2090 \$605 TOP_P|VINP 8.664e-15
* device instance $2091 r0 *1 115.6,44.55 sky130_fd_pr__model__cap_mim
C$2091 \$606 TOP_P|VINP 8.664e-15
* device instance $2092 r0 *1 119,44.55 sky130_fd_pr__model__cap_mim
C$2092 \$605 TOP_P|VINP 8.664e-15
* device instance $2093 r0 *1 122.4,44.55 sky130_fd_pr__model__cap_mim
C$2093 \$607 TOP_P|VINP 8.664e-15
* device instance $2094 r0 *1 125.8,44.55 sky130_fd_pr__model__cap_mim
C$2094 \$605 TOP_P|VINP 8.664e-15
* device instance $2095 r0 *1 129.2,44.55 sky130_fd_pr__model__cap_mim
C$2095 \$606 TOP_P|VINP 8.664e-15
* device instance $2096 r0 *1 132.6,44.55 sky130_fd_pr__model__cap_mim
C$2096 \$605 TOP_P|VINP 8.664e-15
* device instance $2097 r0 *1 136,44.55 sky130_fd_pr__model__cap_mim
C$2097 \$594 TOP_P|VINP 8.664e-15
* device instance $2098 r0 *1 139.4,44.55 sky130_fd_pr__model__cap_mim
C$2098 \$605 TOP_P|VINP 8.664e-15
* device instance $2099 r0 *1 142.8,44.55 sky130_fd_pr__model__cap_mim
C$2099 \$606 TOP_P|VINP 8.664e-15
* device instance $2100 r0 *1 146.2,44.55 sky130_fd_pr__model__cap_mim
C$2100 \$605 TOP_P|VINP 8.664e-15
* device instance $2101 r0 *1 149.6,44.55 sky130_fd_pr__model__cap_mim
C$2101 \$607 TOP_P|VINP 8.664e-15
* device instance $2102 r0 *1 153,44.55 sky130_fd_pr__model__cap_mim
C$2102 \$605 TOP_P|VINP 8.664e-15
* device instance $2103 r0 *1 156.4,44.55 sky130_fd_pr__model__cap_mim
C$2103 \$606 TOP_P|VINP 8.664e-15
* device instance $2104 r0 *1 159.8,44.55 sky130_fd_pr__model__cap_mim
C$2104 \$605 TOP_P|VINP 8.664e-15
* device instance $2105 r0 *1 163.2,44.55 sky130_fd_pr__model__cap_mim
C$2105 \$593 TOP_P|VINP 8.664e-15
* device instance $2106 r0 *1 166.6,44.55 sky130_fd_pr__model__cap_mim
C$2106 \$605 TOP_P|VINP 8.664e-15
* device instance $2107 r0 *1 170,44.55 sky130_fd_pr__model__cap_mim
C$2107 \$606 TOP_P|VINP 8.664e-15
* device instance $2108 r0 *1 173.4,44.55 sky130_fd_pr__model__cap_mim
C$2108 \$605 TOP_P|VINP 8.664e-15
* device instance $2109 r0 *1 176.8,44.55 sky130_fd_pr__model__cap_mim
C$2109 \$607 TOP_P|VINP 8.664e-15
* device instance $2110 r0 *1 180.2,44.55 sky130_fd_pr__model__cap_mim
C$2110 \$605 TOP_P|VINP 8.664e-15
* device instance $2111 r0 *1 183.6,44.55 sky130_fd_pr__model__cap_mim
C$2111 \$606 TOP_P|VINP 8.664e-15
* device instance $2112 r0 *1 187,44.55 sky130_fd_pr__model__cap_mim
C$2112 \$605 TOP_P|VINP 8.664e-15
* device instance $2113 r0 *1 190.4,44.55 sky130_fd_pr__model__cap_mim
C$2113 \$594 TOP_P|VINP 8.664e-15
* device instance $2114 r0 *1 193.8,44.55 sky130_fd_pr__model__cap_mim
C$2114 \$605 TOP_P|VINP 8.664e-15
* device instance $2115 r0 *1 197.2,44.55 sky130_fd_pr__model__cap_mim
C$2115 \$606 TOP_P|VINP 8.664e-15
* device instance $2116 r0 *1 200.6,44.55 sky130_fd_pr__model__cap_mim
C$2116 \$605 TOP_P|VINP 8.664e-15
* device instance $2117 r0 *1 204,44.55 sky130_fd_pr__model__cap_mim
C$2117 \$607 TOP_P|VINP 8.664e-15
* device instance $2118 r0 *1 207.4,44.55 sky130_fd_pr__model__cap_mim
C$2118 \$605 TOP_P|VINP 8.664e-15
* device instance $2119 r0 *1 210.8,44.55 sky130_fd_pr__model__cap_mim
C$2119 \$606 TOP_P|VINP 8.664e-15
* device instance $2120 r0 *1 214.2,44.55 sky130_fd_pr__model__cap_mim
C$2120 \$605 TOP_P|VINP 8.664e-15
* device instance $2121 r0 *1 0,47.95 sky130_fd_pr__model__cap_mim
C$2121 \$601 TOP_N|VINN 8.664e-15
* device instance $2122 r0 *1 3.4,47.95 sky130_fd_pr__model__cap_mim
C$2122 \$602 TOP_N|VINN 8.664e-15
* device instance $2123 r0 *1 6.8,47.95 sky130_fd_pr__model__cap_mim
C$2123 \$601 TOP_N|VINN 8.664e-15
* device instance $2124 r0 *1 10.2,47.95 sky130_fd_pr__model__cap_mim
C$2124 \$603 TOP_N|VINN 8.664e-15
* device instance $2125 r0 *1 13.6,47.95 sky130_fd_pr__model__cap_mim
C$2125 \$601 TOP_N|VINN 8.664e-15
* device instance $2126 r0 *1 17,47.95 sky130_fd_pr__model__cap_mim
C$2126 \$602 TOP_N|VINN 8.664e-15
* device instance $2127 r0 *1 20.4,47.95 sky130_fd_pr__model__cap_mim
C$2127 \$601 TOP_N|VINN 8.664e-15
* device instance $2128 r0 *1 23.8,47.95 sky130_fd_pr__model__cap_mim
C$2128 \$604 TOP_N|VINN 8.664e-15
* device instance $2129 r0 *1 27.2,47.95 sky130_fd_pr__model__cap_mim
C$2129 \$601 TOP_N|VINN 8.664e-15
* device instance $2130 r0 *1 30.6,47.95 sky130_fd_pr__model__cap_mim
C$2130 \$602 TOP_N|VINN 8.664e-15
* device instance $2131 r0 *1 34,47.95 sky130_fd_pr__model__cap_mim
C$2131 \$601 TOP_N|VINN 8.664e-15
* device instance $2132 r0 *1 37.4,47.95 sky130_fd_pr__model__cap_mim
C$2132 \$603 TOP_N|VINN 8.664e-15
* device instance $2133 r0 *1 40.8,47.95 sky130_fd_pr__model__cap_mim
C$2133 \$601 TOP_N|VINN 8.664e-15
* device instance $2134 r0 *1 44.2,47.95 sky130_fd_pr__model__cap_mim
C$2134 \$602 TOP_N|VINN 8.664e-15
* device instance $2135 r0 *1 47.6,47.95 sky130_fd_pr__model__cap_mim
C$2135 \$601 TOP_N|VINN 8.664e-15
* device instance $2136 r0 *1 51,47.95 sky130_fd_pr__model__cap_mim
C$2136 \$599 TOP_N|VINN 8.664e-15
* device instance $2137 r0 *1 54.4,47.95 sky130_fd_pr__model__cap_mim
C$2137 \$601 TOP_N|VINN 8.664e-15
* device instance $2138 r0 *1 57.8,47.95 sky130_fd_pr__model__cap_mim
C$2138 \$602 TOP_N|VINN 8.664e-15
* device instance $2139 r0 *1 61.2,47.95 sky130_fd_pr__model__cap_mim
C$2139 \$601 TOP_N|VINN 8.664e-15
* device instance $2140 r0 *1 64.6,47.95 sky130_fd_pr__model__cap_mim
C$2140 \$603 TOP_N|VINN 8.664e-15
* device instance $2141 r0 *1 68,47.95 sky130_fd_pr__model__cap_mim
C$2141 \$601 TOP_N|VINN 8.664e-15
* device instance $2142 r0 *1 71.4,47.95 sky130_fd_pr__model__cap_mim
C$2142 \$602 TOP_N|VINN 8.664e-15
* device instance $2143 r0 *1 74.8,47.95 sky130_fd_pr__model__cap_mim
C$2143 \$601 TOP_N|VINN 8.664e-15
* device instance $2144 r0 *1 78.2,47.95 sky130_fd_pr__model__cap_mim
C$2144 \$604 TOP_N|VINN 8.664e-15
* device instance $2145 r0 *1 81.6,47.95 sky130_fd_pr__model__cap_mim
C$2145 \$601 TOP_N|VINN 8.664e-15
* device instance $2146 r0 *1 85,47.95 sky130_fd_pr__model__cap_mim
C$2146 \$602 TOP_N|VINN 8.664e-15
* device instance $2147 r0 *1 88.4,47.95 sky130_fd_pr__model__cap_mim
C$2147 \$601 TOP_N|VINN 8.664e-15
* device instance $2148 r0 *1 91.8,47.95 sky130_fd_pr__model__cap_mim
C$2148 \$603 TOP_N|VINN 8.664e-15
* device instance $2149 r0 *1 95.2,47.95 sky130_fd_pr__model__cap_mim
C$2149 \$601 TOP_N|VINN 8.664e-15
* device instance $2150 r0 *1 98.6,47.95 sky130_fd_pr__model__cap_mim
C$2150 \$602 TOP_N|VINN 8.664e-15
* device instance $2151 r0 *1 102,47.95 sky130_fd_pr__model__cap_mim
C$2151 \$601 TOP_N|VINN 8.664e-15
* device instance $2152 r0 *1 105.4,47.95 sky130_fd_pr__model__cap_mim
C$2152 \$598 TOP_N|VINN 8.664e-15
* device instance $2153 r0 *1 108.8,47.95 sky130_fd_pr__model__cap_mim
C$2153 VREFN TOP_N|VINN 8.664e-15
* device instance $2154 r0 *1 112.2,47.95 sky130_fd_pr__model__cap_mim
C$2154 \$601 TOP_N|VINN 8.664e-15
* device instance $2155 r0 *1 115.6,47.95 sky130_fd_pr__model__cap_mim
C$2155 \$602 TOP_N|VINN 8.664e-15
* device instance $2156 r0 *1 119,47.95 sky130_fd_pr__model__cap_mim
C$2156 \$601 TOP_N|VINN 8.664e-15
* device instance $2157 r0 *1 122.4,47.95 sky130_fd_pr__model__cap_mim
C$2157 \$603 TOP_N|VINN 8.664e-15
* device instance $2158 r0 *1 125.8,47.95 sky130_fd_pr__model__cap_mim
C$2158 \$601 TOP_N|VINN 8.664e-15
* device instance $2159 r0 *1 129.2,47.95 sky130_fd_pr__model__cap_mim
C$2159 \$602 TOP_N|VINN 8.664e-15
* device instance $2160 r0 *1 132.6,47.95 sky130_fd_pr__model__cap_mim
C$2160 \$601 TOP_N|VINN 8.664e-15
* device instance $2161 r0 *1 136,47.95 sky130_fd_pr__model__cap_mim
C$2161 \$604 TOP_N|VINN 8.664e-15
* device instance $2162 r0 *1 139.4,47.95 sky130_fd_pr__model__cap_mim
C$2162 \$601 TOP_N|VINN 8.664e-15
* device instance $2163 r0 *1 142.8,47.95 sky130_fd_pr__model__cap_mim
C$2163 \$602 TOP_N|VINN 8.664e-15
* device instance $2164 r0 *1 146.2,47.95 sky130_fd_pr__model__cap_mim
C$2164 \$601 TOP_N|VINN 8.664e-15
* device instance $2165 r0 *1 149.6,47.95 sky130_fd_pr__model__cap_mim
C$2165 \$603 TOP_N|VINN 8.664e-15
* device instance $2166 r0 *1 153,47.95 sky130_fd_pr__model__cap_mim
C$2166 \$601 TOP_N|VINN 8.664e-15
* device instance $2167 r0 *1 156.4,47.95 sky130_fd_pr__model__cap_mim
C$2167 \$602 TOP_N|VINN 8.664e-15
* device instance $2168 r0 *1 159.8,47.95 sky130_fd_pr__model__cap_mim
C$2168 \$601 TOP_N|VINN 8.664e-15
* device instance $2169 r0 *1 163.2,47.95 sky130_fd_pr__model__cap_mim
C$2169 \$599 TOP_N|VINN 8.664e-15
* device instance $2170 r0 *1 166.6,47.95 sky130_fd_pr__model__cap_mim
C$2170 \$601 TOP_N|VINN 8.664e-15
* device instance $2171 r0 *1 170,47.95 sky130_fd_pr__model__cap_mim
C$2171 \$602 TOP_N|VINN 8.664e-15
* device instance $2172 r0 *1 173.4,47.95 sky130_fd_pr__model__cap_mim
C$2172 \$601 TOP_N|VINN 8.664e-15
* device instance $2173 r0 *1 176.8,47.95 sky130_fd_pr__model__cap_mim
C$2173 \$603 TOP_N|VINN 8.664e-15
* device instance $2174 r0 *1 180.2,47.95 sky130_fd_pr__model__cap_mim
C$2174 \$601 TOP_N|VINN 8.664e-15
* device instance $2175 r0 *1 183.6,47.95 sky130_fd_pr__model__cap_mim
C$2175 \$602 TOP_N|VINN 8.664e-15
* device instance $2176 r0 *1 187,47.95 sky130_fd_pr__model__cap_mim
C$2176 \$601 TOP_N|VINN 8.664e-15
* device instance $2177 r0 *1 190.4,47.95 sky130_fd_pr__model__cap_mim
C$2177 \$604 TOP_N|VINN 8.664e-15
* device instance $2178 r0 *1 193.8,47.95 sky130_fd_pr__model__cap_mim
C$2178 \$601 TOP_N|VINN 8.664e-15
* device instance $2179 r0 *1 197.2,47.95 sky130_fd_pr__model__cap_mim
C$2179 \$602 TOP_N|VINN 8.664e-15
* device instance $2180 r0 *1 200.6,47.95 sky130_fd_pr__model__cap_mim
C$2180 \$601 TOP_N|VINN 8.664e-15
* device instance $2181 r0 *1 204,47.95 sky130_fd_pr__model__cap_mim
C$2181 \$603 TOP_N|VINN 8.664e-15
* device instance $2182 r0 *1 207.4,47.95 sky130_fd_pr__model__cap_mim
C$2182 \$601 TOP_N|VINN 8.664e-15
* device instance $2183 r0 *1 210.8,47.95 sky130_fd_pr__model__cap_mim
C$2183 \$602 TOP_N|VINN 8.664e-15
* device instance $2184 r0 *1 214.2,47.95 sky130_fd_pr__model__cap_mim
C$2184 \$601 TOP_N|VINN 8.664e-15
* device instance $2185 r0 *1 0,51.35 sky130_fd_pr__model__cap_mim
C$2185 \$605 TOP_P|VINP 8.664e-15
* device instance $2186 r0 *1 3.4,51.35 sky130_fd_pr__model__cap_mim
C$2186 \$606 TOP_P|VINP 8.664e-15
* device instance $2187 r0 *1 6.8,51.35 sky130_fd_pr__model__cap_mim
C$2187 \$605 TOP_P|VINP 8.664e-15
* device instance $2188 r0 *1 10.2,51.35 sky130_fd_pr__model__cap_mim
C$2188 \$607 TOP_P|VINP 8.664e-15
* device instance $2189 r0 *1 13.6,51.35 sky130_fd_pr__model__cap_mim
C$2189 \$605 TOP_P|VINP 8.664e-15
* device instance $2190 r0 *1 17,51.35 sky130_fd_pr__model__cap_mim
C$2190 \$606 TOP_P|VINP 8.664e-15
* device instance $2191 r0 *1 20.4,51.35 sky130_fd_pr__model__cap_mim
C$2191 \$605 TOP_P|VINP 8.664e-15
* device instance $2192 r0 *1 23.8,51.35 sky130_fd_pr__model__cap_mim
C$2192 \$594 TOP_P|VINP 8.664e-15
* device instance $2193 r0 *1 27.2,51.35 sky130_fd_pr__model__cap_mim
C$2193 \$605 TOP_P|VINP 8.664e-15
* device instance $2194 r0 *1 30.6,51.35 sky130_fd_pr__model__cap_mim
C$2194 \$606 TOP_P|VINP 8.664e-15
* device instance $2195 r0 *1 34,51.35 sky130_fd_pr__model__cap_mim
C$2195 \$605 TOP_P|VINP 8.664e-15
* device instance $2196 r0 *1 37.4,51.35 sky130_fd_pr__model__cap_mim
C$2196 \$607 TOP_P|VINP 8.664e-15
* device instance $2197 r0 *1 40.8,51.35 sky130_fd_pr__model__cap_mim
C$2197 \$605 TOP_P|VINP 8.664e-15
* device instance $2198 r0 *1 44.2,51.35 sky130_fd_pr__model__cap_mim
C$2198 \$606 TOP_P|VINP 8.664e-15
* device instance $2199 r0 *1 47.6,51.35 sky130_fd_pr__model__cap_mim
C$2199 \$605 TOP_P|VINP 8.664e-15
* device instance $2200 r0 *1 51,51.35 sky130_fd_pr__model__cap_mim
C$2200 \$593 TOP_P|VINP 8.664e-15
* device instance $2201 r0 *1 54.4,51.35 sky130_fd_pr__model__cap_mim
C$2201 \$605 TOP_P|VINP 8.664e-15
* device instance $2202 r0 *1 57.8,51.35 sky130_fd_pr__model__cap_mim
C$2202 \$606 TOP_P|VINP 8.664e-15
* device instance $2203 r0 *1 61.2,51.35 sky130_fd_pr__model__cap_mim
C$2203 \$605 TOP_P|VINP 8.664e-15
* device instance $2204 r0 *1 64.6,51.35 sky130_fd_pr__model__cap_mim
C$2204 \$607 TOP_P|VINP 8.664e-15
* device instance $2205 r0 *1 68,51.35 sky130_fd_pr__model__cap_mim
C$2205 \$605 TOP_P|VINP 8.664e-15
* device instance $2206 r0 *1 71.4,51.35 sky130_fd_pr__model__cap_mim
C$2206 \$606 TOP_P|VINP 8.664e-15
* device instance $2207 r0 *1 74.8,51.35 sky130_fd_pr__model__cap_mim
C$2207 \$605 TOP_P|VINP 8.664e-15
* device instance $2208 r0 *1 78.2,51.35 sky130_fd_pr__model__cap_mim
C$2208 \$594 TOP_P|VINP 8.664e-15
* device instance $2209 r0 *1 81.6,51.35 sky130_fd_pr__model__cap_mim
C$2209 \$605 TOP_P|VINP 8.664e-15
* device instance $2210 r0 *1 85,51.35 sky130_fd_pr__model__cap_mim
C$2210 \$606 TOP_P|VINP 8.664e-15
* device instance $2211 r0 *1 88.4,51.35 sky130_fd_pr__model__cap_mim
C$2211 \$605 TOP_P|VINP 8.664e-15
* device instance $2212 r0 *1 91.8,51.35 sky130_fd_pr__model__cap_mim
C$2212 \$607 TOP_P|VINP 8.664e-15
* device instance $2213 r0 *1 95.2,51.35 sky130_fd_pr__model__cap_mim
C$2213 \$605 TOP_P|VINP 8.664e-15
* device instance $2214 r0 *1 98.6,51.35 sky130_fd_pr__model__cap_mim
C$2214 \$606 TOP_P|VINP 8.664e-15
* device instance $2215 r0 *1 102,51.35 sky130_fd_pr__model__cap_mim
C$2215 \$605 TOP_P|VINP 8.664e-15
* device instance $2216 r0 *1 105.4,51.35 sky130_fd_pr__model__cap_mim
C$2216 \$592 TOP_P|VINP 8.664e-15
* device instance $2217 r0 *1 108.8,51.35 sky130_fd_pr__model__cap_mim
C$2217 VREFN TOP_P|VINP 8.664e-15
* device instance $2218 r0 *1 112.2,51.35 sky130_fd_pr__model__cap_mim
C$2218 \$605 TOP_P|VINP 8.664e-15
* device instance $2219 r0 *1 115.6,51.35 sky130_fd_pr__model__cap_mim
C$2219 \$606 TOP_P|VINP 8.664e-15
* device instance $2220 r0 *1 119,51.35 sky130_fd_pr__model__cap_mim
C$2220 \$605 TOP_P|VINP 8.664e-15
* device instance $2221 r0 *1 122.4,51.35 sky130_fd_pr__model__cap_mim
C$2221 \$607 TOP_P|VINP 8.664e-15
* device instance $2222 r0 *1 125.8,51.35 sky130_fd_pr__model__cap_mim
C$2222 \$605 TOP_P|VINP 8.664e-15
* device instance $2223 r0 *1 129.2,51.35 sky130_fd_pr__model__cap_mim
C$2223 \$606 TOP_P|VINP 8.664e-15
* device instance $2224 r0 *1 132.6,51.35 sky130_fd_pr__model__cap_mim
C$2224 \$605 TOP_P|VINP 8.664e-15
* device instance $2225 r0 *1 136,51.35 sky130_fd_pr__model__cap_mim
C$2225 \$594 TOP_P|VINP 8.664e-15
* device instance $2226 r0 *1 139.4,51.35 sky130_fd_pr__model__cap_mim
C$2226 \$605 TOP_P|VINP 8.664e-15
* device instance $2227 r0 *1 142.8,51.35 sky130_fd_pr__model__cap_mim
C$2227 \$606 TOP_P|VINP 8.664e-15
* device instance $2228 r0 *1 146.2,51.35 sky130_fd_pr__model__cap_mim
C$2228 \$605 TOP_P|VINP 8.664e-15
* device instance $2229 r0 *1 149.6,51.35 sky130_fd_pr__model__cap_mim
C$2229 \$607 TOP_P|VINP 8.664e-15
* device instance $2230 r0 *1 153,51.35 sky130_fd_pr__model__cap_mim
C$2230 \$605 TOP_P|VINP 8.664e-15
* device instance $2231 r0 *1 156.4,51.35 sky130_fd_pr__model__cap_mim
C$2231 \$606 TOP_P|VINP 8.664e-15
* device instance $2232 r0 *1 159.8,51.35 sky130_fd_pr__model__cap_mim
C$2232 \$605 TOP_P|VINP 8.664e-15
* device instance $2233 r0 *1 163.2,51.35 sky130_fd_pr__model__cap_mim
C$2233 \$593 TOP_P|VINP 8.664e-15
* device instance $2234 r0 *1 166.6,51.35 sky130_fd_pr__model__cap_mim
C$2234 \$605 TOP_P|VINP 8.664e-15
* device instance $2235 r0 *1 170,51.35 sky130_fd_pr__model__cap_mim
C$2235 \$606 TOP_P|VINP 8.664e-15
* device instance $2236 r0 *1 173.4,51.35 sky130_fd_pr__model__cap_mim
C$2236 \$605 TOP_P|VINP 8.664e-15
* device instance $2237 r0 *1 176.8,51.35 sky130_fd_pr__model__cap_mim
C$2237 \$607 TOP_P|VINP 8.664e-15
* device instance $2238 r0 *1 180.2,51.35 sky130_fd_pr__model__cap_mim
C$2238 \$605 TOP_P|VINP 8.664e-15
* device instance $2239 r0 *1 183.6,51.35 sky130_fd_pr__model__cap_mim
C$2239 \$606 TOP_P|VINP 8.664e-15
* device instance $2240 r0 *1 187,51.35 sky130_fd_pr__model__cap_mim
C$2240 \$605 TOP_P|VINP 8.664e-15
* device instance $2241 r0 *1 190.4,51.35 sky130_fd_pr__model__cap_mim
C$2241 \$594 TOP_P|VINP 8.664e-15
* device instance $2242 r0 *1 193.8,51.35 sky130_fd_pr__model__cap_mim
C$2242 \$605 TOP_P|VINP 8.664e-15
* device instance $2243 r0 *1 197.2,51.35 sky130_fd_pr__model__cap_mim
C$2243 \$606 TOP_P|VINP 8.664e-15
* device instance $2244 r0 *1 200.6,51.35 sky130_fd_pr__model__cap_mim
C$2244 \$605 TOP_P|VINP 8.664e-15
* device instance $2245 r0 *1 204,51.35 sky130_fd_pr__model__cap_mim
C$2245 \$607 TOP_P|VINP 8.664e-15
* device instance $2246 r0 *1 207.4,51.35 sky130_fd_pr__model__cap_mim
C$2246 \$605 TOP_P|VINP 8.664e-15
* device instance $2247 r0 *1 210.8,51.35 sky130_fd_pr__model__cap_mim
C$2247 \$606 TOP_P|VINP 8.664e-15
* device instance $2248 r0 *1 214.2,51.35 sky130_fd_pr__model__cap_mim
C$2248 \$605 TOP_P|VINP 8.664e-15
* device instance $2249 r0 *1 120.9,73.45 sky130_fd_pr__model__cap_mim
C$2249 BOT_OFF_N TOP_N|VINN 8.664e-15
* device instance $2250 r0 *1 136.9,73.45 sky130_fd_pr__model__cap_mim
C$2250 BOT_OFF_P TOP_P|VINP 8.664e-15
* device instance $2251 r0 *1 143.385,93.65 sky130_fd_pr__model__cap_mim
C$2251 \$618 BOOST_P 1.99528e-13
* device instance $2252 r0 *1 154.685,93.65 sky130_fd_pr__model__cap_mim
C$2252 \$620 BOOST_N 1.99528e-13
* device instance $2253 r0 *1 187.035,112.2 sky130_fd_pr__model__cap_mim
C$2253 BPREF_P TOP_P|VINP 4.434864e-12
* device instance $2254 r0 *1 235.435,112.2 sky130_fd_pr__model__cap_mim
C$2254 BPREF_N TOP_N|VINN 4.434864e-12
* device instance $2255 r0 *1 151.95,173.95 sky130_fd_pr__model__cap_mim
C$2255 A|B|BUSY|DOUT2|GND|VGND|VSS VDD 4.434864e-12
* device instance $2256 r0 *1 203.95,173.95 sky130_fd_pr__model__cap_mim
C$2256 A|B|BUSY|DOUT2|GND|VGND|VSS VDD 4.434864e-12
.ENDS gen_compose_0
