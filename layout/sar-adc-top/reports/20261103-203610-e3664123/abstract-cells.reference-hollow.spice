* GENERATED by layout/sar-adc-top/bin/generate-hollow-reference.py from the
* flow's own sar_adc_top.lvs-reference.spice -- DO NOT HAND-EDIT.
* Hollowed macros + inlined comparator/sampling_frontend/halflsb_offset: the reference
* shape for `klt extract --abstract-cells` (README.md).
.SUBCKT cdac_array__cdac_array VREFP VREFN VDD VSS SELn0 SELp0 SELn1 SELp1 SELn2 SELp2 SELn3 SELp3 SELn4 SELp4 TOP_N TOP_P SELp5 SELn5 SELp6 SELn6 SELn7 SELp7 SELn8 SELp8
.ENDS cdac_array__cdac_array
.SUBCKT sar_sequencer__sar_sequencer CLK RST_B COMP_OUT PH_B9 PH_B8 PH_B7 PH_B6 PH_B5 PH_B4 PH_B3 PH_B2 PH_B1 PH_B0 PH_EOC PH_SAMPLE BUSY DOUT9 DOUT8 DOUT7 DOUT6 DOUT5 DOUT4 DOUT3 DOUT2 DOUT1 DOUT0 VPWR VGND
.ENDS sar_sequencer__sar_sequencer
.SUBCKT top_glue__top_glue CLK DOUT9 DOUT8 DOUT7 DOUT6 DOUT5 DOUT4 DOUT3 DOUT2 DOUT1 DOUT0 PH_B9 BUSY OUTN_NC CLKN SELp8 SELp7 SELp6 SELp5 SELp4 SELp3 SELp2 SELp1 SELp0 SELn8 SELn7 SELn6 SELn5 SELn4 SELn3 SELn2 SELn1 SELn0 ADCOUT8 ADCOUT7 ADCOUT6 ADCOUT5 ADCOUT4 ADCOUT3 ADCOUT2 ADCOUT1 ADCOUT0 HALF_LSB_EN HALF_LSB_ENN DUMLOAD_MUX_NC DUMLOAD_XNOR_NC VPWR VGND
.ENDS top_glue__top_glue
.SUBCKT sar_adc_top VINP VINN VDD VREFP VREFN VCM CLK RST_B DOUT9 DOUT8 DOUT7 DOUT6 DOUT5 DOUT4 DOUT3 DOUT2 DOUT1 DOUT0 BUSY VPWR VGND GND
MFE_MSW_P VINP FE_G_P TOP_P GND nfet L=0.15U W=2U
MFE_MSW_N VINN FE_G_N TOP_N GND nfet L=0.15U W=2U
MFE_SB_P FE_BSBOT_P FE_SAMPLEB GND GND nfet L=0.15U W=1U
MFE_SCN_P FE_BSBOT_P SAMPLE_INT VINP GND nfet L=0.15U W=1U
MFE_SD_P FE_G_P FE_SAMPLEB GND GND nfet L=0.5U W=1U
MFE_CMSWN_P BPREF_P_NC SAMPLE_INT VCM GND nfet L=0.15U W=16U
MFE_CMSWN_N BPREF_N_NC SAMPLE_INT VCM GND nfet L=0.15U W=16U
MFE_SD_N FE_G_N FE_SAMPLEB GND GND nfet L=0.5U W=1U
MFE_SCN_N FE_BSBOT_N SAMPLE_INT VINN GND nfet L=0.15U W=1U
MFE_SB_N FE_BSBOT_N FE_SAMPLEB GND GND nfet L=0.15U W=1U
MFE_INVN FE_SAMPLEB SAMPLE_INT GND GND nfet L=0.15U W=1U
MFE_SA_P BOOST_P_NC FE_G_P VDD BOOST_P_NC pfet L=0.5U W=1U
MFE_SE_P FE_G_P FE_SAMPLEB BOOST_P_NC BOOST_P_NC pfet L=0.15U W=1U
MFE_SCP_P FE_BSBOT_P FE_SAMPLEB VINP VDD pfet L=0.15U W=1U
MFE_CMSWP_P BPREF_P_NC FE_SAMPLEB VCM VDD pfet L=0.15U W=16U
MFE_INVP FE_SAMPLEB SAMPLE_INT VDD VDD pfet L=0.15U W=2U
MFE_CMSWP_N BPREF_N_NC FE_SAMPLEB VCM VDD pfet L=0.15U W=16U
MFE_SCP_N FE_BSBOT_N FE_SAMPLEB VINN VDD pfet L=0.15U W=1U
MFE_SE_N FE_G_N FE_SAMPLEB BOOST_N_NC BOOST_N_NC pfet L=0.15U W=1U
MFE_SA_N BOOST_N_NC FE_G_N VDD BOOST_N_NC pfet L=0.5U W=1U
CFE_CBOOT_P FE_BSBOT_P BOOST_P_NC 1.99528e-13 sky130_fd_pr__model__cap_mim
CFE_CBOOT_N FE_BSBOT_N BOOST_N_NC 1.99528e-13 sky130_fd_pr__model__cap_mim
CFE_CSAMP_P BPREF_P_NC TOP_P 4.434864e-12 sky130_fd_pr__model__cap_mim
CFE_CSAMP_N BPREF_N_NC TOP_N 4.434864e-12 sky130_fd_pr__model__cap_mim
MCMP_TAIL CMP_TAIL CLKN GND GND nfet L=0.5U W=8U
MCMP_INN CMP_DIP TOP_N CMP_TAIL GND nfet L=0.5U W=4U
MCMP_INP CMP_DIN TOP_P CMP_TAIL GND nfet L=0.5U W=4U
MCMP_LATN_P COMP_OUT OUTN_NC CMP_DIP GND nfet L=0.5U W=4U
MCMP_LATN_N OUTN_NC COMP_OUT CMP_DIN GND nfet L=0.5U W=4U
MCMP_LATP_P COMP_OUT OUTN_NC VDD VDD pfet L=0.5U W=8U
MCMP_LATP_N OUTN_NC COMP_OUT VDD VDD pfet L=0.5U W=8U
MCMP_RST_P COMP_OUT CLKN VDD VDD pfet L=0.5U W=16U
MCMP_RST_N OUTN_NC CLKN VDD VDD pfet L=0.5U W=16U
MCMP_RST_DIP CMP_DIP CLKN VDD VDD pfet L=0.5U W=4U
MCMP_RST_DIN CMP_DIN CLKN VDD VDD pfet L=0.5U W=4U
MHALFLSB_MOFF_N_REFP BOT_OFF_N HALF_LSB_EN VREFP VDD pfet L=0.15U W=2.0U
MHALFLSB_MOFF_N_CMN BOT_OFF_N HALF_LSB_EN VCM GND nfet L=0.15U W=1.0U
MHALFLSB_MOFF_N_CMP BOT_OFF_N HALF_LSB_ENN VCM VDD pfet L=0.15U W=2.0U
CHALFLSB_CHOFF_N BOT_OFF_N TOP_N 8.664000000e-15 sky130_fd_pr__model__cap_mim
MHALFLSB_MOFF_P_REFP BOT_OFF_P VGND VREFP VDD pfet L=0.15U W=2.0U
MHALFLSB_MOFF_P_CMN BOT_OFF_P VGND VCM GND nfet L=0.15U W=1.0U
MHALFLSB_MOFF_P_CMP BOT_OFF_P VPWR VCM VDD pfet L=0.15U W=2.0U
CHALFLSB_CHOFF_P BOT_OFF_P TOP_P 8.664000000e-15 sky130_fd_pr__model__cap_mim
Xcdac VREFP VREFN VDD GND SELn0 SELp0 SELn1 SELp1 SELn2 SELp2 SELn3 SELp3 SELn4 SELp4 TOP_N TOP_P SELp5 SELn5 SELp6 SELn6 SELn7 SELp7 SELn8 SELp8 cdac_array__cdac_array
Xseq CLK RST_B COMP_OUT PH_B9 net1 net2 net3 net4 net5 net6 net7 net8 net9 net10 SAMPLE_INT BUSY DOUT9 DOUT8 DOUT7 DOUT6 DOUT5 DOUT4 DOUT3 DOUT2 DOUT1 DOUT0 VPWR VGND sar_sequencer__sar_sequencer
Xglue CLK DOUT9 DOUT8 DOUT7 DOUT6 DOUT5 DOUT4 DOUT3 DOUT2 DOUT1 DOUT0 PH_B9 BUSY OUTN_NC CLKN SELp8 SELp7 SELp6 SELp5 SELp4 SELp3 SELp2 SELp1 SELp0 SELn8 SELn7 SELn6 SELn5 SELn4 SELn3 SELn2 SELn1 SELn0 ADCOUT8 ADCOUT7 ADCOUT6 ADCOUT5 ADCOUT4 ADCOUT3 ADCOUT2 ADCOUT1 ADCOUT0 HALF_LSB_EN HALF_LSB_ENN DUMLOAD_MUX_NC DUMLOAD_XNOR_NC VPWR VGND top_glue__top_glue
Cdecap_a0 GND VDD 4.434864e-12 sky130_fd_pr__model__cap_mim
Cdecap_a1 GND VDD 4.434864e-12 sky130_fd_pr__model__cap_mim
Cdecap_d0 VGND VPWR 4.434864e-12 sky130_fd_pr__model__cap_mim
Cdecap_d1 VGND VPWR 4.434864e-12 sky130_fd_pr__model__cap_mim
.ENDS sar_adc_top
