* extracted by klt extract --deck sky130

* cell gen_compose_0
* pin A,A0,DOUT0,Q,SELp0
* pin A,A0,DOUT1,Q,SELp1
* pin A,A0,DOUT2,Q,SELp2
* pin A,A0,DOUT3,Q,SELp3
* pin A,A0,DOUT4,Q,SELp4
* pin A,A0,DOUT5,Q,SELp5
* pin A,A0,DOUT6,Q,SELp6
* pin A,A0,DOUT7,Q,SELp7
* pin A,A0,DOUT8,Q,SELp8
* pin A,BUSY,X
* pin A,CLK
* pin A,CLK,X
* pin A0,DOUT9,Q
* pin CLK,X
* pin RESET_B,RST_B
* pin TOP_N,VINN
* pin TOP_P,VINP
* pin VCM
* pin VDD
* pin VINN
* pin VINP
* pin VREFN
* pin VREFP
.SUBCKT gen_compose_0 A|A0|DOUT0|Q|SELp0 A|A0|DOUT1|Q|SELp1 A|A0|DOUT2|Q|SELp2
+ A|A0|DOUT3|Q|SELp3 A|A0|DOUT4|Q|SELp4 A|A0|DOUT5|Q|SELp5 A|A0|DOUT6|Q|SELp6
+ A|A0|DOUT7|Q|SELp7 A|A0|DOUT8|Q|SELp8 A|BUSY|X A|CLK A|CLK|X A0|DOUT9|Q CLK|X
+ RESET_B|RST_B TOP_N|VINN TOP_P|VINP VCM VDD VINN VINP VREFN VREFP
* device instance $1 r0 *1 51.948,-146.835 nfet
M$1 GND|VGND A|CLK|X \$4 GND|VGND nfet L=0.15U W=0.42U AS=0.1092P AD=0.0567P
+ PS=1.36U PD=0.69U
* device instance $2 r0 *1 52.368,-146.835 nfet
M$2 \$5 \$4 GND|VGND GND|VGND nfet L=0.15U W=0.42U AS=0.0567P AD=0.1092P
+ PS=0.69U PD=1.36U
* device instance $3 r0 *1 54.118,-146.865 nfet
M$3 \$8 \$4 \$7 GND|VGND nfet L=0.15U W=0.36U AS=0.066P AD=0.0594P PS=0.745U
+ PD=0.69U
* device instance $4 r0 *1 54.598,-146.865 nfet
M$4 \$14 \$5 \$8 GND|VGND nfet L=0.15U W=0.36U AS=0.0594P AD=0.1401P PS=0.69U
+ PD=1.1U
* device instance $5 r0 *1 56.943,-146.865 nfet
M$5 \$11 \$5 \$10 GND|VGND nfet L=0.15U W=0.36U AS=0.0999P AD=0.0711P PS=0.985U
+ PD=0.755U
* device instance $6 r0 *1 57.488,-146.865 nfet
M$6 \$16 \$4 \$11 GND|VGND nfet L=0.15U W=0.36U AS=0.0711P AD=0.0669P PS=0.755U
+ PD=0.75U
* device instance $7 r0 *1 53.643,-146.835 nfet
M$7 \$7 B|D|PH_B8|Q|S GND|VGND GND|VGND nfet L=0.15U W=0.42U AS=0.2205P
+ AD=0.066P PS=1.89U PD=0.745U
* device instance $8 r0 *1 55.428,-146.835 nfet
M$8 \$15 \$10 \$14 GND|VGND nfet L=0.15U W=0.42U AS=0.1401P AD=0.0441P PS=1.1U
+ PD=0.63U
* device instance $9 r0 *1 55.788,-146.835 nfet
M$9 GND|VGND RESET_B|RST_B \$15 GND|VGND nfet L=0.15U W=0.42U AS=0.0441P
+ AD=0.1346P PS=0.63U PD=1.15U
* device instance $10 r0 *1 57.968,-146.835 nfet
M$10 GND|VGND \$12 \$16 GND|VGND nfet L=0.15U W=0.42U AS=0.0669P AD=0.12495P
+ PS=0.75U PD=1.015U
* device instance $11 r0 *1 58.713,-146.835 nfet
M$11 \$17 RESET_B|RST_B GND|VGND GND|VGND nfet L=0.15U W=0.42U AS=0.12495P
+ AD=0.06405P PS=1.015U PD=0.725U
* device instance $12 r0 *1 59.168,-146.835 nfet
M$12 \$12 \$11 \$17 GND|VGND nfet L=0.15U W=0.42U AS=0.06405P AD=0.1092P
+ PS=0.725U PD=1.36U
* device instance $13 r0 *1 56.448,-146.725 nfet
M$13 \$10 \$8 GND|VGND GND|VGND nfet L=0.15U W=0.64U AS=0.1346P AD=0.0999P
+ PS=1.15U PD=0.985U
* device instance $14 r0 *1 60.208,-146.72 nfet
M$14 C|D|PH_B7|Q|S \$12 GND|VGND GND|VGND nfet L=0.15U W=0.65U AS=0.2087P
+ AD=0.169P PS=2.02U PD=1.82U
* device instance $15 r0 *1 35.388,-142.285 nfet
M$15 GND|VGND A|CLK|X \$19 GND|VGND nfet L=0.15U W=0.42U AS=0.1092P AD=0.0567P
+ PS=1.36U PD=0.69U
* device instance $16 r0 *1 35.808,-142.285 nfet
M$16 \$20 \$19 GND|VGND GND|VGND nfet L=0.15U W=0.42U AS=0.0567P AD=0.1092P
+ PS=0.69U PD=1.36U
* device instance $17 r0 *1 37.083,-142.285 nfet
M$17 \$22 D|X GND|VGND GND|VGND nfet L=0.15U W=0.42U AS=0.2205P AD=0.066P
+ PS=1.89U PD=0.745U
* device instance $18 r0 *1 37.558,-142.255 nfet
M$18 \$23 \$19 \$22 GND|VGND nfet L=0.15U W=0.36U AS=0.066P AD=0.0594P
+ PS=0.745U PD=0.69U
* device instance $19 r0 *1 38.038,-142.255 nfet
M$19 \$23 \$20 \$40 GND|VGND nfet L=0.15U W=0.36U AS=0.1401P AD=0.0594P PS=1.1U
+ PD=0.69U
* device instance $20 r0 *1 38.868,-142.285 nfet
M$20 \$41 \$26 \$40 GND|VGND nfet L=0.15U W=0.42U AS=0.1401P AD=0.0441P PS=1.1U
+ PD=0.63U
* device instance $21 r0 *1 39.228,-142.285 nfet
M$21 \$41 RESET_B|RST_B GND|VGND GND|VGND nfet L=0.15U W=0.42U AS=0.1346P
+ AD=0.0441P PS=1.15U PD=0.63U
* device instance $22 r0 *1 39.888,-142.395 nfet
M$22 \$26 \$23 GND|VGND GND|VGND nfet L=0.15U W=0.64U AS=0.1346P AD=0.0999P
+ PS=1.15U PD=0.985U
* device instance $23 r0 *1 40.383,-142.255 nfet
M$23 \$27 \$20 \$26 GND|VGND nfet L=0.15U W=0.36U AS=0.0999P AD=0.0711P
+ PS=0.985U PD=0.755U
* device instance $24 r0 *1 40.928,-142.255 nfet
M$24 \$27 \$19 \$42 GND|VGND nfet L=0.15U W=0.36U AS=0.0669P AD=0.0711P
+ PS=0.75U PD=0.755U
* device instance $25 r0 *1 41.408,-142.285 nfet
M$25 GND|VGND \$28 \$42 GND|VGND nfet L=0.15U W=0.42U AS=0.0669P AD=0.12495P
+ PS=0.75U PD=1.015U
* device instance $26 r0 *1 42.153,-142.285 nfet
M$26 \$44 RESET_B|RST_B GND|VGND GND|VGND nfet L=0.15U W=0.42U AS=0.12495P
+ AD=0.06405P PS=1.015U PD=0.725U
* device instance $27 r0 *1 42.608,-142.285 nfet
M$27 \$28 \$27 \$44 GND|VGND nfet L=0.15U W=0.42U AS=0.06405P AD=0.1092P
+ PS=0.725U PD=1.36U
* device instance $28 r0 *1 43.648,-142.4 nfet
M$28 A|A0|DOUT6|Q|SELp6 \$28 GND|VGND GND|VGND nfet L=0.15U W=0.65U AS=0.2087P
+ AD=0.169P PS=2.02U PD=1.82U
* device instance $29 r0 *1 51.948,-142.285 nfet
M$29 GND|VGND A|CLK|X \$30 GND|VGND nfet L=0.15U W=0.42U AS=0.1092P AD=0.0567P
+ PS=1.36U PD=0.69U
* device instance $30 r0 *1 52.368,-142.285 nfet
M$30 \$31 \$30 GND|VGND GND|VGND nfet L=0.15U W=0.42U AS=0.0567P AD=0.1092P
+ PS=0.69U PD=1.36U
* device instance $31 r0 *1 53.643,-142.285 nfet
M$31 \$33 D|X$1 GND|VGND GND|VGND nfet L=0.15U W=0.42U AS=0.2205P AD=0.066P
+ PS=1.89U PD=0.745U
* device instance $32 r0 *1 54.118,-142.255 nfet
M$32 \$34 \$30 \$33 GND|VGND nfet L=0.15U W=0.36U AS=0.066P AD=0.0594P
+ PS=0.745U PD=0.69U
* device instance $33 r0 *1 54.598,-142.255 nfet
M$33 \$34 \$31 \$45 GND|VGND nfet L=0.15U W=0.36U AS=0.1401P AD=0.0594P PS=1.1U
+ PD=0.69U
* device instance $34 r0 *1 55.428,-142.285 nfet
M$34 \$46 \$36 \$45 GND|VGND nfet L=0.15U W=0.42U AS=0.1401P AD=0.0441P PS=1.1U
+ PD=0.63U
* device instance $35 r0 *1 55.788,-142.285 nfet
M$35 \$46 RESET_B|RST_B GND|VGND GND|VGND nfet L=0.15U W=0.42U AS=0.1346P
+ AD=0.0441P PS=1.15U PD=0.63U
* device instance $36 r0 *1 56.448,-142.395 nfet
M$36 \$36 \$34 GND|VGND GND|VGND nfet L=0.15U W=0.64U AS=0.1346P AD=0.0999P
+ PS=1.15U PD=0.985U
* device instance $37 r0 *1 56.943,-142.255 nfet
M$37 \$37 \$31 \$36 GND|VGND nfet L=0.15U W=0.36U AS=0.0999P AD=0.0711P
+ PS=0.985U PD=0.755U
* device instance $38 r0 *1 57.488,-142.255 nfet
M$38 \$37 \$30 \$48 GND|VGND nfet L=0.15U W=0.36U AS=0.0669P AD=0.0711P
+ PS=0.75U PD=0.755U
* device instance $39 r0 *1 57.968,-142.285 nfet
M$39 GND|VGND \$38 \$48 GND|VGND nfet L=0.15U W=0.42U AS=0.0669P AD=0.12495P
+ PS=0.75U PD=1.015U
* device instance $40 r0 *1 58.713,-142.285 nfet
M$40 \$49 RESET_B|RST_B GND|VGND GND|VGND nfet L=0.15U W=0.42U AS=0.12495P
+ AD=0.06405P PS=1.015U PD=0.725U
* device instance $41 r0 *1 59.168,-142.285 nfet
M$41 \$38 \$37 \$49 GND|VGND nfet L=0.15U W=0.42U AS=0.06405P AD=0.1092P
+ PS=0.725U PD=1.36U
* device instance $42 r0 *1 60.208,-142.4 nfet
M$42 A|A0|DOUT8|Q|SELp8 \$38 GND|VGND GND|VGND nfet L=0.15U W=0.65U AS=0.2087P
+ AD=0.169P PS=2.02U PD=1.82U
* device instance $43 r0 *1 28.488,-141.395 nfet
M$43 GND|VGND A|CLK|X \$50 GND|VGND nfet L=0.15U W=0.42U AS=0.1092P AD=0.0567P
+ PS=1.36U PD=0.69U
* device instance $44 r0 *1 28.908,-141.395 nfet
M$44 \$51 \$50 GND|VGND GND|VGND nfet L=0.15U W=0.42U AS=0.0567P AD=0.1092P
+ PS=0.69U PD=1.36U
* device instance $45 r0 *1 30.658,-141.425 nfet
M$45 \$54 \$50 \$53 GND|VGND nfet L=0.15U W=0.36U AS=0.066P AD=0.0594P
+ PS=0.745U PD=0.69U
* device instance $46 r0 *1 31.138,-141.425 nfet
M$46 \$70 \$51 \$54 GND|VGND nfet L=0.15U W=0.36U AS=0.0594P AD=0.1401P
+ PS=0.69U PD=1.1U
* device instance $47 r0 *1 33.483,-141.425 nfet
M$47 \$57 \$51 \$56 GND|VGND nfet L=0.15U W=0.36U AS=0.0999P AD=0.0711P
+ PS=0.985U PD=0.755U
* device instance $48 r0 *1 34.028,-141.425 nfet
M$48 \$72 \$50 \$57 GND|VGND nfet L=0.15U W=0.36U AS=0.0711P AD=0.0669P
+ PS=0.755U PD=0.75U
* device instance $49 r0 *1 30.183,-141.395 nfet
M$49 \$53 D|X$2 GND|VGND GND|VGND nfet L=0.15U W=0.42U AS=0.2205P AD=0.066P
+ PS=1.89U PD=0.745U
* device instance $50 r0 *1 31.968,-141.395 nfet
M$50 \$71 \$56 \$70 GND|VGND nfet L=0.15U W=0.42U AS=0.1401P AD=0.0441P PS=1.1U
+ PD=0.63U
* device instance $51 r0 *1 32.328,-141.395 nfet
M$51 GND|VGND RESET_B|RST_B \$71 GND|VGND nfet L=0.15U W=0.42U AS=0.0441P
+ AD=0.1346P PS=0.63U PD=1.15U
* device instance $52 r0 *1 34.508,-141.395 nfet
M$52 GND|VGND \$58 \$72 GND|VGND nfet L=0.15U W=0.42U AS=0.0669P AD=0.12495P
+ PS=0.75U PD=1.015U
* device instance $53 r0 *1 35.253,-141.395 nfet
M$53 \$74 RESET_B|RST_B GND|VGND GND|VGND nfet L=0.15U W=0.42U AS=0.12495P
+ AD=0.06405P PS=1.015U PD=0.725U
* device instance $54 r0 *1 35.708,-141.395 nfet
M$54 \$58 \$57 \$74 GND|VGND nfet L=0.15U W=0.42U AS=0.06405P AD=0.1092P
+ PS=0.725U PD=1.36U
* device instance $55 r0 *1 32.988,-141.285 nfet
M$55 \$56 \$54 GND|VGND GND|VGND nfet L=0.15U W=0.64U AS=0.1346P AD=0.0999P
+ PS=1.15U PD=0.985U
* device instance $56 r0 *1 36.748,-141.28 nfet
M$56 A|A0|DOUT5|Q|SELp5 \$58 GND|VGND GND|VGND nfet L=0.15U W=0.65U AS=0.2087P
+ AD=0.169P PS=2.02U PD=1.82U
* device instance $57 r0 *1 44.793,-141.28 nfet
M$57 Y A|CLK|X GND|VGND GND|VGND nfet L=0.15U W=0.65U AS=0.169P AD=0.169P
+ PS=1.82U PD=1.82U
* device instance $58 r0 *1 50.108,-141.395 nfet
M$58 GND|VGND A|CLK|X \$62 GND|VGND nfet L=0.15U W=0.42U AS=0.1092P AD=0.0567P
+ PS=1.36U PD=0.69U
* device instance $59 r0 *1 50.528,-141.395 nfet
M$59 \$63 \$62 GND|VGND GND|VGND nfet L=0.15U W=0.42U AS=0.0567P AD=0.1092P
+ PS=0.69U PD=1.36U
* device instance $60 r0 *1 52.278,-141.425 nfet
M$60 \$65 \$62 \$64 GND|VGND nfet L=0.15U W=0.36U AS=0.066P AD=0.0594P
+ PS=0.745U PD=0.69U
* device instance $61 r0 *1 52.758,-141.425 nfet
M$61 \$75 \$63 \$65 GND|VGND nfet L=0.15U W=0.36U AS=0.0594P AD=0.1401P
+ PS=0.69U PD=1.1U
* device instance $62 r0 *1 55.103,-141.425 nfet
M$62 \$68 \$63 \$67 GND|VGND nfet L=0.15U W=0.36U AS=0.0999P AD=0.0711P
+ PS=0.985U PD=0.755U
* device instance $63 r0 *1 55.648,-141.425 nfet
M$63 \$77 \$62 \$68 GND|VGND nfet L=0.15U W=0.36U AS=0.0711P AD=0.0669P
+ PS=0.755U PD=0.75U
* device instance $64 r0 *1 51.803,-141.395 nfet
M$64 \$64 C|D|PH_B7|Q|S GND|VGND GND|VGND nfet L=0.15U W=0.42U AS=0.2205P
+ AD=0.066P PS=1.89U PD=0.745U
* device instance $65 r0 *1 53.588,-141.395 nfet
M$65 \$76 \$67 \$75 GND|VGND nfet L=0.15U W=0.42U AS=0.1401P AD=0.0441P PS=1.1U
+ PD=0.63U
* device instance $66 r0 *1 53.948,-141.395 nfet
M$66 GND|VGND RESET_B|RST_B \$76 GND|VGND nfet L=0.15U W=0.42U AS=0.0441P
+ AD=0.1346P PS=0.63U PD=1.15U
* device instance $67 r0 *1 56.128,-141.395 nfet
M$67 GND|VGND \$69 \$77 GND|VGND nfet L=0.15U W=0.42U AS=0.0669P AD=0.12495P
+ PS=0.75U PD=1.015U
* device instance $68 r0 *1 56.873,-141.395 nfet
M$68 \$79 RESET_B|RST_B GND|VGND GND|VGND nfet L=0.15U W=0.42U AS=0.12495P
+ AD=0.06405P PS=1.015U PD=0.725U
* device instance $69 r0 *1 57.328,-141.395 nfet
M$69 \$69 \$68 \$79 GND|VGND nfet L=0.15U W=0.42U AS=0.06405P AD=0.1092P
+ PS=0.725U PD=1.36U
* device instance $70 r0 *1 54.608,-141.285 nfet
M$70 \$67 \$65 GND|VGND GND|VGND nfet L=0.15U W=0.64U AS=0.1346P AD=0.0999P
+ PS=1.15U PD=0.985U
* device instance $71 r0 *1 58.368,-141.28 nfet
M$71 D|PH_B6|Q|S \$69 GND|VGND GND|VGND nfet L=0.15U W=0.65U AS=0.2087P
+ AD=0.169P PS=2.02U PD=1.82U
* device instance $72 r0 *1 32.628,-136.96 nfet
M$72 GND|VGND \$80 D|X$2 GND|VGND nfet L=0.15U W=0.65U AS=0.169P AD=0.11285P
+ PS=1.82U PD=1.045U
* device instance $73 r0 *1 33.173,-136.845 nfet
M$73 \$94 A|D|PH_B5|Q|S GND|VGND GND|VGND nfet L=0.15U W=0.42U AS=0.11285P
+ AD=0.0693P PS=1.045U PD=0.75U
* device instance $74 r0 *1 33.653,-136.845 nfet
M$74 \$80 A1|COMP_OUT|OUTP \$94 GND|VGND nfet L=0.15U W=0.42U AS=0.0693P
+ AD=0.09975P PS=0.75U PD=0.895U
* device instance $75 r0 *1 34.278,-136.845 nfet
M$75 \$97 A|A0|DOUT5|Q|SELp5 \$80 GND|VGND nfet L=0.15U W=0.42U AS=0.09975P
+ AD=0.0693P PS=0.895U PD=0.75U
* device instance $76 r0 *1 34.758,-136.845 nfet
M$76 GND|VGND \$83 \$97 GND|VGND nfet L=0.15U W=0.42U AS=0.0693P AD=0.1449P
+ PS=0.75U PD=1.11U
* device instance $77 r0 *1 35.598,-136.845 nfet
M$77 \$83 A|D|PH_B5|Q|S GND|VGND GND|VGND nfet L=0.15U W=0.42U AS=0.1449P
+ AD=0.1092P PS=1.11U PD=1.36U
* device instance $78 r0 *1 33.173,-135.955 nfet
M$78 \$133 C|D|PH_B3|Q|S GND|VGND GND|VGND nfet L=0.15U W=0.42U AS=0.11285P
+ AD=0.0693P PS=1.045U PD=0.75U
* device instance $79 r0 *1 33.653,-135.955 nfet
M$79 \$111 A1|COMP_OUT|OUTP \$133 GND|VGND nfet L=0.15U W=0.42U AS=0.0693P
+ AD=0.09975P PS=0.75U PD=0.895U
* device instance $80 r0 *1 34.278,-135.955 nfet
M$80 \$135 A|A0|DOUT3|Q|SELp3 \$111 GND|VGND nfet L=0.15U W=0.42U AS=0.09975P
+ AD=0.0693P PS=0.895U PD=0.75U
* device instance $81 r0 *1 34.758,-135.955 nfet
M$81 GND|VGND \$114 \$135 GND|VGND nfet L=0.15U W=0.42U AS=0.0693P AD=0.1449P
+ PS=0.75U PD=1.11U
* device instance $82 r0 *1 35.598,-135.955 nfet
M$82 \$114 C|D|PH_B3|Q|S GND|VGND GND|VGND nfet L=0.15U W=0.42U AS=0.1449P
+ AD=0.1092P PS=1.11U PD=1.36U
* device instance $83 r0 *1 32.628,-135.84 nfet
M$83 GND|VGND \$111 D|X$4 GND|VGND nfet L=0.15U W=0.65U AS=0.169P AD=0.11285P
+ PS=1.82U PD=1.045U
* device instance $84 r0 *1 39.068,-136.96 nfet
M$84 GND|VGND \$84 D|X GND|VGND nfet L=0.15U W=0.65U AS=0.169P AD=0.11285P
+ PS=1.82U PD=1.045U
* device instance $85 r0 *1 39.613,-136.845 nfet
M$85 \$98 D|PH_B6|Q|S GND|VGND GND|VGND nfet L=0.15U W=0.42U AS=0.11285P
+ AD=0.0693P PS=1.045U PD=0.75U
* device instance $86 r0 *1 40.093,-136.845 nfet
M$86 \$84 A1|COMP_OUT|OUTP \$98 GND|VGND nfet L=0.15U W=0.42U AS=0.0693P
+ AD=0.09975P PS=0.75U PD=0.895U
* device instance $87 r0 *1 40.718,-136.845 nfet
M$87 \$101 A|A0|DOUT6|Q|SELp6 \$84 GND|VGND nfet L=0.15U W=0.42U AS=0.09975P
+ AD=0.0693P PS=0.895U PD=0.75U
* device instance $88 r0 *1 41.198,-136.845 nfet
M$88 GND|VGND \$86 \$101 GND|VGND nfet L=0.15U W=0.42U AS=0.0693P AD=0.1449P
+ PS=0.75U PD=1.11U
* device instance $89 r0 *1 42.038,-136.845 nfet
M$89 \$86 D|PH_B6|Q|S GND|VGND GND|VGND nfet L=0.15U W=0.42U AS=0.1449P
+ AD=0.1092P PS=1.11U PD=1.36U
* device instance $90 r0 *1 40.448,-135.955 nfet
M$90 GND|VGND A|CLK|X \$115 GND|VGND nfet L=0.15U W=0.42U AS=0.1092P AD=0.0567P
+ PS=1.36U PD=0.69U
* device instance $91 r0 *1 40.868,-135.955 nfet
M$91 \$116 \$115 GND|VGND GND|VGND nfet L=0.15U W=0.42U AS=0.0567P AD=0.1092P
+ PS=0.69U PD=1.36U
* device instance $92 r0 *1 42.618,-135.985 nfet
M$92 \$118 \$115 \$117 GND|VGND nfet L=0.15U W=0.36U AS=0.066P AD=0.0594P
+ PS=0.745U PD=0.69U
* device instance $93 r0 *1 43.098,-135.985 nfet
M$93 \$136 \$116 \$118 GND|VGND nfet L=0.15U W=0.36U AS=0.0594P AD=0.1401P
+ PS=0.69U PD=1.1U
* device instance $94 r0 *1 45.443,-135.985 nfet
M$94 \$121 \$116 \$120 GND|VGND nfet L=0.15U W=0.36U AS=0.0999P AD=0.0711P
+ PS=0.985U PD=0.755U
* device instance $95 r0 *1 45.988,-135.985 nfet
M$95 \$138 \$115 \$121 GND|VGND nfet L=0.15U W=0.36U AS=0.0711P AD=0.0669P
+ PS=0.755U PD=0.75U
* device instance $96 r0 *1 42.143,-135.955 nfet
M$96 \$117 D|PH_B6|Q|S GND|VGND GND|VGND nfet L=0.15U W=0.42U AS=0.2205P
+ AD=0.066P PS=1.89U PD=0.745U
* device instance $97 r0 *1 43.928,-135.955 nfet
M$97 \$137 \$120 \$136 GND|VGND nfet L=0.15U W=0.42U AS=0.1401P AD=0.0441P
+ PS=1.1U PD=0.63U
* device instance $98 r0 *1 44.288,-135.955 nfet
M$98 GND|VGND RESET_B|RST_B \$137 GND|VGND nfet L=0.15U W=0.42U AS=0.0441P
+ AD=0.1346P PS=0.63U PD=1.15U
* device instance $99 r0 *1 46.468,-135.955 nfet
M$99 GND|VGND \$122 \$138 GND|VGND nfet L=0.15U W=0.42U AS=0.0669P AD=0.12495P
+ PS=0.75U PD=1.015U
* device instance $100 r0 *1 47.213,-135.955 nfet
M$100 \$139 RESET_B|RST_B GND|VGND GND|VGND nfet L=0.15U W=0.42U AS=0.12495P
+ AD=0.06405P PS=1.015U PD=0.725U
* device instance $101 r0 *1 47.668,-135.955 nfet
M$101 \$122 \$121 \$139 GND|VGND nfet L=0.15U W=0.42U AS=0.06405P AD=0.1092P
+ PS=0.725U PD=1.36U
* device instance $102 r0 *1 44.948,-135.845 nfet
M$102 \$120 \$118 GND|VGND GND|VGND nfet L=0.15U W=0.64U AS=0.1346P AD=0.0999P
+ PS=1.15U PD=0.985U
* device instance $103 r0 *1 44.588,-136.96 nfet
M$103 GND|VGND A|X$1 \$87 GND|VGND nfet L=0.15U W=0.65U AS=0.169P AD=0.08775P
+ PS=1.82U PD=0.92U
* device instance $104 r0 *1 45.008,-136.96 nfet
M$104 A|CLK|X \$87 GND|VGND GND|VGND nfet L=0.15U W=0.65U AS=0.08775P
+ AD=0.08775P PS=0.92U PD=0.92U
* device instance $105 r0 *1 45.428,-136.96 nfet
M$105 GND|VGND \$87 A|CLK|X GND|VGND nfet L=0.15U W=0.65U AS=0.08775P
+ AD=0.08775P PS=0.92U PD=0.92U
* device instance $106 r0 *1 45.848,-136.96 nfet
M$106 A|CLK|X \$87 GND|VGND GND|VGND nfet L=0.15U W=0.65U AS=0.08775P
+ AD=0.08775P PS=0.92U PD=0.92U
* device instance $107 r0 *1 46.268,-136.96 nfet
M$107 GND|VGND \$87 A|CLK|X GND|VGND nfet L=0.15U W=0.65U AS=0.08775P AD=0.169P
+ PS=0.92U PD=1.82U
* device instance $108 r0 *1 48.708,-135.84 nfet
M$108 A|D|PH_B5|Q|S \$122 GND|VGND GND|VGND nfet L=0.15U W=0.65U AS=0.2087P
+ AD=0.169P PS=2.02U PD=1.82U
* device instance $109 r0 *1 50.568,-135.955 nfet
M$109 GND|VGND A|CLK|X \$124 GND|VGND nfet L=0.15U W=0.42U AS=0.1092P
+ AD=0.0567P PS=1.36U PD=0.69U
* device instance $110 r0 *1 50.988,-135.955 nfet
M$110 \$125 \$124 GND|VGND GND|VGND nfet L=0.15U W=0.42U AS=0.0567P AD=0.1092P
+ PS=0.69U PD=1.36U
* device instance $111 r0 *1 51.948,-136.96 nfet
M$111 GND|VGND \$89 D|X$3 GND|VGND nfet L=0.15U W=0.65U AS=0.169P AD=0.11285P
+ PS=1.82U PD=1.045U
* device instance $112 r0 *1 52.493,-136.845 nfet
M$112 \$103 C|D|PH_B7|Q|S GND|VGND GND|VGND nfet L=0.15U W=0.42U AS=0.11285P
+ AD=0.0693P PS=1.045U PD=0.75U
* device instance $113 r0 *1 52.973,-136.845 nfet
M$113 \$89 A1|COMP_OUT|OUTP \$103 GND|VGND nfet L=0.15U W=0.42U AS=0.0693P
+ AD=0.09975P PS=0.75U PD=0.895U
* device instance $114 r0 *1 53.598,-136.845 nfet
M$114 \$105 A|A0|DOUT7|Q|SELp7 \$89 GND|VGND nfet L=0.15U W=0.42U AS=0.09975P
+ AD=0.0693P PS=0.895U PD=0.75U
* device instance $115 r0 *1 54.078,-136.845 nfet
M$115 GND|VGND \$91 \$105 GND|VGND nfet L=0.15U W=0.42U AS=0.0693P AD=0.1449P
+ PS=0.75U PD=1.11U
* device instance $116 r0 *1 54.918,-136.845 nfet
M$116 \$91 C|D|PH_B7|Q|S GND|VGND GND|VGND nfet L=0.15U W=0.42U AS=0.1449P
+ AD=0.1092P PS=1.11U PD=1.36U
* device instance $117 r0 *1 52.738,-135.985 nfet
M$117 \$127 \$124 \$126 GND|VGND nfet L=0.15U W=0.36U AS=0.066P AD=0.0594P
+ PS=0.745U PD=0.69U
* device instance $118 r0 *1 53.218,-135.985 nfet
M$118 \$140 \$125 \$127 GND|VGND nfet L=0.15U W=0.36U AS=0.0594P AD=0.1401P
+ PS=0.69U PD=1.1U
* device instance $119 r0 *1 55.563,-135.985 nfet
M$119 \$130 \$125 \$129 GND|VGND nfet L=0.15U W=0.36U AS=0.0999P AD=0.0711P
+ PS=0.985U PD=0.755U
* device instance $120 r0 *1 56.108,-135.985 nfet
M$120 \$142 \$124 \$130 GND|VGND nfet L=0.15U W=0.36U AS=0.0711P AD=0.0669P
+ PS=0.755U PD=0.75U
* device instance $121 r0 *1 52.263,-135.955 nfet
M$121 \$126 A|D|PH_B9|Q|S GND|VGND GND|VGND nfet L=0.15U W=0.42U AS=0.2205P
+ AD=0.066P PS=1.89U PD=0.745U
* device instance $122 r0 *1 54.048,-135.955 nfet
M$122 \$141 \$129 \$140 GND|VGND nfet L=0.15U W=0.42U AS=0.1401P AD=0.0441P
+ PS=1.1U PD=0.63U
* device instance $123 r0 *1 54.408,-135.955 nfet
M$123 GND|VGND RESET_B|RST_B \$141 GND|VGND nfet L=0.15U W=0.42U AS=0.0441P
+ AD=0.1346P PS=0.63U PD=1.15U
* device instance $124 r0 *1 56.588,-135.955 nfet
M$124 GND|VGND \$131 \$142 GND|VGND nfet L=0.15U W=0.42U AS=0.0669P AD=0.12495P
+ PS=0.75U PD=1.015U
* device instance $125 r0 *1 57.333,-135.955 nfet
M$125 \$143 RESET_B|RST_B GND|VGND GND|VGND nfet L=0.15U W=0.42U AS=0.12495P
+ AD=0.06405P PS=1.015U PD=0.725U
* device instance $126 r0 *1 57.788,-135.955 nfet
M$126 \$131 \$130 \$143 GND|VGND nfet L=0.15U W=0.42U AS=0.06405P AD=0.1092P
+ PS=0.725U PD=1.36U
* device instance $127 r0 *1 55.068,-135.845 nfet
M$127 \$129 \$127 GND|VGND GND|VGND nfet L=0.15U W=0.64U AS=0.1346P AD=0.0999P
+ PS=1.15U PD=0.985U
* device instance $128 r0 *1 56.088,-136.96 nfet
M$128 GND|VGND \$92 D|X$1 GND|VGND nfet L=0.15U W=0.65U AS=0.169P AD=0.11285P
+ PS=1.82U PD=1.045U
* device instance $129 r0 *1 56.633,-136.845 nfet
M$129 \$106 B|D|PH_B8|Q|S GND|VGND GND|VGND nfet L=0.15U W=0.42U AS=0.11285P
+ AD=0.0693P PS=1.045U PD=0.75U
* device instance $130 r0 *1 57.113,-136.845 nfet
M$130 \$92 A1|COMP_OUT|OUTP \$106 GND|VGND nfet L=0.15U W=0.42U AS=0.0693P
+ AD=0.09975P PS=0.75U PD=0.895U
* device instance $131 r0 *1 57.738,-136.845 nfet
M$131 \$108 A|A0|DOUT8|Q|SELp8 \$92 GND|VGND nfet L=0.15U W=0.42U AS=0.09975P
+ AD=0.0693P PS=0.895U PD=0.75U
* device instance $132 r0 *1 58.218,-136.845 nfet
M$132 GND|VGND \$93 \$108 GND|VGND nfet L=0.15U W=0.42U AS=0.0693P AD=0.1449P
+ PS=0.75U PD=1.11U
* device instance $133 r0 *1 59.058,-136.845 nfet
M$133 \$93 B|D|PH_B8|Q|S GND|VGND GND|VGND nfet L=0.15U W=0.42U AS=0.1449P
+ AD=0.1092P PS=1.11U PD=1.36U
* device instance $134 r0 *1 58.828,-135.84 nfet
M$134 B|D|PH_B8|Q|S \$131 GND|VGND GND|VGND nfet L=0.15U W=0.65U AS=0.2087P
+ AD=0.169P PS=2.02U PD=1.82U
* device instance $135 r0 *1 29.868,-131.405 nfet
M$135 GND|VGND A|CLK|X \$146 GND|VGND nfet L=0.15U W=0.42U AS=0.1092P
+ AD=0.0567P PS=1.36U PD=0.69U
* device instance $136 r0 *1 30.288,-131.405 nfet
M$136 \$147 \$146 GND|VGND GND|VGND nfet L=0.15U W=0.42U AS=0.0567P AD=0.1092P
+ PS=0.69U PD=1.36U
* device instance $137 r0 *1 31.563,-131.405 nfet
M$137 \$149 D|X$5 GND|VGND GND|VGND nfet L=0.15U W=0.42U AS=0.2205P AD=0.066P
+ PS=1.89U PD=0.745U
* device instance $138 r0 *1 32.038,-131.375 nfet
M$138 \$150 \$146 \$149 GND|VGND nfet L=0.15U W=0.36U AS=0.066P AD=0.0594P
+ PS=0.745U PD=0.69U
* device instance $139 r0 *1 32.518,-131.375 nfet
M$139 \$150 \$147 \$167 GND|VGND nfet L=0.15U W=0.36U AS=0.1401P AD=0.0594P
+ PS=1.1U PD=0.69U
* device instance $140 r0 *1 33.348,-131.405 nfet
M$140 \$166 \$152 \$167 GND|VGND nfet L=0.15U W=0.42U AS=0.1401P AD=0.0441P
+ PS=1.1U PD=0.63U
* device instance $141 r0 *1 33.708,-131.405 nfet
M$141 \$166 RESET_B|RST_B GND|VGND GND|VGND nfet L=0.15U W=0.42U AS=0.1346P
+ AD=0.0441P PS=1.15U PD=0.63U
* device instance $142 r0 *1 34.368,-131.515 nfet
M$142 \$152 \$150 GND|VGND GND|VGND nfet L=0.15U W=0.64U AS=0.1346P AD=0.0999P
+ PS=1.15U PD=0.985U
* device instance $143 r0 *1 34.863,-131.375 nfet
M$143 \$153 \$147 \$152 GND|VGND nfet L=0.15U W=0.36U AS=0.0999P AD=0.0711P
+ PS=0.985U PD=0.755U
* device instance $144 r0 *1 35.408,-131.375 nfet
M$144 \$153 \$146 \$168 GND|VGND nfet L=0.15U W=0.36U AS=0.0669P AD=0.0711P
+ PS=0.75U PD=0.755U
* device instance $145 r0 *1 35.888,-131.405 nfet
M$145 GND|VGND \$155 \$168 GND|VGND nfet L=0.15U W=0.42U AS=0.0669P AD=0.12495P
+ PS=0.75U PD=1.015U
* device instance $146 r0 *1 36.633,-131.405 nfet
M$146 \$170 RESET_B|RST_B GND|VGND GND|VGND nfet L=0.15U W=0.42U AS=0.12495P
+ AD=0.06405P PS=1.015U PD=0.725U
* device instance $147 r0 *1 37.088,-131.405 nfet
M$147 \$155 \$153 \$170 GND|VGND nfet L=0.15U W=0.42U AS=0.06405P AD=0.1092P
+ PS=0.725U PD=1.36U
* device instance $148 r0 *1 34.093,-130.515 nfet
M$148 \$193 D|PH_B2|Q|S GND|VGND GND|VGND nfet L=0.15U W=0.42U AS=0.11285P
+ AD=0.0693P PS=1.045U PD=0.75U
* device instance $149 r0 *1 34.573,-130.515 nfet
M$149 \$179 A1|COMP_OUT|OUTP \$193 GND|VGND nfet L=0.15U W=0.42U AS=0.0693P
+ AD=0.09975P PS=0.75U PD=0.895U
* device instance $150 r0 *1 35.198,-130.515 nfet
M$150 \$196 A|A0|DOUT2|Q|SELp2 \$179 GND|VGND nfet L=0.15U W=0.42U AS=0.09975P
+ AD=0.0693P PS=0.895U PD=0.75U
* device instance $151 r0 *1 35.678,-130.515 nfet
M$151 GND|VGND \$181 \$196 GND|VGND nfet L=0.15U W=0.42U AS=0.0693P AD=0.1449P
+ PS=0.75U PD=1.11U
* device instance $152 r0 *1 36.518,-130.515 nfet
M$152 \$181 D|PH_B2|Q|S GND|VGND GND|VGND nfet L=0.15U W=0.42U AS=0.1449P
+ AD=0.1092P PS=1.11U PD=1.36U
* device instance $153 r0 *1 33.548,-130.4 nfet
M$153 GND|VGND \$179 D|X$5 GND|VGND nfet L=0.15U W=0.65U AS=0.169P AD=0.11285P
+ PS=1.82U PD=1.045U
* device instance $154 r0 *1 38.128,-131.52 nfet
M$154 A|A0|DOUT2|Q|SELp2 \$155 GND|VGND GND|VGND nfet L=0.15U W=0.65U
+ AS=0.2087P AD=0.169P PS=2.02U PD=1.82U
* device instance $155 r0 *1 40.448,-130.4 nfet
M$155 GND|VGND A|CLK \$183 GND|VGND nfet L=0.15U W=0.65U AS=0.169P AD=0.08775P
+ PS=1.82U PD=0.92U
* device instance $156 r0 *1 40.868,-130.4 nfet
M$156 A|X$1 \$183 GND|VGND GND|VGND nfet L=0.15U W=0.65U AS=0.08775P
+ AD=0.08775P PS=0.92U PD=0.92U
* device instance $157 r0 *1 41.288,-130.4 nfet
M$157 GND|VGND \$183 A|X$1 GND|VGND nfet L=0.15U W=0.65U AS=0.08775P
+ AD=0.08775P PS=0.92U PD=0.92U
* device instance $158 r0 *1 41.708,-130.4 nfet
M$158 A|X$1 \$183 GND|VGND GND|VGND nfet L=0.15U W=0.65U AS=0.08775P
+ AD=0.08775P PS=0.92U PD=0.92U
* device instance $159 r0 *1 42.128,-130.4 nfet
M$159 GND|VGND \$183 A|X$1 GND|VGND nfet L=0.15U W=0.65U AS=0.08775P AD=0.169P
+ PS=0.92U PD=1.82U
* device instance $160 r0 *1 48.728,-131.435 nfet
M$160 \$156 D|PH_B6|Q|S GND|VGND GND|VGND nfet L=0.15U W=0.42U AS=0.1092P
+ AD=0.0693P PS=1.36U PD=0.75U
* device instance $161 r0 *1 49.208,-131.435 nfet
M$161 GND|VGND C|D|PH_B7|Q|S \$156 GND|VGND nfet L=0.15U W=0.42U AS=0.0693P
+ AD=0.0567P PS=0.75U PD=0.69U
* device instance $162 r0 *1 49.628,-131.435 nfet
M$162 \$156 B|D|PH_B8|Q|S GND|VGND GND|VGND nfet L=0.15U W=0.42U AS=0.0567P
+ AD=0.0567P PS=0.69U PD=0.69U
* device instance $163 r0 *1 50.048,-131.435 nfet
M$163 \$156 A|D|PH_B9|Q|S GND|VGND GND|VGND nfet L=0.15U W=0.42U AS=0.101875P
+ AD=0.0567P PS=0.99U PD=0.69U
* device instance $164 r0 *1 50.538,-131.52 nfet
M$164 A|X \$156 GND|VGND GND|VGND nfet L=0.15U W=0.65U AS=0.101875P AD=0.1755P
+ PS=0.99U PD=1.84U
* device instance $165 r0 *1 49.188,-130.515 nfet
M$165 GND|VGND A|CLK|X \$185 GND|VGND nfet L=0.15U W=0.42U AS=0.1092P
+ AD=0.0567P PS=1.36U PD=0.69U
* device instance $166 r0 *1 49.608,-130.515 nfet
M$166 \$186 \$185 GND|VGND GND|VGND nfet L=0.15U W=0.42U AS=0.0567P AD=0.1092P
+ PS=0.69U PD=1.36U
* device instance $167 r0 *1 51.358,-130.545 nfet
M$167 \$188 \$185 \$187 GND|VGND nfet L=0.15U W=0.36U AS=0.066P AD=0.0594P
+ PS=0.745U PD=0.69U
* device instance $168 r0 *1 51.838,-130.545 nfet
M$168 \$198 \$186 \$188 GND|VGND nfet L=0.15U W=0.36U AS=0.0594P AD=0.1401P
+ PS=0.69U PD=1.1U
* device instance $169 r0 *1 54.183,-130.545 nfet
M$169 \$191 \$186 \$190 GND|VGND nfet L=0.15U W=0.36U AS=0.0999P AD=0.0711P
+ PS=0.985U PD=0.755U
* device instance $170 r0 *1 54.728,-130.545 nfet
M$170 \$200 \$185 \$191 GND|VGND nfet L=0.15U W=0.36U AS=0.0711P AD=0.0669P
+ PS=0.755U PD=0.75U
* device instance $171 r0 *1 50.883,-130.515 nfet
M$171 \$187 D|X$3 GND|VGND GND|VGND nfet L=0.15U W=0.42U AS=0.2205P AD=0.066P
+ PS=1.89U PD=0.745U
* device instance $172 r0 *1 52.668,-130.515 nfet
M$172 \$197 \$190 \$198 GND|VGND nfet L=0.15U W=0.42U AS=0.1401P AD=0.0441P
+ PS=1.1U PD=0.63U
* device instance $173 r0 *1 53.028,-130.515 nfet
M$173 GND|VGND RESET_B|RST_B \$197 GND|VGND nfet L=0.15U W=0.42U AS=0.0441P
+ AD=0.1346P PS=0.63U PD=1.15U
* device instance $174 r0 *1 55.208,-130.515 nfet
M$174 GND|VGND \$192 \$200 GND|VGND nfet L=0.15U W=0.42U AS=0.0669P AD=0.12495P
+ PS=0.75U PD=1.015U
* device instance $175 r0 *1 55.953,-130.515 nfet
M$175 \$201 RESET_B|RST_B GND|VGND GND|VGND nfet L=0.15U W=0.42U AS=0.12495P
+ AD=0.06405P PS=1.015U PD=0.725U
* device instance $176 r0 *1 56.408,-130.515 nfet
M$176 \$192 \$191 \$201 GND|VGND nfet L=0.15U W=0.42U AS=0.06405P AD=0.1092P
+ PS=0.725U PD=1.36U
* device instance $177 r0 *1 53.688,-130.405 nfet
M$177 \$190 \$188 GND|VGND GND|VGND nfet L=0.15U W=0.64U AS=0.1346P AD=0.0999P
+ PS=1.15U PD=0.985U
* device instance $178 r0 *1 51.948,-131.405 nfet
M$178 GND|VGND A|CLK|X \$158 GND|VGND nfet L=0.15U W=0.42U AS=0.1092P
+ AD=0.0567P PS=1.36U PD=0.69U
* device instance $179 r0 *1 52.368,-131.405 nfet
M$179 \$159 \$158 GND|VGND GND|VGND nfet L=0.15U W=0.42U AS=0.0567P AD=0.1092P
+ PS=0.69U PD=1.36U
* device instance $180 r0 *1 53.643,-131.405 nfet
M$180 \$160 D|PH_SAMPLE|SAMPLE|Y GND|VGND GND|VGND nfet L=0.15U W=0.42U
+ AS=0.2205P AD=0.066P PS=1.89U PD=0.745U
* device instance $181 r0 *1 54.118,-131.375 nfet
M$181 \$161 \$158 \$160 GND|VGND nfet L=0.15U W=0.36U AS=0.066P AD=0.0594P
+ PS=0.745U PD=0.69U
* device instance $182 r0 *1 54.598,-131.375 nfet
M$182 \$161 \$159 \$175 GND|VGND nfet L=0.15U W=0.36U AS=0.1401P AD=0.0594P
+ PS=1.1U PD=0.69U
* device instance $183 r0 *1 55.428,-131.405 nfet
M$183 \$174 \$163 \$175 GND|VGND nfet L=0.15U W=0.42U AS=0.1401P AD=0.0441P
+ PS=1.1U PD=0.63U
* device instance $184 r0 *1 55.788,-131.405 nfet
M$184 \$174 RESET_B|RST_B GND|VGND GND|VGND nfet L=0.15U W=0.42U AS=0.1346P
+ AD=0.0441P PS=1.15U PD=0.63U
* device instance $185 r0 *1 56.448,-131.515 nfet
M$185 \$163 \$161 GND|VGND GND|VGND nfet L=0.15U W=0.64U AS=0.1346P AD=0.0999P
+ PS=1.15U PD=0.985U
* device instance $186 r0 *1 56.943,-131.375 nfet
M$186 \$164 \$159 \$163 GND|VGND nfet L=0.15U W=0.36U AS=0.0999P AD=0.0711P
+ PS=0.985U PD=0.755U
* device instance $187 r0 *1 57.488,-131.375 nfet
M$187 \$164 \$158 \$177 GND|VGND nfet L=0.15U W=0.36U AS=0.0669P AD=0.0711P
+ PS=0.75U PD=0.755U
* device instance $188 r0 *1 57.968,-131.405 nfet
M$188 GND|VGND \$165 \$177 GND|VGND nfet L=0.15U W=0.42U AS=0.0669P AD=0.12495P
+ PS=0.75U PD=1.015U
* device instance $189 r0 *1 58.713,-131.405 nfet
M$189 \$178 RESET_B|RST_B GND|VGND GND|VGND nfet L=0.15U W=0.42U AS=0.12495P
+ AD=0.06405P PS=1.015U PD=0.725U
* device instance $190 r0 *1 59.168,-131.405 nfet
M$190 \$165 \$164 \$178 GND|VGND nfet L=0.15U W=0.42U AS=0.06405P AD=0.1092P
+ PS=0.725U PD=1.36U
* device instance $191 r0 *1 57.448,-130.4 nfet
M$191 A|A0|DOUT7|Q|SELp7 \$192 GND|VGND GND|VGND nfet L=0.15U W=0.65U
+ AS=0.2087P AD=0.169P PS=2.02U PD=1.82U
* device instance $192 r0 *1 60.208,-131.52 nfet
M$192 A|D|PH_B9|Q|S \$165 GND|VGND GND|VGND nfet L=0.15U W=0.65U AS=0.2087P
+ AD=0.169P PS=2.02U PD=1.82U
* device instance $193 r0 *1 29.868,-125.965 nfet
M$193 GND|VGND CLK|X \$203 GND|VGND nfet L=0.15U W=0.42U AS=0.1092P AD=0.0567P
+ PS=1.36U PD=0.69U
* device instance $194 r0 *1 30.288,-125.965 nfet
M$194 \$204 \$203 GND|VGND GND|VGND nfet L=0.15U W=0.42U AS=0.0567P AD=0.1092P
+ PS=0.69U PD=1.36U
* device instance $195 r0 *1 31.563,-125.965 nfet
M$195 \$205 A|D|PH_B5|Q|S GND|VGND GND|VGND nfet L=0.15U W=0.42U AS=0.2205P
+ AD=0.066P PS=1.89U PD=0.745U
* device instance $196 r0 *1 32.038,-125.935 nfet
M$196 \$206 \$203 \$205 GND|VGND nfet L=0.15U W=0.36U AS=0.066P AD=0.0594P
+ PS=0.745U PD=0.69U
* device instance $197 r0 *1 32.518,-125.935 nfet
M$197 \$206 \$204 \$233 GND|VGND nfet L=0.15U W=0.36U AS=0.1401P AD=0.0594P
+ PS=1.1U PD=0.69U
* device instance $198 r0 *1 33.348,-125.965 nfet
M$198 \$234 \$208 \$233 GND|VGND nfet L=0.15U W=0.42U AS=0.1401P AD=0.0441P
+ PS=1.1U PD=0.63U
* device instance $199 r0 *1 33.708,-125.965 nfet
M$199 \$234 RESET_B|RST_B GND|VGND GND|VGND nfet L=0.15U W=0.42U AS=0.1346P
+ AD=0.0441P PS=1.15U PD=0.63U
* device instance $200 r0 *1 34.368,-126.075 nfet
M$200 \$208 \$206 GND|VGND GND|VGND nfet L=0.15U W=0.64U AS=0.1346P AD=0.0999P
+ PS=1.15U PD=0.985U
* device instance $201 r0 *1 34.863,-125.935 nfet
M$201 \$210 \$204 \$208 GND|VGND nfet L=0.15U W=0.36U AS=0.0999P AD=0.0711P
+ PS=0.985U PD=0.755U
* device instance $202 r0 *1 35.408,-125.935 nfet
M$202 \$210 \$203 \$232 GND|VGND nfet L=0.15U W=0.36U AS=0.0669P AD=0.0711P
+ PS=0.75U PD=0.755U
* device instance $203 r0 *1 35.888,-125.965 nfet
M$203 GND|VGND \$211 \$232 GND|VGND nfet L=0.15U W=0.42U AS=0.0669P AD=0.12495P
+ PS=0.75U PD=1.015U
* device instance $204 r0 *1 36.633,-125.965 nfet
M$204 \$231 RESET_B|RST_B GND|VGND GND|VGND nfet L=0.15U W=0.42U AS=0.12495P
+ AD=0.06405P PS=1.015U PD=0.725U
* device instance $205 r0 *1 37.088,-125.965 nfet
M$205 \$211 \$210 \$231 GND|VGND nfet L=0.15U W=0.42U AS=0.06405P AD=0.1092P
+ PS=0.725U PD=1.36U
* device instance $206 r0 *1 38.128,-126.08 nfet
M$206 B|D|PH_B4|Q|S \$211 GND|VGND GND|VGND nfet L=0.15U W=0.65U AS=0.2087P
+ AD=0.169P PS=2.02U PD=1.82U
* device instance $207 r0 *1 48.728,-125.995 nfet
M$207 \$212 D|PH_B2|Q|S GND|VGND GND|VGND nfet L=0.15U W=0.42U AS=0.1092P
+ AD=0.0693P PS=1.36U PD=0.75U
* device instance $208 r0 *1 49.208,-125.995 nfet
M$208 GND|VGND C|D|PH_B3|Q|S \$212 GND|VGND nfet L=0.15U W=0.42U AS=0.0693P
+ AD=0.0567P PS=0.75U PD=0.69U
* device instance $209 r0 *1 49.628,-125.995 nfet
M$209 \$212 B|D|PH_B4|Q|S GND|VGND GND|VGND nfet L=0.15U W=0.42U AS=0.0567P
+ AD=0.0567P PS=0.69U PD=0.69U
* device instance $210 r0 *1 50.048,-125.995 nfet
M$210 \$212 A|D|PH_B5|Q|S GND|VGND GND|VGND nfet L=0.15U W=0.42U AS=0.101875P
+ AD=0.0567P PS=0.99U PD=0.69U
* device instance $211 r0 *1 50.538,-126.08 nfet
M$211 B|X \$212 GND|VGND GND|VGND nfet L=0.15U W=0.65U AS=0.101875P AD=0.1755P
+ PS=0.99U PD=1.84U
* device instance $212 r0 *1 52.613,-126.08 nfet
M$212 D|PH_SAMPLE|SAMPLE|Y A|BUSY|X GND|VGND GND|VGND nfet L=0.15U W=0.65U
+ AS=0.169P AD=0.169P PS=1.82U PD=1.82U
* device instance $213 r0 *1 53.798,-125.995 nfet
M$213 GND|VGND C|X \$216 GND|VGND nfet L=0.15U W=0.42U AS=0.1092P AD=0.0567P
+ PS=1.36U PD=0.69U
* device instance $214 r0 *1 54.218,-125.995 nfet
M$214 \$216 B|X GND|VGND GND|VGND nfet L=0.15U W=0.42U AS=0.0567P AD=0.0567P
+ PS=0.69U PD=0.69U
* device instance $215 r0 *1 54.638,-125.995 nfet
M$215 \$216 A|X GND|VGND GND|VGND nfet L=0.15U W=0.42U AS=0.101875P AD=0.0567P
+ PS=0.99U PD=0.69U
* device instance $216 r0 *1 55.128,-126.08 nfet
M$216 A|BUSY|X \$216 GND|VGND GND|VGND nfet L=0.15U W=0.65U AS=0.101875P
+ AD=0.182P PS=0.99U PD=1.86U
* device instance $217 r0 *1 56.088,-126.08 nfet
M$217 GND|VGND \$218 D|X$6 GND|VGND nfet L=0.15U W=0.65U AS=0.169P AD=0.11285P
+ PS=1.82U PD=1.045U
* device instance $218 r0 *1 56.633,-125.965 nfet
M$218 \$230 A|D|PH_B9|Q|S GND|VGND GND|VGND nfet L=0.15U W=0.42U AS=0.11285P
+ AD=0.0693P PS=1.045U PD=0.75U
* device instance $219 r0 *1 57.113,-125.965 nfet
M$219 \$218 A1|COMP_OUT|OUTP \$230 GND|VGND nfet L=0.15U W=0.42U AS=0.0693P
+ AD=0.09975P PS=0.75U PD=0.895U
* device instance $220 r0 *1 57.738,-125.965 nfet
M$220 \$229 A0|DOUT9|Q \$218 GND|VGND nfet L=0.15U W=0.42U AS=0.09975P
+ AD=0.0693P PS=0.895U PD=0.75U
* device instance $221 r0 *1 58.218,-125.965 nfet
M$221 GND|VGND \$220 \$229 GND|VGND nfet L=0.15U W=0.42U AS=0.0693P AD=0.1449P
+ PS=0.75U PD=1.11U
* device instance $222 r0 *1 59.058,-125.965 nfet
M$222 \$220 A|D|PH_B9|Q|S GND|VGND GND|VGND nfet L=0.15U W=0.42U AS=0.1449P
+ AD=0.1092P PS=1.11U PD=1.36U
* device instance $223 r0 *1 28.488,-125.075 nfet
M$223 GND|VGND CLK|X \$235 GND|VGND nfet L=0.15U W=0.42U AS=0.1092P AD=0.0567P
+ PS=1.36U PD=0.69U
* device instance $224 r0 *1 28.908,-125.075 nfet
M$224 \$236 \$235 GND|VGND GND|VGND nfet L=0.15U W=0.42U AS=0.0567P AD=0.1092P
+ PS=0.69U PD=1.36U
* device instance $225 r0 *1 30.658,-125.105 nfet
M$225 \$238 \$235 \$237 GND|VGND nfet L=0.15U W=0.36U AS=0.066P AD=0.0594P
+ PS=0.745U PD=0.69U
* device instance $226 r0 *1 31.138,-125.105 nfet
M$226 \$251 \$236 \$238 GND|VGND nfet L=0.15U W=0.36U AS=0.0594P AD=0.1401P
+ PS=0.69U PD=1.1U
* device instance $227 r0 *1 33.483,-125.105 nfet
M$227 \$241 \$236 \$240 GND|VGND nfet L=0.15U W=0.36U AS=0.0999P AD=0.0711P
+ PS=0.985U PD=0.755U
* device instance $228 r0 *1 34.028,-125.105 nfet
M$228 \$253 \$235 \$241 GND|VGND nfet L=0.15U W=0.36U AS=0.0711P AD=0.0669P
+ PS=0.755U PD=0.75U
* device instance $229 r0 *1 30.183,-125.075 nfet
M$229 \$237 B|D|PH_B4|Q|S GND|VGND GND|VGND nfet L=0.15U W=0.42U AS=0.2205P
+ AD=0.066P PS=1.89U PD=0.745U
* device instance $230 r0 *1 31.968,-125.075 nfet
M$230 \$252 \$240 \$251 GND|VGND nfet L=0.15U W=0.42U AS=0.1401P AD=0.0441P
+ PS=1.1U PD=0.63U
* device instance $231 r0 *1 32.328,-125.075 nfet
M$231 GND|VGND RESET_B|RST_B \$252 GND|VGND nfet L=0.15U W=0.42U AS=0.0441P
+ AD=0.1346P PS=0.63U PD=1.15U
* device instance $232 r0 *1 34.508,-125.075 nfet
M$232 GND|VGND \$242 \$253 GND|VGND nfet L=0.15U W=0.42U AS=0.0669P AD=0.12495P
+ PS=0.75U PD=1.015U
* device instance $233 r0 *1 35.253,-125.075 nfet
M$233 \$255 RESET_B|RST_B GND|VGND GND|VGND nfet L=0.15U W=0.42U AS=0.12495P
+ AD=0.06405P PS=1.015U PD=0.725U
* device instance $234 r0 *1 35.708,-125.075 nfet
M$234 \$242 \$241 \$255 GND|VGND nfet L=0.15U W=0.42U AS=0.06405P AD=0.1092P
+ PS=0.725U PD=1.36U
* device instance $235 r0 *1 32.988,-124.965 nfet
M$235 \$240 \$238 GND|VGND GND|VGND nfet L=0.15U W=0.64U AS=0.1346P AD=0.0999P
+ PS=1.15U PD=0.985U
* device instance $236 r0 *1 36.748,-124.96 nfet
M$236 C|D|PH_B3|Q|S \$242 GND|VGND GND|VGND nfet L=0.15U W=0.65U AS=0.2087P
+ AD=0.169P PS=2.02U PD=1.82U
* device instance $237 r0 *1 49.188,-125.075 nfet
M$237 GND|VGND CLK|X \$243 GND|VGND nfet L=0.15U W=0.42U AS=0.1092P AD=0.0567P
+ PS=1.36U PD=0.69U
* device instance $238 r0 *1 49.608,-125.075 nfet
M$238 \$244 \$243 GND|VGND GND|VGND nfet L=0.15U W=0.42U AS=0.0567P AD=0.1092P
+ PS=0.69U PD=1.36U
* device instance $239 r0 *1 51.358,-125.105 nfet
M$239 \$246 \$243 \$245 GND|VGND nfet L=0.15U W=0.36U AS=0.066P AD=0.0594P
+ PS=0.745U PD=0.69U
* device instance $240 r0 *1 51.838,-125.105 nfet
M$240 \$256 \$244 \$246 GND|VGND nfet L=0.15U W=0.36U AS=0.0594P AD=0.1401P
+ PS=0.69U PD=1.1U
* device instance $241 r0 *1 54.183,-125.105 nfet
M$241 \$249 \$244 \$248 GND|VGND nfet L=0.15U W=0.36U AS=0.0999P AD=0.0711P
+ PS=0.985U PD=0.755U
* device instance $242 r0 *1 54.728,-125.105 nfet
M$242 \$259 \$243 \$249 GND|VGND nfet L=0.15U W=0.36U AS=0.0711P AD=0.0669P
+ PS=0.755U PD=0.75U
* device instance $243 r0 *1 50.883,-125.075 nfet
M$243 \$245 D|X$6 GND|VGND GND|VGND nfet L=0.15U W=0.42U AS=0.2205P AD=0.066P
+ PS=1.89U PD=0.745U
* device instance $244 r0 *1 52.668,-125.075 nfet
M$244 \$257 \$248 \$256 GND|VGND nfet L=0.15U W=0.42U AS=0.1401P AD=0.0441P
+ PS=1.1U PD=0.63U
* device instance $245 r0 *1 53.028,-125.075 nfet
M$245 GND|VGND RESET_B|RST_B \$257 GND|VGND nfet L=0.15U W=0.42U AS=0.0441P
+ AD=0.1346P PS=0.63U PD=1.15U
* device instance $246 r0 *1 55.208,-125.075 nfet
M$246 GND|VGND \$250 \$259 GND|VGND nfet L=0.15U W=0.42U AS=0.0669P AD=0.12495P
+ PS=0.75U PD=1.015U
* device instance $247 r0 *1 55.953,-125.075 nfet
M$247 \$260 RESET_B|RST_B GND|VGND GND|VGND nfet L=0.15U W=0.42U AS=0.12495P
+ AD=0.06405P PS=1.015U PD=0.725U
* device instance $248 r0 *1 56.408,-125.075 nfet
M$248 \$250 \$249 \$260 GND|VGND nfet L=0.15U W=0.42U AS=0.06405P AD=0.1092P
+ PS=0.725U PD=1.36U
* device instance $249 r0 *1 53.688,-124.965 nfet
M$249 \$248 \$246 GND|VGND GND|VGND nfet L=0.15U W=0.64U AS=0.1346P AD=0.0999P
+ PS=1.15U PD=0.985U
* device instance $250 r0 *1 57.448,-124.96 nfet
M$250 A0|DOUT9|Q \$250 GND|VGND GND|VGND nfet L=0.15U W=0.65U AS=0.2087P
+ AD=0.169P PS=2.02U PD=1.82U
* device instance $251 r0 *1 32.168,-120.64 nfet
M$251 GND|VGND \$262 D|X$7 GND|VGND nfet L=0.15U W=0.65U AS=0.169P AD=0.11285P
+ PS=1.82U PD=1.045U
* device instance $252 r0 *1 32.713,-120.525 nfet
M$252 \$296 B|D|PH_B4|Q|S GND|VGND GND|VGND nfet L=0.15U W=0.42U AS=0.11285P
+ AD=0.0693P PS=1.045U PD=0.75U
* device instance $253 r0 *1 33.193,-120.525 nfet
M$253 \$262 A1|COMP_OUT|OUTP \$296 GND|VGND nfet L=0.15U W=0.42U AS=0.0693P
+ AD=0.09975P PS=0.75U PD=0.895U
* device instance $254 r0 *1 33.818,-120.525 nfet
M$254 \$297 A|A0|DOUT4|Q|SELp4 \$262 GND|VGND nfet L=0.15U W=0.42U AS=0.09975P
+ AD=0.0693P PS=0.895U PD=0.75U
* device instance $255 r0 *1 34.298,-120.525 nfet
M$255 GND|VGND \$264 \$297 GND|VGND nfet L=0.15U W=0.42U AS=0.0693P AD=0.1449P
+ PS=0.75U PD=1.11U
* device instance $256 r0 *1 35.138,-120.525 nfet
M$256 \$264 B|D|PH_B4|Q|S GND|VGND GND|VGND nfet L=0.15U W=0.42U AS=0.1449P
+ AD=0.1092P PS=1.11U PD=1.36U
* device instance $257 r0 *1 36.308,-120.525 nfet
M$257 GND|VGND CLK|X \$265 GND|VGND nfet L=0.15U W=0.42U AS=0.1092P AD=0.0567P
+ PS=1.36U PD=0.69U
* device instance $258 r0 *1 36.728,-120.525 nfet
M$258 \$266 \$265 GND|VGND GND|VGND nfet L=0.15U W=0.42U AS=0.0567P AD=0.1092P
+ PS=0.69U PD=1.36U
* device instance $259 r0 *1 38.003,-120.525 nfet
M$259 \$267 D|PH_B2|Q|S GND|VGND GND|VGND nfet L=0.15U W=0.42U AS=0.2205P
+ AD=0.066P PS=1.89U PD=0.745U
* device instance $260 r0 *1 38.478,-120.495 nfet
M$260 \$268 \$265 \$267 GND|VGND nfet L=0.15U W=0.36U AS=0.066P AD=0.0594P
+ PS=0.745U PD=0.69U
* device instance $261 r0 *1 38.958,-120.495 nfet
M$261 \$268 \$266 \$300 GND|VGND nfet L=0.15U W=0.36U AS=0.1401P AD=0.0594P
+ PS=1.1U PD=0.69U
* device instance $262 r0 *1 39.788,-120.525 nfet
M$262 \$301 \$270 \$300 GND|VGND nfet L=0.15U W=0.42U AS=0.1401P AD=0.0441P
+ PS=1.1U PD=0.63U
* device instance $263 r0 *1 40.148,-120.525 nfet
M$263 \$301 RESET_B|RST_B GND|VGND GND|VGND nfet L=0.15U W=0.42U AS=0.1346P
+ AD=0.0441P PS=1.15U PD=0.63U
* device instance $264 r0 *1 40.808,-120.635 nfet
M$264 \$270 \$268 GND|VGND GND|VGND nfet L=0.15U W=0.64U AS=0.1346P AD=0.0999P
+ PS=1.15U PD=0.985U
* device instance $265 r0 *1 41.303,-120.495 nfet
M$265 \$271 \$266 \$270 GND|VGND nfet L=0.15U W=0.36U AS=0.0999P AD=0.0711P
+ PS=0.985U PD=0.755U
* device instance $266 r0 *1 41.848,-120.495 nfet
M$266 \$271 \$265 \$303 GND|VGND nfet L=0.15U W=0.36U AS=0.0669P AD=0.0711P
+ PS=0.75U PD=0.755U
* device instance $267 r0 *1 42.328,-120.525 nfet
M$267 GND|VGND \$272 \$303 GND|VGND nfet L=0.15U W=0.42U AS=0.0669P AD=0.12495P
+ PS=0.75U PD=1.015U
* device instance $268 r0 *1 43.073,-120.525 nfet
M$268 \$302 RESET_B|RST_B GND|VGND GND|VGND nfet L=0.15U W=0.42U AS=0.12495P
+ AD=0.06405P PS=1.015U PD=0.725U
* device instance $269 r0 *1 43.528,-120.525 nfet
M$269 \$272 \$271 \$302 GND|VGND nfet L=0.15U W=0.42U AS=0.06405P AD=0.1092P
+ PS=0.725U PD=1.36U
* device instance $270 r0 *1 44.568,-120.64 nfet
M$270 A|D|PH_B1|Q|S \$272 GND|VGND GND|VGND nfet L=0.15U W=0.65U AS=0.2087P
+ AD=0.169P PS=2.02U PD=1.82U
* device instance $271 r0 *1 47.348,-120.64 nfet
M$271 GND|VGND \$274 D|X$8 GND|VGND nfet L=0.15U W=0.65U AS=0.169P AD=0.11285P
+ PS=1.82U PD=1.045U
* device instance $272 r0 *1 47.893,-120.525 nfet
M$272 \$299 A|D|PH_B1|Q|S GND|VGND GND|VGND nfet L=0.15U W=0.42U AS=0.11285P
+ AD=0.0693P PS=1.045U PD=0.75U
* device instance $273 r0 *1 48.373,-120.525 nfet
M$273 \$274 A1|COMP_OUT|OUTP \$299 GND|VGND nfet L=0.15U W=0.42U AS=0.0693P
+ AD=0.09975P PS=0.75U PD=0.895U
* device instance $274 r0 *1 48.998,-120.525 nfet
M$274 \$298 A|A0|DOUT1|Q|SELp1 \$274 GND|VGND nfet L=0.15U W=0.42U AS=0.09975P
+ AD=0.0693P PS=0.895U PD=0.75U
* device instance $275 r0 *1 49.478,-120.525 nfet
M$275 GND|VGND \$277 \$298 GND|VGND nfet L=0.15U W=0.42U AS=0.0693P AD=0.1449P
+ PS=0.75U PD=1.11U
* device instance $276 r0 *1 50.318,-120.525 nfet
M$276 \$277 A|D|PH_B1|Q|S GND|VGND GND|VGND nfet L=0.15U W=0.42U AS=0.1449P
+ AD=0.1092P PS=1.11U PD=1.36U
* device instance $277 r0 *1 52.408,-120.64 nfet
M$277 GND|VGND \$279 D|X$9 GND|VGND nfet L=0.15U W=0.65U AS=0.169P AD=0.11285P
+ PS=1.82U PD=1.045U
* device instance $278 r0 *1 52.953,-120.525 nfet
M$278 \$295 B|D|PH_B0|Q|S GND|VGND GND|VGND nfet L=0.15U W=0.42U AS=0.11285P
+ AD=0.0693P PS=1.045U PD=0.75U
* device instance $279 r0 *1 53.433,-120.525 nfet
M$279 \$279 A1|COMP_OUT|OUTP \$295 GND|VGND nfet L=0.15U W=0.42U AS=0.0693P
+ AD=0.09975P PS=0.75U PD=0.895U
* device instance $280 r0 *1 54.058,-120.525 nfet
M$280 \$294 A|A0|DOUT0|Q|SELp0 \$279 GND|VGND nfet L=0.15U W=0.42U AS=0.09975P
+ AD=0.0693P PS=0.895U PD=0.75U
* device instance $281 r0 *1 54.538,-120.525 nfet
M$281 GND|VGND \$282 \$294 GND|VGND nfet L=0.15U W=0.42U AS=0.0693P AD=0.1449P
+ PS=0.75U PD=1.11U
* device instance $282 r0 *1 55.378,-120.525 nfet
M$282 \$282 B|D|PH_B0|Q|S GND|VGND GND|VGND nfet L=0.15U W=0.42U AS=0.1449P
+ AD=0.1092P PS=1.11U PD=1.36U
* device instance $283 r0 *1 56.558,-120.555 nfet
M$283 GND|VGND C|PH_EOC|Q \$284 GND|VGND nfet L=0.15U W=0.42U AS=0.1092P
+ AD=0.0567P PS=1.36U PD=0.69U
* device instance $284 r0 *1 56.978,-120.555 nfet
M$284 \$284 B|D|PH_B0|Q|S GND|VGND GND|VGND nfet L=0.15U W=0.42U AS=0.0567P
+ AD=0.0567P PS=0.69U PD=0.69U
* device instance $285 r0 *1 57.398,-120.555 nfet
M$285 \$284 A|D|PH_B1|Q|S GND|VGND GND|VGND nfet L=0.15U W=0.42U AS=0.101875P
+ AD=0.0567P PS=0.99U PD=0.69U
* device instance $286 r0 *1 57.888,-120.64 nfet
M$286 C|X \$284 GND|VGND GND|VGND nfet L=0.15U W=0.65U AS=0.101875P AD=0.182P
+ PS=0.99U PD=1.86U
* device instance $287 r0 *1 28.488,-119.635 nfet
M$287 GND|VGND CLK|X \$304 GND|VGND nfet L=0.15U W=0.42U AS=0.1092P AD=0.0567P
+ PS=1.36U PD=0.69U
* device instance $288 r0 *1 28.908,-119.635 nfet
M$288 \$305 \$304 GND|VGND GND|VGND nfet L=0.15U W=0.42U AS=0.0567P AD=0.1092P
+ PS=0.69U PD=1.36U
* device instance $289 r0 *1 30.658,-119.665 nfet
M$289 \$307 \$304 \$306 GND|VGND nfet L=0.15U W=0.36U AS=0.066P AD=0.0594P
+ PS=0.745U PD=0.69U
* device instance $290 r0 *1 31.138,-119.665 nfet
M$290 \$320 \$305 \$307 GND|VGND nfet L=0.15U W=0.36U AS=0.0594P AD=0.1401P
+ PS=0.69U PD=1.1U
* device instance $291 r0 *1 33.483,-119.665 nfet
M$291 \$310 \$305 \$309 GND|VGND nfet L=0.15U W=0.36U AS=0.0999P AD=0.0711P
+ PS=0.985U PD=0.755U
* device instance $292 r0 *1 34.028,-119.665 nfet
M$292 \$323 \$304 \$310 GND|VGND nfet L=0.15U W=0.36U AS=0.0711P AD=0.0669P
+ PS=0.755U PD=0.75U
* device instance $293 r0 *1 30.183,-119.635 nfet
M$293 \$306 D|X$4 GND|VGND GND|VGND nfet L=0.15U W=0.42U AS=0.2205P AD=0.066P
+ PS=1.89U PD=0.745U
* device instance $294 r0 *1 31.968,-119.635 nfet
M$294 \$321 \$309 \$320 GND|VGND nfet L=0.15U W=0.42U AS=0.1401P AD=0.0441P
+ PS=1.1U PD=0.63U
* device instance $295 r0 *1 32.328,-119.635 nfet
M$295 GND|VGND RESET_B|RST_B \$321 GND|VGND nfet L=0.15U W=0.42U AS=0.0441P
+ AD=0.1346P PS=0.63U PD=1.15U
* device instance $296 r0 *1 34.508,-119.635 nfet
M$296 GND|VGND \$311 \$323 GND|VGND nfet L=0.15U W=0.42U AS=0.0669P AD=0.12495P
+ PS=0.75U PD=1.015U
* device instance $297 r0 *1 35.253,-119.635 nfet
M$297 \$324 RESET_B|RST_B GND|VGND GND|VGND nfet L=0.15U W=0.42U AS=0.12495P
+ AD=0.06405P PS=1.015U PD=0.725U
* device instance $298 r0 *1 35.708,-119.635 nfet
M$298 \$311 \$310 \$324 GND|VGND nfet L=0.15U W=0.42U AS=0.06405P AD=0.1092P
+ PS=0.725U PD=1.36U
* device instance $299 r0 *1 32.988,-119.525 nfet
M$299 \$309 \$307 GND|VGND GND|VGND nfet L=0.15U W=0.64U AS=0.1346P AD=0.0999P
+ PS=1.15U PD=0.985U
* device instance $300 r0 *1 36.748,-119.52 nfet
M$300 A|A0|DOUT3|Q|SELp3 \$311 GND|VGND GND|VGND nfet L=0.15U W=0.65U
+ AS=0.2087P AD=0.169P PS=2.02U PD=1.82U
* device instance $301 r0 *1 37.668,-115.2 nfet
M$301 A|A0|DOUT4|Q|SELp4 \$337 GND|VGND GND|VGND nfet L=0.15U W=0.65U
+ AS=0.2087P AD=0.169P PS=2.02U PD=1.82U
* device instance $302 r0 *1 38.608,-115.2 nfet
M$302 GND|VGND A|X$1 \$338 GND|VGND nfet L=0.15U W=0.65U AS=0.169P AD=0.08775P
+ PS=1.82U PD=0.92U
* device instance $303 r0 *1 39.028,-115.2 nfet
M$303 CLK|X \$338 GND|VGND GND|VGND nfet L=0.15U W=0.65U AS=0.08775P
+ AD=0.08775P PS=0.92U PD=0.92U
* device instance $304 r0 *1 39.448,-115.2 nfet
M$304 GND|VGND \$338 CLK|X GND|VGND nfet L=0.15U W=0.65U AS=0.08775P
+ AD=0.08775P PS=0.92U PD=0.92U
* device instance $305 r0 *1 39.868,-115.2 nfet
M$305 CLK|X \$338 GND|VGND GND|VGND nfet L=0.15U W=0.65U AS=0.08775P
+ AD=0.08775P PS=0.92U PD=0.92U
* device instance $306 r0 *1 40.288,-115.2 nfet
M$306 GND|VGND \$338 CLK|X GND|VGND nfet L=0.15U W=0.65U AS=0.08775P AD=0.169P
+ PS=0.92U PD=1.82U
* device instance $307 r0 *1 49.648,-119.635 nfet
M$307 GND|VGND CLK|X \$312 GND|VGND nfet L=0.15U W=0.42U AS=0.1092P AD=0.0567P
+ PS=1.36U PD=0.69U
* device instance $308 r0 *1 50.068,-119.635 nfet
M$308 \$313 \$312 GND|VGND GND|VGND nfet L=0.15U W=0.42U AS=0.0567P AD=0.1092P
+ PS=0.69U PD=1.36U
* device instance $309 r0 *1 50.548,-115.2 nfet
M$309 B|D|PH_B0|Q|S \$346 GND|VGND GND|VGND nfet L=0.15U W=0.65U AS=0.2087P
+ AD=0.169P PS=2.02U PD=1.82U
* device instance $310 r0 *1 51.818,-119.665 nfet
M$310 \$315 \$312 \$314 GND|VGND nfet L=0.15U W=0.36U AS=0.066P AD=0.0594P
+ PS=0.745U PD=0.69U
* device instance $311 r0 *1 52.298,-119.665 nfet
M$311 \$325 \$313 \$315 GND|VGND nfet L=0.15U W=0.36U AS=0.0594P AD=0.1401P
+ PS=0.69U PD=1.1U
* device instance $312 r0 *1 54.643,-119.665 nfet
M$312 \$318 \$313 \$317 GND|VGND nfet L=0.15U W=0.36U AS=0.0999P AD=0.0711P
+ PS=0.985U PD=0.755U
* device instance $313 r0 *1 55.188,-119.665 nfet
M$313 \$328 \$312 \$318 GND|VGND nfet L=0.15U W=0.36U AS=0.0711P AD=0.0669P
+ PS=0.755U PD=0.75U
* device instance $314 r0 *1 51.343,-119.635 nfet
M$314 \$314 B|D|PH_B0|Q|S GND|VGND GND|VGND nfet L=0.15U W=0.42U AS=0.2205P
+ AD=0.066P PS=1.89U PD=0.745U
* device instance $315 r0 *1 53.128,-119.635 nfet
M$315 \$326 \$317 \$325 GND|VGND nfet L=0.15U W=0.42U AS=0.1401P AD=0.0441P
+ PS=1.1U PD=0.63U
* device instance $316 r0 *1 53.488,-119.635 nfet
M$316 GND|VGND RESET_B|RST_B \$326 GND|VGND nfet L=0.15U W=0.42U AS=0.0441P
+ AD=0.1346P PS=0.63U PD=1.15U
* device instance $317 r0 *1 55.668,-119.635 nfet
M$317 GND|VGND \$319 \$328 GND|VGND nfet L=0.15U W=0.42U AS=0.0669P AD=0.12495P
+ PS=0.75U PD=1.015U
* device instance $318 r0 *1 56.413,-119.635 nfet
M$318 \$329 RESET_B|RST_B GND|VGND GND|VGND nfet L=0.15U W=0.42U AS=0.12495P
+ AD=0.06405P PS=1.015U PD=0.725U
* device instance $319 r0 *1 56.868,-119.635 nfet
M$319 \$319 \$318 \$329 GND|VGND nfet L=0.15U W=0.42U AS=0.06405P AD=0.1092P
+ PS=0.725U PD=1.36U
* device instance $320 r0 *1 54.148,-119.525 nfet
M$320 \$317 \$315 GND|VGND GND|VGND nfet L=0.15U W=0.64U AS=0.1346P AD=0.0999P
+ PS=1.15U PD=0.985U
* device instance $321 r0 *1 57.908,-119.52 nfet
M$321 C|PH_EOC|Q \$319 GND|VGND GND|VGND nfet L=0.15U W=0.65U AS=0.2087P
+ AD=0.169P PS=2.02U PD=1.82U
* device instance $322 r0 *1 60.208,-115.2 nfet
M$322 A|A0|DOUT1|Q|SELp1 \$354 GND|VGND GND|VGND nfet L=0.15U W=0.65U
+ AS=0.2087P AD=0.169P PS=2.02U PD=1.82U
* device instance $323 r0 *1 91.583,-115.2 nfet
M$323 SELn4|Y A|A0|DOUT4|Q|SELp4 GND|VGND GND|VGND nfet L=0.15U W=0.65U
+ AS=0.169P AD=0.169P PS=1.82U PD=1.82U
* device instance $324 r0 *1 29.408,-115.085 nfet
M$324 GND|VGND CLK|X \$330 GND|VGND nfet L=0.15U W=0.42U AS=0.1092P AD=0.0567P
+ PS=1.36U PD=0.69U
* device instance $325 r0 *1 29.828,-115.085 nfet
M$325 \$331 \$330 GND|VGND GND|VGND nfet L=0.15U W=0.42U AS=0.0567P AD=0.1092P
+ PS=0.69U PD=1.36U
* device instance $326 r0 *1 31.103,-115.085 nfet
M$326 \$332 D|X$7 GND|VGND GND|VGND nfet L=0.15U W=0.42U AS=0.2205P AD=0.066P
+ PS=1.89U PD=0.745U
* device instance $327 r0 *1 31.578,-115.055 nfet
M$327 \$333 \$330 \$332 GND|VGND nfet L=0.15U W=0.36U AS=0.066P AD=0.0594P
+ PS=0.745U PD=0.69U
* device instance $328 r0 *1 32.058,-115.055 nfet
M$328 \$333 \$331 \$359 GND|VGND nfet L=0.15U W=0.36U AS=0.1401P AD=0.0594P
+ PS=1.1U PD=0.69U
* device instance $329 r0 *1 32.888,-115.085 nfet
M$329 \$360 \$335 \$359 GND|VGND nfet L=0.15U W=0.42U AS=0.1401P AD=0.0441P
+ PS=1.1U PD=0.63U
* device instance $330 r0 *1 33.248,-115.085 nfet
M$330 \$360 RESET_B|RST_B GND|VGND GND|VGND nfet L=0.15U W=0.42U AS=0.1346P
+ AD=0.0441P PS=1.15U PD=0.63U
* device instance $331 r0 *1 33.908,-115.195 nfet
M$331 \$335 \$333 GND|VGND GND|VGND nfet L=0.15U W=0.64U AS=0.1346P AD=0.0999P
+ PS=1.15U PD=0.985U
* device instance $332 r0 *1 34.403,-115.055 nfet
M$332 \$336 \$331 \$335 GND|VGND nfet L=0.15U W=0.36U AS=0.0999P AD=0.0711P
+ PS=0.985U PD=0.755U
* device instance $333 r0 *1 34.948,-115.055 nfet
M$333 \$336 \$330 \$361 GND|VGND nfet L=0.15U W=0.36U AS=0.0669P AD=0.0711P
+ PS=0.75U PD=0.755U
* device instance $334 r0 *1 35.428,-115.085 nfet
M$334 GND|VGND \$337 \$361 GND|VGND nfet L=0.15U W=0.42U AS=0.0669P AD=0.12495P
+ PS=0.75U PD=1.015U
* device instance $335 r0 *1 36.173,-115.085 nfet
M$335 \$362 RESET_B|RST_B GND|VGND GND|VGND nfet L=0.15U W=0.42U AS=0.12495P
+ AD=0.06405P PS=1.015U PD=0.725U
* device instance $336 r0 *1 36.628,-115.085 nfet
M$336 \$337 \$336 \$362 GND|VGND nfet L=0.15U W=0.42U AS=0.06405P AD=0.1092P
+ PS=0.725U PD=1.36U
* device instance $337 r0 *1 42.288,-115.085 nfet
M$337 GND|VGND CLK|X \$339 GND|VGND nfet L=0.15U W=0.42U AS=0.1092P AD=0.0567P
+ PS=1.36U PD=0.69U
* device instance $338 r0 *1 42.708,-115.085 nfet
M$338 \$340 \$339 GND|VGND GND|VGND nfet L=0.15U W=0.42U AS=0.0567P AD=0.1092P
+ PS=0.69U PD=1.36U
* device instance $339 r0 *1 43.983,-115.085 nfet
M$339 \$341 A|D|PH_B1|Q|S GND|VGND GND|VGND nfet L=0.15U W=0.42U AS=0.2205P
+ AD=0.066P PS=1.89U PD=0.745U
* device instance $340 r0 *1 44.458,-115.055 nfet
M$340 \$342 \$339 \$341 GND|VGND nfet L=0.15U W=0.36U AS=0.066P AD=0.0594P
+ PS=0.745U PD=0.69U
* device instance $341 r0 *1 44.938,-115.055 nfet
M$341 \$342 \$340 \$366 GND|VGND nfet L=0.15U W=0.36U AS=0.1401P AD=0.0594P
+ PS=1.1U PD=0.69U
* device instance $342 r0 *1 45.768,-115.085 nfet
M$342 \$365 \$344 \$366 GND|VGND nfet L=0.15U W=0.42U AS=0.1401P AD=0.0441P
+ PS=1.1U PD=0.63U
* device instance $343 r0 *1 46.128,-115.085 nfet
M$343 \$365 RESET_B|RST_B GND|VGND GND|VGND nfet L=0.15U W=0.42U AS=0.1346P
+ AD=0.0441P PS=1.15U PD=0.63U
* device instance $344 r0 *1 46.788,-115.195 nfet
M$344 \$344 \$342 GND|VGND GND|VGND nfet L=0.15U W=0.64U AS=0.1346P AD=0.0999P
+ PS=1.15U PD=0.985U
* device instance $345 r0 *1 47.283,-115.055 nfet
M$345 \$345 \$340 \$344 GND|VGND nfet L=0.15U W=0.36U AS=0.0999P AD=0.0711P
+ PS=0.985U PD=0.755U
* device instance $346 r0 *1 47.828,-115.055 nfet
M$346 \$345 \$339 \$367 GND|VGND nfet L=0.15U W=0.36U AS=0.0669P AD=0.0711P
+ PS=0.75U PD=0.755U
* device instance $347 r0 *1 48.308,-115.085 nfet
M$347 GND|VGND \$346 \$367 GND|VGND nfet L=0.15U W=0.42U AS=0.0669P AD=0.12495P
+ PS=0.75U PD=1.015U
* device instance $348 r0 *1 49.053,-115.085 nfet
M$348 \$368 RESET_B|RST_B GND|VGND GND|VGND nfet L=0.15U W=0.42U AS=0.12495P
+ AD=0.06405P PS=1.015U PD=0.725U
* device instance $349 r0 *1 49.508,-115.085 nfet
M$349 \$346 \$345 \$368 GND|VGND nfet L=0.15U W=0.42U AS=0.06405P AD=0.1092P
+ PS=0.725U PD=1.36U
* device instance $350 r0 *1 51.948,-115.085 nfet
M$350 GND|VGND CLK|X \$347 GND|VGND nfet L=0.15U W=0.42U AS=0.1092P AD=0.0567P
+ PS=1.36U PD=0.69U
* device instance $351 r0 *1 52.368,-115.085 nfet
M$351 \$348 \$347 GND|VGND GND|VGND nfet L=0.15U W=0.42U AS=0.0567P AD=0.1092P
+ PS=0.69U PD=1.36U
* device instance $352 r0 *1 53.643,-115.085 nfet
M$352 \$349 D|X$8 GND|VGND GND|VGND nfet L=0.15U W=0.42U AS=0.2205P AD=0.066P
+ PS=1.89U PD=0.745U
* device instance $353 r0 *1 54.118,-115.055 nfet
M$353 \$350 \$347 \$349 GND|VGND nfet L=0.15U W=0.36U AS=0.066P AD=0.0594P
+ PS=0.745U PD=0.69U
* device instance $354 r0 *1 54.598,-115.055 nfet
M$354 \$350 \$348 \$369 GND|VGND nfet L=0.15U W=0.36U AS=0.1401P AD=0.0594P
+ PS=1.1U PD=0.69U
* device instance $355 r0 *1 55.428,-115.085 nfet
M$355 \$370 \$352 \$369 GND|VGND nfet L=0.15U W=0.42U AS=0.1401P AD=0.0441P
+ PS=1.1U PD=0.63U
* device instance $356 r0 *1 55.788,-115.085 nfet
M$356 \$370 RESET_B|RST_B GND|VGND GND|VGND nfet L=0.15U W=0.42U AS=0.1346P
+ AD=0.0441P PS=1.15U PD=0.63U
* device instance $357 r0 *1 56.448,-115.195 nfet
M$357 \$352 \$350 GND|VGND GND|VGND nfet L=0.15U W=0.64U AS=0.1346P AD=0.0999P
+ PS=1.15U PD=0.985U
* device instance $358 r0 *1 56.943,-115.055 nfet
M$358 \$353 \$348 \$352 GND|VGND nfet L=0.15U W=0.36U AS=0.0999P AD=0.0711P
+ PS=0.985U PD=0.755U
* device instance $359 r0 *1 57.488,-115.055 nfet
M$359 \$353 \$347 \$364 GND|VGND nfet L=0.15U W=0.36U AS=0.0669P AD=0.0711P
+ PS=0.75U PD=0.755U
* device instance $360 r0 *1 57.968,-115.085 nfet
M$360 GND|VGND \$354 \$364 GND|VGND nfet L=0.15U W=0.42U AS=0.0669P AD=0.12495P
+ PS=0.75U PD=1.015U
* device instance $361 r0 *1 58.713,-115.085 nfet
M$361 \$363 RESET_B|RST_B GND|VGND GND|VGND nfet L=0.15U W=0.42U AS=0.12495P
+ AD=0.06405P PS=1.015U PD=0.725U
* device instance $362 r0 *1 59.168,-115.085 nfet
M$362 \$354 \$353 \$363 GND|VGND nfet L=0.15U W=0.42U AS=0.06405P AD=0.1092P
+ PS=0.725U PD=1.36U
* device instance $363 r0 *1 28.488,-114.195 nfet
M$363 GND|VGND CLK|X \$371 GND|VGND nfet L=0.15U W=0.42U AS=0.1092P AD=0.0567P
+ PS=1.36U PD=0.69U
* device instance $364 r0 *1 28.908,-114.195 nfet
M$364 \$372 \$371 GND|VGND GND|VGND nfet L=0.15U W=0.42U AS=0.0567P AD=0.1092P
+ PS=0.69U PD=1.36U
* device instance $365 r0 *1 30.658,-114.225 nfet
M$365 \$374 \$371 \$373 GND|VGND nfet L=0.15U W=0.36U AS=0.066P AD=0.0594P
+ PS=0.745U PD=0.69U
* device instance $366 r0 *1 31.138,-114.225 nfet
M$366 \$388 \$372 \$374 GND|VGND nfet L=0.15U W=0.36U AS=0.0594P AD=0.1401P
+ PS=0.69U PD=1.1U
* device instance $367 r0 *1 33.483,-114.225 nfet
M$367 \$377 \$372 \$376 GND|VGND nfet L=0.15U W=0.36U AS=0.0999P AD=0.0711P
+ PS=0.985U PD=0.755U
* device instance $368 r0 *1 34.028,-114.225 nfet
M$368 \$390 \$371 \$377 GND|VGND nfet L=0.15U W=0.36U AS=0.0711P AD=0.0669P
+ PS=0.755U PD=0.75U
* device instance $369 r0 *1 30.183,-114.195 nfet
M$369 \$373 C|D|PH_B3|Q|S GND|VGND GND|VGND nfet L=0.15U W=0.42U AS=0.2205P
+ AD=0.066P PS=1.89U PD=0.745U
* device instance $370 r0 *1 31.968,-114.195 nfet
M$370 \$389 \$376 \$388 GND|VGND nfet L=0.15U W=0.42U AS=0.1401P AD=0.0441P
+ PS=1.1U PD=0.63U
* device instance $371 r0 *1 32.328,-114.195 nfet
M$371 GND|VGND RESET_B|RST_B \$389 GND|VGND nfet L=0.15U W=0.42U AS=0.0441P
+ AD=0.1346P PS=0.63U PD=1.15U
* device instance $372 r0 *1 34.508,-114.195 nfet
M$372 GND|VGND \$378 \$390 GND|VGND nfet L=0.15U W=0.42U AS=0.0669P AD=0.12495P
+ PS=0.75U PD=1.015U
* device instance $373 r0 *1 35.253,-114.195 nfet
M$373 \$392 RESET_B|RST_B GND|VGND GND|VGND nfet L=0.15U W=0.42U AS=0.12495P
+ AD=0.06405P PS=1.015U PD=0.725U
* device instance $374 r0 *1 35.708,-114.195 nfet
M$374 \$378 \$377 \$392 GND|VGND nfet L=0.15U W=0.42U AS=0.06405P AD=0.1092P
+ PS=0.725U PD=1.36U
* device instance $375 r0 *1 32.988,-114.085 nfet
M$375 \$376 \$374 GND|VGND GND|VGND nfet L=0.15U W=0.64U AS=0.1346P AD=0.0999P
+ PS=1.15U PD=0.985U
* device instance $376 r0 *1 36.748,-114.08 nfet
M$376 D|PH_B2|Q|S \$378 GND|VGND GND|VGND nfet L=0.15U W=0.65U AS=0.2087P
+ AD=0.169P PS=2.02U PD=1.82U
* device instance $377 r0 *1 51.948,-114.195 nfet
M$377 GND|VGND CLK|X \$379 GND|VGND nfet L=0.15U W=0.42U AS=0.1092P AD=0.0567P
+ PS=1.36U PD=0.69U
* device instance $378 r0 *1 52.368,-114.195 nfet
M$378 \$380 \$379 GND|VGND GND|VGND nfet L=0.15U W=0.42U AS=0.0567P AD=0.1092P
+ PS=0.69U PD=1.36U
* device instance $379 r0 *1 54.118,-114.225 nfet
M$379 \$382 \$379 \$381 GND|VGND nfet L=0.15U W=0.36U AS=0.066P AD=0.0594P
+ PS=0.745U PD=0.69U
* device instance $380 r0 *1 54.598,-114.225 nfet
M$380 \$393 \$380 \$382 GND|VGND nfet L=0.15U W=0.36U AS=0.0594P AD=0.1401P
+ PS=0.69U PD=1.1U
* device instance $381 r0 *1 56.943,-114.225 nfet
M$381 \$385 \$380 \$384 GND|VGND nfet L=0.15U W=0.36U AS=0.0999P AD=0.0711P
+ PS=0.985U PD=0.755U
* device instance $382 r0 *1 57.488,-114.225 nfet
M$382 \$395 \$379 \$385 GND|VGND nfet L=0.15U W=0.36U AS=0.0711P AD=0.0669P
+ PS=0.755U PD=0.75U
* device instance $383 r0 *1 53.643,-114.195 nfet
M$383 \$381 D|X$9 GND|VGND GND|VGND nfet L=0.15U W=0.42U AS=0.2205P AD=0.066P
+ PS=1.89U PD=0.745U
* device instance $384 r0 *1 55.428,-114.195 nfet
M$384 \$394 \$384 \$393 GND|VGND nfet L=0.15U W=0.42U AS=0.1401P AD=0.0441P
+ PS=1.1U PD=0.63U
* device instance $385 r0 *1 55.788,-114.195 nfet
M$385 GND|VGND RESET_B|RST_B \$394 GND|VGND nfet L=0.15U W=0.42U AS=0.0441P
+ AD=0.1346P PS=0.63U PD=1.15U
* device instance $386 r0 *1 57.968,-114.195 nfet
M$386 GND|VGND \$386 \$395 GND|VGND nfet L=0.15U W=0.42U AS=0.0669P AD=0.12495P
+ PS=0.75U PD=1.015U
* device instance $387 r0 *1 58.713,-114.195 nfet
M$387 \$397 RESET_B|RST_B GND|VGND GND|VGND nfet L=0.15U W=0.42U AS=0.12495P
+ AD=0.06405P PS=1.015U PD=0.725U
* device instance $388 r0 *1 59.168,-114.195 nfet
M$388 \$386 \$385 \$397 GND|VGND nfet L=0.15U W=0.42U AS=0.06405P AD=0.1092P
+ PS=0.725U PD=1.36U
* device instance $389 r0 *1 56.448,-114.085 nfet
M$389 \$384 \$382 GND|VGND GND|VGND nfet L=0.15U W=0.64U AS=0.1346P AD=0.0999P
+ PS=1.15U PD=0.985U
* device instance $390 r0 *1 60.208,-114.08 nfet
M$390 A|A0|DOUT0|Q|SELp0 \$386 GND|VGND GND|VGND nfet L=0.15U W=0.65U
+ AS=0.2087P AD=0.169P PS=2.02U PD=1.82U
* device instance $391 r0 *1 91.583,-114.08 nfet
M$391 SELn6|Y A|A0|DOUT6|Q|SELp6 GND|VGND GND|VGND nfet L=0.15U W=0.65U
+ AS=0.169P AD=0.169P PS=1.82U PD=1.82U
* device instance $392 r0 *1 91.583,-109.76 nfet
M$392 SELn5|Y A|A0|DOUT5|Q|SELp5 GND|VGND GND|VGND nfet L=0.15U W=0.65U
+ AS=0.169P AD=0.169P PS=1.82U PD=1.82U
* device instance $393 r0 *1 91.583,-108.64 nfet
M$393 SELn8|Y A|A0|DOUT8|Q|SELp8 GND|VGND GND|VGND nfet L=0.15U W=0.65U
+ AS=0.169P AD=0.169P PS=1.82U PD=1.82U
* device instance $394 r0 *1 92.963,-108.64 nfet
M$394 SELn3|Y A|A0|DOUT3|Q|SELp3 GND|VGND GND|VGND nfet L=0.15U W=0.65U
+ AS=0.169P AD=0.169P PS=1.82U PD=1.82U
* device instance $395 r0 *1 91.583,-104.32 nfet
M$395 SELn2|Y A|A0|DOUT2|Q|SELp2 GND|VGND GND|VGND nfet L=0.15U W=0.65U
+ AS=0.169P AD=0.169P PS=1.82U PD=1.82U
* device instance $396 r0 *1 91.583,-103.2 nfet
M$396 SELn7|Y A|A0|DOUT7|Q|SELp7 GND|VGND GND|VGND nfet L=0.15U W=0.65U
+ AS=0.169P AD=0.169P PS=1.82U PD=1.82U
* device instance $397 r0 *1 91.583,-98.88 nfet
M$397 SELn0|Y A|A0|DOUT0|Q|SELp0 GND|VGND GND|VGND nfet L=0.15U W=0.65U
+ AS=0.169P AD=0.169P PS=1.82U PD=1.82U
* device instance $398 r0 *1 91.583,-97.76 nfet
M$398 SELn1|Y A|A0|DOUT1|Q|SELp1 GND|VGND GND|VGND nfet L=0.15U W=0.65U
+ AS=0.169P AD=0.169P PS=1.82U PD=1.82U
* device instance $399 r0 *1 4.545,-29.5 nfet
M$399 \$407 A|A0|DOUT0|Q|SELp0 VREFN GND|VGND nfet L=0.15U W=1U AS=0.47P
+ AD=0.47P PS=2.94U PD=2.94U
* device instance $400 r0 *1 15.545,-29.5 nfet
M$400 \$408 A|A0|DOUT1|Q|SELp1 VREFN GND|VGND nfet L=0.15U W=1U AS=0.47P
+ AD=0.47P PS=2.94U PD=2.94U
* device instance $401 r0 *1 26.545,-29.5 nfet
M$401 \$409 A|A0|DOUT2|Q|SELp2 VREFN GND|VGND nfet L=0.15U W=1U AS=0.47P
+ AD=0.47P PS=2.94U PD=2.94U
* device instance $402 r0 *1 37.545,-29.5 nfet
M$402 \$410 A|A0|DOUT3|Q|SELp3 VREFN GND|VGND nfet L=0.15U W=1U AS=0.47P
+ AD=0.47P PS=2.94U PD=2.94U
* device instance $403 r0 *1 48.545,-29.5 nfet
M$403 \$411 A|A0|DOUT4|Q|SELp4 VREFN GND|VGND nfet L=0.15U W=1U AS=0.47P
+ AD=0.47P PS=2.94U PD=2.94U
* device instance $404 r0 *1 59.545,-29.5 nfet
M$404 \$412 A|A0|DOUT5|Q|SELp5 VREFN GND|VGND nfet L=0.15U W=1U AS=0.47P
+ AD=0.47P PS=2.94U PD=2.94U
* device instance $405 r0 *1 70.545,-29.5 nfet
M$405 \$425 A|A0|DOUT6|Q|SELp6 VREFN GND|VGND nfet L=0.15U W=1U AS=0.47P
+ AD=0.47P PS=2.94U PD=2.94U
* device instance $406 r0 *1 81.545,-29.5 nfet
M$406 \$424 A|A0|DOUT7|Q|SELp7 VREFN GND|VGND nfet L=0.15U W=1U AS=0.47P
+ AD=0.47P PS=2.94U PD=2.94U
* device instance $407 r0 *1 92.545,-29.5 nfet
M$407 \$423 A|A0|DOUT8|Q|SELp8 VREFN GND|VGND nfet L=0.15U W=1U AS=0.47P
+ AD=0.47P PS=2.94U PD=2.94U
* device instance $408 r0 *1 103.545,-29.5 nfet
M$408 \$413 SELn0|Y VREFN GND|VGND nfet L=0.15U W=1U AS=0.47P AD=0.47P PS=2.94U
+ PD=2.94U
* device instance $409 r0 *1 114.545,-29.5 nfet
M$409 \$414 SELn1|Y VREFN GND|VGND nfet L=0.15U W=1U AS=0.47P AD=0.47P PS=2.94U
+ PD=2.94U
* device instance $410 r0 *1 125.545,-29.5 nfet
M$410 \$415 SELn2|Y VREFN GND|VGND nfet L=0.15U W=1U AS=0.47P AD=0.47P PS=2.94U
+ PD=2.94U
* device instance $411 r0 *1 136.545,-29.5 nfet
M$411 \$416 SELn3|Y VREFN GND|VGND nfet L=0.15U W=1U AS=0.47P AD=0.47P PS=2.94U
+ PD=2.94U
* device instance $412 r0 *1 147.545,-29.5 nfet
M$412 \$417 SELn4|Y VREFN GND|VGND nfet L=0.15U W=1U AS=0.47P AD=0.47P PS=2.94U
+ PD=2.94U
* device instance $413 r0 *1 158.545,-29.5 nfet
M$413 \$422 SELn5|Y VREFN GND|VGND nfet L=0.15U W=1U AS=0.47P AD=0.47P PS=2.94U
+ PD=2.94U
* device instance $414 r0 *1 169.545,-29.5 nfet
M$414 \$421 SELn6|Y VREFN GND|VGND nfet L=0.15U W=1U AS=0.47P AD=0.47P PS=2.94U
+ PD=2.94U
* device instance $415 r0 *1 180.545,-29.5 nfet
M$415 \$420 SELn7|Y VREFN GND|VGND nfet L=0.15U W=1U AS=0.47P AD=0.47P PS=2.94U
+ PD=2.94U
* device instance $416 r0 *1 191.545,-29.5 nfet
M$416 \$419 SELn8|Y VREFN GND|VGND nfet L=0.15U W=1U AS=0.47P AD=0.47P PS=2.94U
+ PD=2.94U
* device instance $417 r0 *1 102.87,193.8 nfet
M$417 \$441 A|CLK GND|VGND GND|VGND nfet L=0.5U W=8U AS=3.36P AD=3.36P
+ PS=16.84U PD=16.84U
* device instance $418 r0 *1 106.37,195.41 nfet
M$418 OUTN TOP_P|VINP \$441 GND|VGND nfet L=0.5U W=2U AS=0.84P AD=0.84P
+ PS=4.84U PD=4.84U
* device instance $419 r0 *1 106.37,192.19 nfet
M$419 A1|COMP_OUT|OUTP TOP_N|VINN \$441 GND|VGND nfet L=0.5U W=2U AS=0.84P
+ AD=0.84P PS=4.84U PD=4.84U
* device instance $420 r0 *1 106.84,89.25 nfet
M$420 VINP \$430 TOP_P|VINP GND|VGND nfet L=0.15U W=2U AS=0.94P AD=0.94P
+ PS=4.94U PD=4.94U
* device instance $421 r0 *1 108.11,192.19 nfet
M$421 OUTN TOP_P|VINP \$441 GND|VGND nfet L=0.5U W=2U AS=0.84P AD=0.84P
+ PS=4.84U PD=4.84U
* device instance $422 r0 *1 108.11,195.41 nfet
M$422 A1|COMP_OUT|OUTP TOP_N|VINN \$441 GND|VGND nfet L=0.5U W=2U AS=0.84P
+ AD=0.84P PS=4.84U PD=4.84U
* device instance $423 r0 *1 109.13,89.25 nfet
M$423 VINN \$438 TOP_N|VINN GND|VGND nfet L=0.15U W=2U AS=0.94P AD=0.94P
+ PS=4.94U PD=4.94U
* device instance $424 r0 *1 111.57,196.41 nfet
M$424 OUTN A1|COMP_OUT|OUTP GND|VGND GND|VGND nfet L=0.5U W=4U AS=1.68P
+ AD=1.68P PS=8.84U PD=8.84U
* device instance $425 r0 *1 111.57,191.19 nfet
M$425 A1|COMP_OUT|OUTP OUTN GND|VGND GND|VGND nfet L=0.5U W=4U AS=1.68P
+ AD=1.68P PS=8.84U PD=8.84U
* device instance $426 r0 *1 111.42,88.75 nfet
M$426 \$432 \$439 GND|VGND GND|VGND nfet L=0.15U W=1U AS=0.47P AD=0.47P
+ PS=2.94U PD=2.94U
* device instance $427 r0 *1 113.71,88.75 nfet
M$427 \$432 D|PH_SAMPLE|SAMPLE|Y VINP GND|VGND nfet L=0.15U W=1U AS=0.47P
+ AD=0.47P PS=2.94U PD=2.94U
* device instance $428 r0 *1 116.125,88.75 nfet
M$428 \$430 \$439 GND|VGND GND|VGND nfet L=0.5U W=1U AS=0.42P AD=0.42P PS=2.84U
+ PD=2.84U
* device instance $429 r0 *1 118.54,88.75 nfet
M$429 BPREF_P D|PH_SAMPLE|SAMPLE|Y VCM GND|VGND nfet L=0.15U W=1U AS=0.47P
+ AD=0.47P PS=2.94U PD=2.94U
* device instance $430 r0 *1 120.83,88.75 nfet
M$430 BPREF_N D|PH_SAMPLE|SAMPLE|Y VCM GND|VGND nfet L=0.15U W=1U AS=0.47P
+ AD=0.47P PS=2.94U PD=2.94U
* device instance $431 r0 *1 123.245,88.75 nfet
M$431 \$438 \$439 GND|VGND GND|VGND nfet L=0.5U W=1U AS=0.42P AD=0.42P PS=2.84U
+ PD=2.84U
* device instance $432 r0 *1 125.66,88.75 nfet
M$432 \$437 D|PH_SAMPLE|SAMPLE|Y VINN GND|VGND nfet L=0.15U W=1U AS=0.47P
+ AD=0.47P PS=2.94U PD=2.94U
* device instance $433 r0 *1 127.95,88.75 nfet
M$433 \$437 \$439 GND|VGND GND|VGND nfet L=0.15U W=1U AS=0.47P AD=0.47P
+ PS=2.94U PD=2.94U
* device instance $434 r0 *1 130.24,88.75 nfet
M$434 \$439 D|PH_SAMPLE|SAMPLE|Y GND|VGND GND|VGND nfet L=0.15U W=1U AS=0.47P
+ AD=0.47P PS=2.94U PD=2.94U
* device instance $435 r0 *1 60.208,-145.295 pfet
M$435 C|D|PH_B7|Q|S \$12 VPB|VPWR VPB|VPWR pfet L=0.15U W=1U AS=0.3012P
+ AD=0.26P PS=2.66U PD=2.52U
* device instance $436 r0 *1 56.828,-145.215 pfet
M$436 \$10 \$8 VPB|VPWR VPB|VPWR pfet L=0.15U W=0.84U AS=0.2184P AD=0.12915P
+ PS=2.2U PD=1.185U
* device instance $437 r0 *1 57.323,-145.005 pfet
M$437 \$11 \$4 \$10 VPB|VPWR pfet L=0.15U W=0.42U AS=0.12915P AD=0.0588P
+ PS=1.185U PD=0.7U
* device instance $438 r0 *1 57.753,-145.005 pfet
M$438 \$18 \$5 \$11 VPB|VPWR pfet L=0.15U W=0.42U AS=0.0588P AD=0.0567P PS=0.7U
+ PD=0.69U
* device instance $439 r0 *1 58.173,-145.005 pfet
M$439 VPB|VPWR \$12 \$18 VPB|VPWR pfet L=0.15U W=0.42U AS=0.0567P AD=0.0819P
+ PS=0.69U PD=0.81U
* device instance $440 r0 *1 58.713,-145.005 pfet
M$440 \$12 RESET_B|RST_B VPB|VPWR VPB|VPWR pfet L=0.15U W=0.42U AS=0.0819P
+ AD=0.0567P PS=0.81U PD=0.69U
* device instance $441 r0 *1 59.133,-145.005 pfet
M$441 VPB|VPWR \$11 \$12 VPB|VPWR pfet L=0.15U W=0.42U AS=0.0567P AD=0.1134P
+ PS=0.69U PD=1.38U
* device instance $442 r0 *1 51.948,-145.145 pfet
M$442 VPB|VPWR A|CLK|X \$4 VPB|VPWR pfet L=0.15U W=0.64U AS=0.1664P AD=0.0864P
+ PS=1.8U PD=0.91U
* device instance $443 r0 *1 52.368,-145.145 pfet
M$443 \$5 \$4 VPB|VPWR VPB|VPWR pfet L=0.15U W=0.64U AS=0.0864P AD=0.1664P
+ PS=0.91U PD=1.8U
* device instance $444 r0 *1 53.703,-145.005 pfet
M$444 \$7 B|D|PH_B8|Q|S VPB|VPWR VPB|VPWR pfet L=0.15U W=0.42U AS=0.1092P
+ AD=0.0651P PS=1.36U PD=0.73U
* device instance $445 r0 *1 54.163,-145.005 pfet
M$445 \$8 \$5 \$7 VPB|VPWR pfet L=0.15U W=0.42U AS=0.0651P AD=0.07245P PS=0.73U
+ PD=0.765U
* device instance $446 r0 *1 54.658,-145.005 pfet
M$446 \$9 \$4 \$8 VPB|VPWR pfet L=0.15U W=0.42U AS=0.07245P AD=0.1155P
+ PS=0.765U PD=0.97U
* device instance $447 r0 *1 55.358,-145.005 pfet
M$447 VPB|VPWR \$10 \$9 VPB|VPWR pfet L=0.15U W=0.42U AS=0.1155P AD=0.07035P
+ PS=0.97U PD=0.755U
* device instance $448 r0 *1 55.843,-145.005 pfet
M$448 \$9 RESET_B|RST_B VPB|VPWR VPB|VPWR pfet L=0.15U W=0.42U AS=0.07035P
+ AD=0.1092P PS=0.755U PD=1.36U
* device instance $449 r0 *1 37.143,-144.115 pfet
M$449 \$22 D|X VPB|VPWR VPB|VPWR pfet L=0.15U W=0.42U AS=0.1092P AD=0.0651P
+ PS=1.36U PD=0.73U
* device instance $450 r0 *1 37.603,-144.115 pfet
M$450 \$23 \$20 \$22 VPB|VPWR pfet L=0.15U W=0.42U AS=0.0651P AD=0.07245P
+ PS=0.73U PD=0.765U
* device instance $451 r0 *1 38.098,-144.115 pfet
M$451 \$24 \$19 \$23 VPB|VPWR pfet L=0.15U W=0.42U AS=0.07245P AD=0.1155P
+ PS=0.765U PD=0.97U
* device instance $452 r0 *1 38.798,-144.115 pfet
M$452 VPB|VPWR \$26 \$24 VPB|VPWR pfet L=0.15U W=0.42U AS=0.1155P AD=0.07035P
+ PS=0.97U PD=0.755U
* device instance $453 r0 *1 39.283,-144.115 pfet
M$453 \$24 RESET_B|RST_B VPB|VPWR VPB|VPWR pfet L=0.15U W=0.42U AS=0.07035P
+ AD=0.1092P PS=0.755U PD=1.36U
* device instance $454 r0 *1 40.763,-144.115 pfet
M$454 \$27 \$19 \$26 VPB|VPWR pfet L=0.15U W=0.42U AS=0.12915P AD=0.0588P
+ PS=1.185U PD=0.7U
* device instance $455 r0 *1 41.193,-144.115 pfet
M$455 \$43 \$20 \$27 VPB|VPWR pfet L=0.15U W=0.42U AS=0.0588P AD=0.0567P
+ PS=0.7U PD=0.69U
* device instance $456 r0 *1 41.613,-144.115 pfet
M$456 VPB|VPWR \$28 \$43 VPB|VPWR pfet L=0.15U W=0.42U AS=0.0567P AD=0.0819P
+ PS=0.69U PD=0.81U
* device instance $457 r0 *1 42.153,-144.115 pfet
M$457 \$28 RESET_B|RST_B VPB|VPWR VPB|VPWR pfet L=0.15U W=0.42U AS=0.0819P
+ AD=0.0567P PS=0.81U PD=0.69U
* device instance $458 r0 *1 42.573,-144.115 pfet
M$458 VPB|VPWR \$27 \$28 VPB|VPWR pfet L=0.15U W=0.42U AS=0.0567P AD=0.1134P
+ PS=0.69U PD=1.38U
* device instance $459 r0 *1 40.268,-143.905 pfet
M$459 \$26 \$23 VPB|VPWR VPB|VPWR pfet L=0.15U W=0.84U AS=0.2184P AD=0.12915P
+ PS=2.2U PD=1.185U
* device instance $460 r0 *1 43.648,-143.825 pfet
M$460 A|A0|DOUT6|Q|SELp6 \$28 VPB|VPWR VPB|VPWR pfet L=0.15U W=1U AS=0.3012P
+ AD=0.26P PS=2.66U PD=2.52U
* device instance $461 r0 *1 53.703,-144.115 pfet
M$461 \$33 D|X$1 VPB|VPWR VPB|VPWR pfet L=0.15U W=0.42U AS=0.1092P AD=0.0651P
+ PS=1.36U PD=0.73U
* device instance $462 r0 *1 54.163,-144.115 pfet
M$462 \$34 \$31 \$33 VPB|VPWR pfet L=0.15U W=0.42U AS=0.0651P AD=0.07245P
+ PS=0.73U PD=0.765U
* device instance $463 r0 *1 54.658,-144.115 pfet
M$463 \$35 \$30 \$34 VPB|VPWR pfet L=0.15U W=0.42U AS=0.07245P AD=0.1155P
+ PS=0.765U PD=0.97U
* device instance $464 r0 *1 55.358,-144.115 pfet
M$464 VPB|VPWR \$36 \$35 VPB|VPWR pfet L=0.15U W=0.42U AS=0.1155P AD=0.07035P
+ PS=0.97U PD=0.755U
* device instance $465 r0 *1 55.843,-144.115 pfet
M$465 \$35 RESET_B|RST_B VPB|VPWR VPB|VPWR pfet L=0.15U W=0.42U AS=0.07035P
+ AD=0.1092P PS=0.755U PD=1.36U
* device instance $466 r0 *1 57.323,-144.115 pfet
M$466 \$37 \$30 \$36 VPB|VPWR pfet L=0.15U W=0.42U AS=0.12915P AD=0.0588P
+ PS=1.185U PD=0.7U
* device instance $467 r0 *1 57.753,-144.115 pfet
M$467 \$47 \$31 \$37 VPB|VPWR pfet L=0.15U W=0.42U AS=0.0588P AD=0.0567P
+ PS=0.7U PD=0.69U
* device instance $468 r0 *1 58.173,-144.115 pfet
M$468 VPB|VPWR \$38 \$47 VPB|VPWR pfet L=0.15U W=0.42U AS=0.0567P AD=0.0819P
+ PS=0.69U PD=0.81U
* device instance $469 r0 *1 58.713,-144.115 pfet
M$469 \$38 RESET_B|RST_B VPB|VPWR VPB|VPWR pfet L=0.15U W=0.42U AS=0.0819P
+ AD=0.0567P PS=0.81U PD=0.69U
* device instance $470 r0 *1 59.133,-144.115 pfet
M$470 VPB|VPWR \$37 \$38 VPB|VPWR pfet L=0.15U W=0.42U AS=0.0567P AD=0.1134P
+ PS=0.69U PD=1.38U
* device instance $471 r0 *1 56.828,-143.905 pfet
M$471 \$36 \$34 VPB|VPWR VPB|VPWR pfet L=0.15U W=0.84U AS=0.2184P AD=0.12915P
+ PS=2.2U PD=1.185U
* device instance $472 r0 *1 60.208,-143.825 pfet
M$472 A|A0|DOUT8|Q|SELp8 \$38 VPB|VPWR VPB|VPWR pfet L=0.15U W=1U AS=0.3012P
+ AD=0.26P PS=2.66U PD=2.52U
* device instance $473 r0 *1 28.488,-139.705 pfet
M$473 VPB|VPWR A|CLK|X \$50 VPB|VPWR pfet L=0.15U W=0.64U AS=0.1664P AD=0.0864P
+ PS=1.8U PD=0.91U
* device instance $474 r0 *1 28.908,-139.705 pfet
M$474 \$51 \$50 VPB|VPWR VPB|VPWR pfet L=0.15U W=0.64U AS=0.0864P AD=0.1664P
+ PS=0.91U PD=1.8U
* device instance $475 r0 *1 30.243,-139.565 pfet
M$475 \$53 D|X$2 VPB|VPWR VPB|VPWR pfet L=0.15U W=0.42U AS=0.1092P AD=0.0651P
+ PS=1.36U PD=0.73U
* device instance $476 r0 *1 30.703,-139.565 pfet
M$476 \$54 \$51 \$53 VPB|VPWR pfet L=0.15U W=0.42U AS=0.0651P AD=0.07245P
+ PS=0.73U PD=0.765U
* device instance $477 r0 *1 31.198,-139.565 pfet
M$477 \$55 \$50 \$54 VPB|VPWR pfet L=0.15U W=0.42U AS=0.07245P AD=0.1155P
+ PS=0.765U PD=0.97U
* device instance $478 r0 *1 31.898,-139.565 pfet
M$478 VPB|VPWR \$56 \$55 VPB|VPWR pfet L=0.15U W=0.42U AS=0.1155P AD=0.07035P
+ PS=0.97U PD=0.755U
* device instance $479 r0 *1 32.383,-139.565 pfet
M$479 \$55 RESET_B|RST_B VPB|VPWR VPB|VPWR pfet L=0.15U W=0.42U AS=0.07035P
+ AD=0.1092P PS=0.755U PD=1.36U
* device instance $480 r0 *1 33.368,-139.775 pfet
M$480 \$56 \$54 VPB|VPWR VPB|VPWR pfet L=0.15U W=0.84U AS=0.2184P AD=0.12915P
+ PS=2.2U PD=1.185U
* device instance $481 r0 *1 33.863,-139.565 pfet
M$481 \$57 \$50 \$56 VPB|VPWR pfet L=0.15U W=0.42U AS=0.12915P AD=0.0588P
+ PS=1.185U PD=0.7U
* device instance $482 r0 *1 34.293,-139.565 pfet
M$482 \$73 \$51 \$57 VPB|VPWR pfet L=0.15U W=0.42U AS=0.0588P AD=0.0567P
+ PS=0.7U PD=0.69U
* device instance $483 r0 *1 34.713,-139.565 pfet
M$483 VPB|VPWR \$58 \$73 VPB|VPWR pfet L=0.15U W=0.42U AS=0.0567P AD=0.0819P
+ PS=0.69U PD=0.81U
* device instance $484 r0 *1 35.253,-139.565 pfet
M$484 \$58 RESET_B|RST_B VPB|VPWR VPB|VPWR pfet L=0.15U W=0.42U AS=0.0819P
+ AD=0.0567P PS=0.81U PD=0.69U
* device instance $485 r0 *1 35.673,-139.565 pfet
M$485 VPB|VPWR \$57 \$58 VPB|VPWR pfet L=0.15U W=0.42U AS=0.0567P AD=0.1134P
+ PS=0.69U PD=1.38U
* device instance $486 r0 *1 35.388,-143.975 pfet
M$486 VPB|VPWR A|CLK|X \$19 VPB|VPWR pfet L=0.15U W=0.64U AS=0.1664P AD=0.0864P
+ PS=1.8U PD=0.91U
* device instance $487 r0 *1 35.808,-143.975 pfet
M$487 \$20 \$19 VPB|VPWR VPB|VPWR pfet L=0.15U W=0.64U AS=0.0864P AD=0.1664P
+ PS=0.91U PD=1.8U
* device instance $488 r0 *1 36.748,-139.855 pfet
M$488 A|A0|DOUT5|Q|SELp5 \$58 VPB|VPWR VPB|VPWR pfet L=0.15U W=1U AS=0.3012P
+ AD=0.26P PS=2.66U PD=2.52U
* device instance $489 r0 *1 44.793,-139.855 pfet
M$489 Y A|CLK|X VPB|VPWR VPB|VPWR pfet L=0.15U W=1U AS=0.26P AD=0.26P PS=2.52U
+ PD=2.52U
* device instance $490 r0 *1 50.108,-139.705 pfet
M$490 VPB|VPWR A|CLK|X \$62 VPB|VPWR pfet L=0.15U W=0.64U AS=0.1664P AD=0.0864P
+ PS=1.8U PD=0.91U
* device instance $491 r0 *1 50.528,-139.705 pfet
M$491 \$63 \$62 VPB|VPWR VPB|VPWR pfet L=0.15U W=0.64U AS=0.0864P AD=0.1664P
+ PS=0.91U PD=1.8U
* device instance $492 r0 *1 51.863,-139.565 pfet
M$492 \$64 C|D|PH_B7|Q|S VPB|VPWR VPB|VPWR pfet L=0.15U W=0.42U AS=0.1092P
+ AD=0.0651P PS=1.36U PD=0.73U
* device instance $493 r0 *1 52.323,-139.565 pfet
M$493 \$65 \$63 \$64 VPB|VPWR pfet L=0.15U W=0.42U AS=0.0651P AD=0.07245P
+ PS=0.73U PD=0.765U
* device instance $494 r0 *1 52.818,-139.565 pfet
M$494 \$66 \$62 \$65 VPB|VPWR pfet L=0.15U W=0.42U AS=0.07245P AD=0.1155P
+ PS=0.765U PD=0.97U
* device instance $495 r0 *1 53.518,-139.565 pfet
M$495 VPB|VPWR \$67 \$66 VPB|VPWR pfet L=0.15U W=0.42U AS=0.1155P AD=0.07035P
+ PS=0.97U PD=0.755U
* device instance $496 r0 *1 54.003,-139.565 pfet
M$496 \$66 RESET_B|RST_B VPB|VPWR VPB|VPWR pfet L=0.15U W=0.42U AS=0.07035P
+ AD=0.1092P PS=0.755U PD=1.36U
* device instance $497 r0 *1 51.948,-143.975 pfet
M$497 VPB|VPWR A|CLK|X \$30 VPB|VPWR pfet L=0.15U W=0.64U AS=0.1664P AD=0.0864P
+ PS=1.8U PD=0.91U
* device instance $498 r0 *1 52.368,-143.975 pfet
M$498 \$31 \$30 VPB|VPWR VPB|VPWR pfet L=0.15U W=0.64U AS=0.0864P AD=0.1664P
+ PS=0.91U PD=1.8U
* device instance $499 r0 *1 54.988,-139.775 pfet
M$499 \$67 \$65 VPB|VPWR VPB|VPWR pfet L=0.15U W=0.84U AS=0.2184P AD=0.12915P
+ PS=2.2U PD=1.185U
* device instance $500 r0 *1 55.483,-139.565 pfet
M$500 \$68 \$62 \$67 VPB|VPWR pfet L=0.15U W=0.42U AS=0.12915P AD=0.0588P
+ PS=1.185U PD=0.7U
* device instance $501 r0 *1 55.913,-139.565 pfet
M$501 \$78 \$63 \$68 VPB|VPWR pfet L=0.15U W=0.42U AS=0.0588P AD=0.0567P
+ PS=0.7U PD=0.69U
* device instance $502 r0 *1 56.333,-139.565 pfet
M$502 VPB|VPWR \$69 \$78 VPB|VPWR pfet L=0.15U W=0.42U AS=0.0567P AD=0.0819P
+ PS=0.69U PD=0.81U
* device instance $503 r0 *1 56.873,-139.565 pfet
M$503 \$69 RESET_B|RST_B VPB|VPWR VPB|VPWR pfet L=0.15U W=0.42U AS=0.0819P
+ AD=0.0567P PS=0.81U PD=0.69U
* device instance $504 r0 *1 57.293,-139.565 pfet
M$504 VPB|VPWR \$68 \$69 VPB|VPWR pfet L=0.15U W=0.42U AS=0.0567P AD=0.1134P
+ PS=0.69U PD=1.38U
* device instance $505 r0 *1 58.368,-139.855 pfet
M$505 D|PH_B6|Q|S \$69 VPB|VPWR VPB|VPWR pfet L=0.15U W=1U AS=0.3012P AD=0.26P
+ PS=2.66U PD=2.52U
* device instance $506 r0 *1 33.173,-134.32 pfet
M$506 \$132 C|D|PH_B3|Q|S VPB|VPWR VPB|VPWR pfet L=0.15U W=0.42U AS=0.15835P
+ AD=0.07665P PS=1.395U PD=0.785U
* device instance $507 r0 *1 33.688,-134.32 pfet
M$507 \$111 A|A0|DOUT3|Q|SELp3 \$132 VPB|VPWR pfet L=0.15U W=0.42U AS=0.07665P
+ AD=0.1932P PS=0.785U PD=1.34U
* device instance $508 r0 *1 34.758,-134.32 pfet
M$508 \$134 A1|COMP_OUT|OUTP \$111 VPB|VPWR pfet L=0.15U W=0.42U AS=0.1932P
+ AD=0.0441P PS=1.34U PD=0.63U
* device instance $509 r0 *1 35.118,-134.32 pfet
M$509 VPB|VPWR \$114 \$134 VPB|VPWR pfet L=0.15U W=0.42U AS=0.0441P AD=0.0693P
+ PS=0.63U PD=0.75U
* device instance $510 r0 *1 35.598,-134.32 pfet
M$510 \$114 C|D|PH_B3|Q|S VPB|VPWR VPB|VPWR pfet L=0.15U W=0.42U AS=0.0693P
+ AD=0.1176P PS=0.75U PD=1.4U
* device instance $511 r0 *1 32.628,-134.415 pfet
M$511 VPB|VPWR \$111 D|X$4 VPB|VPWR pfet L=0.15U W=1U AS=0.26P AD=0.15835P
+ PS=2.52U PD=1.395U
* device instance $512 r0 *1 33.173,-138.48 pfet
M$512 \$95 A|D|PH_B5|Q|S VPB|VPWR VPB|VPWR pfet L=0.15U W=0.42U AS=0.15835P
+ AD=0.07665P PS=1.395U PD=0.785U
* device instance $513 r0 *1 33.688,-138.48 pfet
M$513 \$80 A|A0|DOUT5|Q|SELp5 \$95 VPB|VPWR pfet L=0.15U W=0.42U AS=0.07665P
+ AD=0.1932P PS=0.785U PD=1.34U
* device instance $514 r0 *1 34.758,-138.48 pfet
M$514 \$96 A1|COMP_OUT|OUTP \$80 VPB|VPWR pfet L=0.15U W=0.42U AS=0.1932P
+ AD=0.0441P PS=1.34U PD=0.63U
* device instance $515 r0 *1 35.118,-138.48 pfet
M$515 VPB|VPWR \$83 \$96 VPB|VPWR pfet L=0.15U W=0.42U AS=0.0441P AD=0.0693P
+ PS=0.63U PD=0.75U
* device instance $516 r0 *1 35.598,-138.48 pfet
M$516 \$83 A|D|PH_B5|Q|S VPB|VPWR VPB|VPWR pfet L=0.15U W=0.42U AS=0.0693P
+ AD=0.1176P PS=0.75U PD=1.4U
* device instance $517 r0 *1 32.628,-138.385 pfet
M$517 VPB|VPWR \$80 D|X$2 VPB|VPWR pfet L=0.15U W=1U AS=0.26P AD=0.15835P
+ PS=2.52U PD=1.395U
* device instance $518 r0 *1 39.613,-138.48 pfet
M$518 \$99 D|PH_B6|Q|S VPB|VPWR VPB|VPWR pfet L=0.15U W=0.42U AS=0.15835P
+ AD=0.07665P PS=1.395U PD=0.785U
* device instance $519 r0 *1 40.128,-138.48 pfet
M$519 \$84 A|A0|DOUT6|Q|SELp6 \$99 VPB|VPWR pfet L=0.15U W=0.42U AS=0.07665P
+ AD=0.1932P PS=0.785U PD=1.34U
* device instance $520 r0 *1 41.198,-138.48 pfet
M$520 \$100 A1|COMP_OUT|OUTP \$84 VPB|VPWR pfet L=0.15U W=0.42U AS=0.1932P
+ AD=0.0441P PS=1.34U PD=0.63U
* device instance $521 r0 *1 41.558,-138.48 pfet
M$521 VPB|VPWR \$86 \$100 VPB|VPWR pfet L=0.15U W=0.42U AS=0.0441P AD=0.0693P
+ PS=0.63U PD=0.75U
* device instance $522 r0 *1 42.038,-138.48 pfet
M$522 \$86 D|PH_B6|Q|S VPB|VPWR VPB|VPWR pfet L=0.15U W=0.42U AS=0.0693P
+ AD=0.1176P PS=0.75U PD=1.4U
* device instance $523 r0 *1 39.068,-138.385 pfet
M$523 VPB|VPWR \$84 D|X VPB|VPWR pfet L=0.15U W=1U AS=0.26P AD=0.15835P
+ PS=2.52U PD=1.395U
* device instance $524 r0 *1 44.588,-138.385 pfet
M$524 VPB|VPWR A|X$1 \$87 VPB|VPWR pfet L=0.15U W=1U AS=0.26P AD=0.135P
+ PS=2.52U PD=1.27U
* device instance $525 r0 *1 45.008,-138.385 pfet
M$525 A|CLK|X \$87 VPB|VPWR VPB|VPWR pfet L=0.15U W=1U AS=0.135P AD=0.135P
+ PS=1.27U PD=1.27U
* device instance $526 r0 *1 45.428,-138.385 pfet
M$526 VPB|VPWR \$87 A|CLK|X VPB|VPWR pfet L=0.15U W=1U AS=0.135P AD=0.135P
+ PS=1.27U PD=1.27U
* device instance $527 r0 *1 45.848,-138.385 pfet
M$527 A|CLK|X \$87 VPB|VPWR VPB|VPWR pfet L=0.15U W=1U AS=0.135P AD=0.135P
+ PS=1.27U PD=1.27U
* device instance $528 r0 *1 46.268,-138.385 pfet
M$528 VPB|VPWR \$87 A|CLK|X VPB|VPWR pfet L=0.15U W=1U AS=0.135P AD=0.26P
+ PS=1.27U PD=2.52U
* device instance $529 r0 *1 48.708,-134.415 pfet
M$529 A|D|PH_B5|Q|S \$122 VPB|VPWR VPB|VPWR pfet L=0.15U W=1U AS=0.3012P
+ AD=0.26P PS=2.66U PD=2.52U
* device instance $530 r0 *1 52.493,-138.48 pfet
M$530 \$102 C|D|PH_B7|Q|S VPB|VPWR VPB|VPWR pfet L=0.15U W=0.42U AS=0.15835P
+ AD=0.07665P PS=1.395U PD=0.785U
* device instance $531 r0 *1 53.008,-138.48 pfet
M$531 \$89 A|A0|DOUT7|Q|SELp7 \$102 VPB|VPWR pfet L=0.15U W=0.42U AS=0.07665P
+ AD=0.1932P PS=0.785U PD=1.34U
* device instance $532 r0 *1 54.078,-138.48 pfet
M$532 \$104 A1|COMP_OUT|OUTP \$89 VPB|VPWR pfet L=0.15U W=0.42U AS=0.1932P
+ AD=0.0441P PS=1.34U PD=0.63U
* device instance $533 r0 *1 54.438,-138.48 pfet
M$533 VPB|VPWR \$91 \$104 VPB|VPWR pfet L=0.15U W=0.42U AS=0.0441P AD=0.0693P
+ PS=0.63U PD=0.75U
* device instance $534 r0 *1 54.918,-138.48 pfet
M$534 \$91 C|D|PH_B7|Q|S VPB|VPWR VPB|VPWR pfet L=0.15U W=0.42U AS=0.0693P
+ AD=0.1176P PS=0.75U PD=1.4U
* device instance $535 r0 *1 51.948,-138.385 pfet
M$535 VPB|VPWR \$89 D|X$3 VPB|VPWR pfet L=0.15U W=1U AS=0.26P AD=0.15835P
+ PS=2.52U PD=1.395U
* device instance $536 r0 *1 56.633,-138.48 pfet
M$536 \$107 B|D|PH_B8|Q|S VPB|VPWR VPB|VPWR pfet L=0.15U W=0.42U AS=0.15835P
+ AD=0.07665P PS=1.395U PD=0.785U
* device instance $537 r0 *1 57.148,-138.48 pfet
M$537 \$92 A|A0|DOUT8|Q|SELp8 \$107 VPB|VPWR pfet L=0.15U W=0.42U AS=0.07665P
+ AD=0.1932P PS=0.785U PD=1.34U
* device instance $538 r0 *1 58.218,-138.48 pfet
M$538 \$109 A1|COMP_OUT|OUTP \$92 VPB|VPWR pfet L=0.15U W=0.42U AS=0.1932P
+ AD=0.0441P PS=1.34U PD=0.63U
* device instance $539 r0 *1 58.578,-138.48 pfet
M$539 VPB|VPWR \$93 \$109 VPB|VPWR pfet L=0.15U W=0.42U AS=0.0441P AD=0.0693P
+ PS=0.63U PD=0.75U
* device instance $540 r0 *1 59.058,-138.48 pfet
M$540 \$93 B|D|PH_B8|Q|S VPB|VPWR VPB|VPWR pfet L=0.15U W=0.42U AS=0.0693P
+ AD=0.1176P PS=0.75U PD=1.4U
* device instance $541 r0 *1 56.088,-138.385 pfet
M$541 VPB|VPWR \$92 D|X$1 VPB|VPWR pfet L=0.15U W=1U AS=0.26P AD=0.15835P
+ PS=2.52U PD=1.395U
* device instance $542 r0 *1 58.828,-134.415 pfet
M$542 B|D|PH_B8|Q|S \$131 VPB|VPWR VPB|VPWR pfet L=0.15U W=1U AS=0.3012P
+ AD=0.26P PS=2.66U PD=2.52U
* device instance $543 r0 *1 40.448,-134.265 pfet
M$543 VPB|VPWR A|CLK|X \$115 VPB|VPWR pfet L=0.15U W=0.64U AS=0.1664P
+ AD=0.0864P PS=1.8U PD=0.91U
* device instance $544 r0 *1 40.868,-134.265 pfet
M$544 \$116 \$115 VPB|VPWR VPB|VPWR pfet L=0.15U W=0.64U AS=0.0864P AD=0.1664P
+ PS=0.91U PD=1.8U
* device instance $545 r0 *1 45.328,-134.335 pfet
M$545 \$120 \$118 VPB|VPWR VPB|VPWR pfet L=0.15U W=0.84U AS=0.2184P AD=0.12915P
+ PS=2.2U PD=1.185U
* device instance $546 r0 *1 45.823,-134.125 pfet
M$546 \$121 \$115 \$120 VPB|VPWR pfet L=0.15U W=0.42U AS=0.12915P AD=0.0588P
+ PS=1.185U PD=0.7U
* device instance $547 r0 *1 46.253,-134.125 pfet
M$547 \$145 \$116 \$121 VPB|VPWR pfet L=0.15U W=0.42U AS=0.0588P AD=0.0567P
+ PS=0.7U PD=0.69U
* device instance $548 r0 *1 46.673,-134.125 pfet
M$548 VPB|VPWR \$122 \$145 VPB|VPWR pfet L=0.15U W=0.42U AS=0.0567P AD=0.0819P
+ PS=0.69U PD=0.81U
* device instance $549 r0 *1 47.213,-134.125 pfet
M$549 \$122 RESET_B|RST_B VPB|VPWR VPB|VPWR pfet L=0.15U W=0.42U AS=0.0819P
+ AD=0.0567P PS=0.81U PD=0.69U
* device instance $550 r0 *1 47.633,-134.125 pfet
M$550 VPB|VPWR \$121 \$122 VPB|VPWR pfet L=0.15U W=0.42U AS=0.0567P AD=0.1134P
+ PS=0.69U PD=1.38U
* device instance $551 r0 *1 50.568,-134.265 pfet
M$551 VPB|VPWR A|CLK|X \$124 VPB|VPWR pfet L=0.15U W=0.64U AS=0.1664P
+ AD=0.0864P PS=1.8U PD=0.91U
* device instance $552 r0 *1 50.988,-134.265 pfet
M$552 \$125 \$124 VPB|VPWR VPB|VPWR pfet L=0.15U W=0.64U AS=0.0864P AD=0.1664P
+ PS=0.91U PD=1.8U
* device instance $553 r0 *1 55.448,-134.335 pfet
M$553 \$129 \$127 VPB|VPWR VPB|VPWR pfet L=0.15U W=0.84U AS=0.2184P AD=0.12915P
+ PS=2.2U PD=1.185U
* device instance $554 r0 *1 55.943,-134.125 pfet
M$554 \$130 \$124 \$129 VPB|VPWR pfet L=0.15U W=0.42U AS=0.12915P AD=0.0588P
+ PS=1.185U PD=0.7U
* device instance $555 r0 *1 56.373,-134.125 pfet
M$555 \$144 \$125 \$130 VPB|VPWR pfet L=0.15U W=0.42U AS=0.0588P AD=0.0567P
+ PS=0.7U PD=0.69U
* device instance $556 r0 *1 56.793,-134.125 pfet
M$556 VPB|VPWR \$131 \$144 VPB|VPWR pfet L=0.15U W=0.42U AS=0.0567P AD=0.0819P
+ PS=0.69U PD=0.81U
* device instance $557 r0 *1 57.333,-134.125 pfet
M$557 \$131 RESET_B|RST_B VPB|VPWR VPB|VPWR pfet L=0.15U W=0.42U AS=0.0819P
+ AD=0.0567P PS=0.81U PD=0.69U
* device instance $558 r0 *1 57.753,-134.125 pfet
M$558 VPB|VPWR \$130 \$131 VPB|VPWR pfet L=0.15U W=0.42U AS=0.0567P AD=0.1134P
+ PS=0.69U PD=1.38U
* device instance $559 r0 *1 42.203,-134.125 pfet
M$559 \$117 D|PH_B6|Q|S VPB|VPWR VPB|VPWR pfet L=0.15U W=0.42U AS=0.1092P
+ AD=0.0651P PS=1.36U PD=0.73U
* device instance $560 r0 *1 42.663,-134.125 pfet
M$560 \$118 \$116 \$117 VPB|VPWR pfet L=0.15U W=0.42U AS=0.0651P AD=0.07245P
+ PS=0.73U PD=0.765U
* device instance $561 r0 *1 43.158,-134.125 pfet
M$561 \$119 \$115 \$118 VPB|VPWR pfet L=0.15U W=0.42U AS=0.07245P AD=0.1155P
+ PS=0.765U PD=0.97U
* device instance $562 r0 *1 43.858,-134.125 pfet
M$562 VPB|VPWR \$120 \$119 VPB|VPWR pfet L=0.15U W=0.42U AS=0.1155P AD=0.07035P
+ PS=0.97U PD=0.755U
* device instance $563 r0 *1 44.343,-134.125 pfet
M$563 \$119 RESET_B|RST_B VPB|VPWR VPB|VPWR pfet L=0.15U W=0.42U AS=0.07035P
+ AD=0.1092P PS=0.755U PD=1.36U
* device instance $564 r0 *1 52.323,-134.125 pfet
M$564 \$126 A|D|PH_B9|Q|S VPB|VPWR VPB|VPWR pfet L=0.15U W=0.42U AS=0.1092P
+ AD=0.0651P PS=1.36U PD=0.73U
* device instance $565 r0 *1 52.783,-134.125 pfet
M$565 \$127 \$125 \$126 VPB|VPWR pfet L=0.15U W=0.42U AS=0.0651P AD=0.07245P
+ PS=0.73U PD=0.765U
* device instance $566 r0 *1 53.278,-134.125 pfet
M$566 \$128 \$124 \$127 VPB|VPWR pfet L=0.15U W=0.42U AS=0.07245P AD=0.1155P
+ PS=0.765U PD=0.97U
* device instance $567 r0 *1 53.978,-134.125 pfet
M$567 VPB|VPWR \$129 \$128 VPB|VPWR pfet L=0.15U W=0.42U AS=0.1155P AD=0.07035P
+ PS=0.97U PD=0.755U
* device instance $568 r0 *1 54.463,-134.125 pfet
M$568 \$128 RESET_B|RST_B VPB|VPWR VPB|VPWR pfet L=0.15U W=0.42U AS=0.07035P
+ AD=0.1092P PS=0.755U PD=1.36U
* device instance $569 r0 *1 29.868,-133.095 pfet
M$569 VPB|VPWR A|CLK|X \$146 VPB|VPWR pfet L=0.15U W=0.64U AS=0.1664P
+ AD=0.0864P PS=1.8U PD=0.91U
* device instance $570 r0 *1 30.288,-133.095 pfet
M$570 \$147 \$146 VPB|VPWR VPB|VPWR pfet L=0.15U W=0.64U AS=0.0864P AD=0.1664P
+ PS=0.91U PD=1.8U
* device instance $571 r0 *1 31.623,-133.235 pfet
M$571 \$149 D|X$5 VPB|VPWR VPB|VPWR pfet L=0.15U W=0.42U AS=0.1092P AD=0.0651P
+ PS=1.36U PD=0.73U
* device instance $572 r0 *1 32.083,-133.235 pfet
M$572 \$150 \$147 \$149 VPB|VPWR pfet L=0.15U W=0.42U AS=0.0651P AD=0.07245P
+ PS=0.73U PD=0.765U
* device instance $573 r0 *1 32.578,-133.235 pfet
M$573 \$151 \$146 \$150 VPB|VPWR pfet L=0.15U W=0.42U AS=0.07245P AD=0.1155P
+ PS=0.765U PD=0.97U
* device instance $574 r0 *1 33.278,-133.235 pfet
M$574 VPB|VPWR \$152 \$151 VPB|VPWR pfet L=0.15U W=0.42U AS=0.1155P AD=0.07035P
+ PS=0.97U PD=0.755U
* device instance $575 r0 *1 33.763,-133.235 pfet
M$575 \$151 RESET_B|RST_B VPB|VPWR VPB|VPWR pfet L=0.15U W=0.42U AS=0.07035P
+ AD=0.1092P PS=0.755U PD=1.36U
* device instance $576 r0 *1 34.093,-128.88 pfet
M$576 \$194 D|PH_B2|Q|S VPB|VPWR VPB|VPWR pfet L=0.15U W=0.42U AS=0.15835P
+ AD=0.07665P PS=1.395U PD=0.785U
* device instance $577 r0 *1 34.608,-128.88 pfet
M$577 \$179 A|A0|DOUT2|Q|SELp2 \$194 VPB|VPWR pfet L=0.15U W=0.42U AS=0.07665P
+ AD=0.1932P PS=0.785U PD=1.34U
* device instance $578 r0 *1 35.678,-128.88 pfet
M$578 \$195 A1|COMP_OUT|OUTP \$179 VPB|VPWR pfet L=0.15U W=0.42U AS=0.1932P
+ AD=0.0441P PS=1.34U PD=0.63U
* device instance $579 r0 *1 36.038,-128.88 pfet
M$579 VPB|VPWR \$181 \$195 VPB|VPWR pfet L=0.15U W=0.42U AS=0.0441P AD=0.0693P
+ PS=0.63U PD=0.75U
* device instance $580 r0 *1 36.518,-128.88 pfet
M$580 \$181 D|PH_B2|Q|S VPB|VPWR VPB|VPWR pfet L=0.15U W=0.42U AS=0.0693P
+ AD=0.1176P PS=0.75U PD=1.4U
* device instance $581 r0 *1 33.548,-128.975 pfet
M$581 VPB|VPWR \$179 D|X$5 VPB|VPWR pfet L=0.15U W=1U AS=0.26P AD=0.15835P
+ PS=2.52U PD=1.395U
* device instance $582 r0 *1 35.243,-133.235 pfet
M$582 \$153 \$146 \$152 VPB|VPWR pfet L=0.15U W=0.42U AS=0.12915P AD=0.0588P
+ PS=1.185U PD=0.7U
* device instance $583 r0 *1 35.673,-133.235 pfet
M$583 \$169 \$147 \$153 VPB|VPWR pfet L=0.15U W=0.42U AS=0.0588P AD=0.0567P
+ PS=0.7U PD=0.69U
* device instance $584 r0 *1 36.093,-133.235 pfet
M$584 VPB|VPWR \$155 \$169 VPB|VPWR pfet L=0.15U W=0.42U AS=0.0567P AD=0.0819P
+ PS=0.69U PD=0.81U
* device instance $585 r0 *1 36.633,-133.235 pfet
M$585 \$155 RESET_B|RST_B VPB|VPWR VPB|VPWR pfet L=0.15U W=0.42U AS=0.0819P
+ AD=0.0567P PS=0.81U PD=0.69U
* device instance $586 r0 *1 37.053,-133.235 pfet
M$586 VPB|VPWR \$153 \$155 VPB|VPWR pfet L=0.15U W=0.42U AS=0.0567P AD=0.1134P
+ PS=0.69U PD=1.38U
* device instance $587 r0 *1 34.748,-133.025 pfet
M$587 \$152 \$150 VPB|VPWR VPB|VPWR pfet L=0.15U W=0.84U AS=0.2184P AD=0.12915P
+ PS=2.2U PD=1.185U
* device instance $588 r0 *1 38.128,-132.945 pfet
M$588 A|A0|DOUT2|Q|SELp2 \$155 VPB|VPWR VPB|VPWR pfet L=0.15U W=1U AS=0.3012P
+ AD=0.26P PS=2.66U PD=2.52U
* device instance $589 r0 *1 40.448,-128.975 pfet
M$589 VPB|VPWR A|CLK \$183 VPB|VPWR pfet L=0.15U W=1U AS=0.26P AD=0.135P
+ PS=2.52U PD=1.27U
* device instance $590 r0 *1 40.868,-128.975 pfet
M$590 A|X$1 \$183 VPB|VPWR VPB|VPWR pfet L=0.15U W=1U AS=0.135P AD=0.135P
+ PS=1.27U PD=1.27U
* device instance $591 r0 *1 41.288,-128.975 pfet
M$591 VPB|VPWR \$183 A|X$1 VPB|VPWR pfet L=0.15U W=1U AS=0.135P AD=0.135P
+ PS=1.27U PD=1.27U
* device instance $592 r0 *1 41.708,-128.975 pfet
M$592 A|X$1 \$183 VPB|VPWR VPB|VPWR pfet L=0.15U W=1U AS=0.135P AD=0.135P
+ PS=1.27U PD=1.27U
* device instance $593 r0 *1 42.128,-128.975 pfet
M$593 VPB|VPWR \$183 A|X$1 VPB|VPWR pfet L=0.15U W=1U AS=0.135P AD=0.26P
+ PS=1.27U PD=2.52U
* device instance $594 r0 *1 48.728,-132.655 pfet
M$594 \$171 D|PH_B6|Q|S \$156 VPB|VPWR pfet L=0.15U W=0.42U AS=0.1092P
+ AD=0.0693P PS=1.36U PD=0.75U
* device instance $595 r0 *1 49.208,-132.655 pfet
M$595 \$172 C|D|PH_B7|Q|S \$171 VPB|VPWR pfet L=0.15U W=0.42U AS=0.0693P
+ AD=0.0441P PS=0.75U PD=0.63U
* device instance $596 r0 *1 49.568,-132.655 pfet
M$596 \$173 B|D|PH_B8|Q|S \$172 VPB|VPWR pfet L=0.15U W=0.42U AS=0.0441P
+ AD=0.0693P PS=0.63U PD=0.75U
* device instance $597 r0 *1 50.048,-132.655 pfet
M$597 \$173 A|D|PH_B9|Q|S VPB|VPWR VPB|VPWR pfet L=0.15U W=0.42U AS=0.14825P
+ AD=0.0693P PS=1.34U PD=0.75U
* device instance $598 r0 *1 50.538,-132.945 pfet
M$598 A|X \$156 VPB|VPWR VPB|VPWR pfet L=0.15U W=1U AS=0.14825P AD=0.27P
+ PS=1.34U PD=2.54U
* device instance $599 r0 *1 51.948,-133.095 pfet
M$599 VPB|VPWR A|CLK|X \$158 VPB|VPWR pfet L=0.15U W=0.64U AS=0.1664P
+ AD=0.0864P PS=1.8U PD=0.91U
* device instance $600 r0 *1 52.368,-133.095 pfet
M$600 \$159 \$158 VPB|VPWR VPB|VPWR pfet L=0.15U W=0.64U AS=0.0864P AD=0.1664P
+ PS=0.91U PD=1.8U
* device instance $601 r0 *1 53.703,-133.235 pfet
M$601 \$160 D|PH_SAMPLE|SAMPLE|Y VPB|VPWR VPB|VPWR pfet L=0.15U W=0.42U
+ AS=0.1092P AD=0.0651P PS=1.36U PD=0.73U
* device instance $602 r0 *1 54.163,-133.235 pfet
M$602 \$161 \$159 \$160 VPB|VPWR pfet L=0.15U W=0.42U AS=0.0651P AD=0.07245P
+ PS=0.73U PD=0.765U
* device instance $603 r0 *1 54.658,-133.235 pfet
M$603 \$162 \$158 \$161 VPB|VPWR pfet L=0.15U W=0.42U AS=0.07245P AD=0.1155P
+ PS=0.765U PD=0.97U
* device instance $604 r0 *1 55.358,-133.235 pfet
M$604 VPB|VPWR \$163 \$162 VPB|VPWR pfet L=0.15U W=0.42U AS=0.1155P AD=0.07035P
+ PS=0.97U PD=0.755U
* device instance $605 r0 *1 55.843,-133.235 pfet
M$605 \$162 RESET_B|RST_B VPB|VPWR VPB|VPWR pfet L=0.15U W=0.42U AS=0.07035P
+ AD=0.1092P PS=0.755U PD=1.36U
* device instance $606 r0 *1 57.323,-133.235 pfet
M$606 \$164 \$158 \$163 VPB|VPWR pfet L=0.15U W=0.42U AS=0.12915P AD=0.0588P
+ PS=1.185U PD=0.7U
* device instance $607 r0 *1 57.753,-133.235 pfet
M$607 \$176 \$159 \$164 VPB|VPWR pfet L=0.15U W=0.42U AS=0.0588P AD=0.0567P
+ PS=0.7U PD=0.69U
* device instance $608 r0 *1 58.173,-133.235 pfet
M$608 VPB|VPWR \$165 \$176 VPB|VPWR pfet L=0.15U W=0.42U AS=0.0567P AD=0.0819P
+ PS=0.69U PD=0.81U
* device instance $609 r0 *1 58.713,-133.235 pfet
M$609 \$165 RESET_B|RST_B VPB|VPWR VPB|VPWR pfet L=0.15U W=0.42U AS=0.0819P
+ AD=0.0567P PS=0.81U PD=0.69U
* device instance $610 r0 *1 59.133,-133.235 pfet
M$610 VPB|VPWR \$164 \$165 VPB|VPWR pfet L=0.15U W=0.42U AS=0.0567P AD=0.1134P
+ PS=0.69U PD=1.38U
* device instance $611 r0 *1 56.828,-133.025 pfet
M$611 \$163 \$161 VPB|VPWR VPB|VPWR pfet L=0.15U W=0.84U AS=0.2184P AD=0.12915P
+ PS=2.2U PD=1.185U
* device instance $612 r0 *1 57.448,-128.975 pfet
M$612 A|A0|DOUT7|Q|SELp7 \$192 VPB|VPWR VPB|VPWR pfet L=0.15U W=1U AS=0.3012P
+ AD=0.26P PS=2.66U PD=2.52U
* device instance $613 r0 *1 60.208,-132.945 pfet
M$613 A|D|PH_B9|Q|S \$165 VPB|VPWR VPB|VPWR pfet L=0.15U W=1U AS=0.3012P
+ AD=0.26P PS=2.66U PD=2.52U
* device instance $614 r0 *1 49.188,-128.825 pfet
M$614 VPB|VPWR A|CLK|X \$185 VPB|VPWR pfet L=0.15U W=0.64U AS=0.1664P
+ AD=0.0864P PS=1.8U PD=0.91U
* device instance $615 r0 *1 49.608,-128.825 pfet
M$615 \$186 \$185 VPB|VPWR VPB|VPWR pfet L=0.15U W=0.64U AS=0.0864P AD=0.1664P
+ PS=0.91U PD=1.8U
* device instance $616 r0 *1 54.068,-128.895 pfet
M$616 \$190 \$188 VPB|VPWR VPB|VPWR pfet L=0.15U W=0.84U AS=0.2184P AD=0.12915P
+ PS=2.2U PD=1.185U
* device instance $617 r0 *1 54.563,-128.685 pfet
M$617 \$191 \$185 \$190 VPB|VPWR pfet L=0.15U W=0.42U AS=0.12915P AD=0.0588P
+ PS=1.185U PD=0.7U
* device instance $618 r0 *1 54.993,-128.685 pfet
M$618 \$199 \$186 \$191 VPB|VPWR pfet L=0.15U W=0.42U AS=0.0588P AD=0.0567P
+ PS=0.7U PD=0.69U
* device instance $619 r0 *1 55.413,-128.685 pfet
M$619 VPB|VPWR \$192 \$199 VPB|VPWR pfet L=0.15U W=0.42U AS=0.0567P AD=0.0819P
+ PS=0.69U PD=0.81U
* device instance $620 r0 *1 55.953,-128.685 pfet
M$620 \$192 RESET_B|RST_B VPB|VPWR VPB|VPWR pfet L=0.15U W=0.42U AS=0.0819P
+ AD=0.0567P PS=0.81U PD=0.69U
* device instance $621 r0 *1 56.373,-128.685 pfet
M$621 VPB|VPWR \$191 \$192 VPB|VPWR pfet L=0.15U W=0.42U AS=0.0567P AD=0.1134P
+ PS=0.69U PD=1.38U
* device instance $622 r0 *1 31.623,-127.795 pfet
M$622 \$205 A|D|PH_B5|Q|S VPB|VPWR VPB|VPWR pfet L=0.15U W=0.42U AS=0.1092P
+ AD=0.0651P PS=1.36U PD=0.73U
* device instance $623 r0 *1 32.083,-127.795 pfet
M$623 \$206 \$204 \$205 VPB|VPWR pfet L=0.15U W=0.42U AS=0.0651P AD=0.07245P
+ PS=0.73U PD=0.765U
* device instance $624 r0 *1 32.578,-127.795 pfet
M$624 \$207 \$203 \$206 VPB|VPWR pfet L=0.15U W=0.42U AS=0.07245P AD=0.1155P
+ PS=0.765U PD=0.97U
* device instance $625 r0 *1 33.278,-127.795 pfet
M$625 VPB|VPWR \$208 \$207 VPB|VPWR pfet L=0.15U W=0.42U AS=0.1155P AD=0.07035P
+ PS=0.97U PD=0.755U
* device instance $626 r0 *1 33.763,-127.795 pfet
M$626 \$207 RESET_B|RST_B VPB|VPWR VPB|VPWR pfet L=0.15U W=0.42U AS=0.07035P
+ AD=0.1092P PS=0.755U PD=1.36U
* device instance $627 r0 *1 35.243,-127.795 pfet
M$627 \$210 \$203 \$208 VPB|VPWR pfet L=0.15U W=0.42U AS=0.12915P AD=0.0588P
+ PS=1.185U PD=0.7U
* device instance $628 r0 *1 35.673,-127.795 pfet
M$628 \$221 \$204 \$210 VPB|VPWR pfet L=0.15U W=0.42U AS=0.0588P AD=0.0567P
+ PS=0.7U PD=0.69U
* device instance $629 r0 *1 36.093,-127.795 pfet
M$629 VPB|VPWR \$211 \$221 VPB|VPWR pfet L=0.15U W=0.42U AS=0.0567P AD=0.0819P
+ PS=0.69U PD=0.81U
* device instance $630 r0 *1 36.633,-127.795 pfet
M$630 \$211 RESET_B|RST_B VPB|VPWR VPB|VPWR pfet L=0.15U W=0.42U AS=0.0819P
+ AD=0.0567P PS=0.81U PD=0.69U
* device instance $631 r0 *1 37.053,-127.795 pfet
M$631 VPB|VPWR \$210 \$211 VPB|VPWR pfet L=0.15U W=0.42U AS=0.0567P AD=0.1134P
+ PS=0.69U PD=1.38U
* device instance $632 r0 *1 34.748,-127.585 pfet
M$632 \$208 \$206 VPB|VPWR VPB|VPWR pfet L=0.15U W=0.84U AS=0.2184P AD=0.12915P
+ PS=2.2U PD=1.185U
* device instance $633 r0 *1 38.128,-127.505 pfet
M$633 B|D|PH_B4|Q|S \$211 VPB|VPWR VPB|VPWR pfet L=0.15U W=1U AS=0.3012P
+ AD=0.26P PS=2.66U PD=2.52U
* device instance $634 r0 *1 50.943,-128.685 pfet
M$634 \$187 D|X$3 VPB|VPWR VPB|VPWR pfet L=0.15U W=0.42U AS=0.1092P AD=0.0651P
+ PS=1.36U PD=0.73U
* device instance $635 r0 *1 51.403,-128.685 pfet
M$635 \$188 \$186 \$187 VPB|VPWR pfet L=0.15U W=0.42U AS=0.0651P AD=0.07245P
+ PS=0.73U PD=0.765U
* device instance $636 r0 *1 51.898,-128.685 pfet
M$636 \$189 \$185 \$188 VPB|VPWR pfet L=0.15U W=0.42U AS=0.07245P AD=0.1155P
+ PS=0.765U PD=0.97U
* device instance $637 r0 *1 52.598,-128.685 pfet
M$637 VPB|VPWR \$190 \$189 VPB|VPWR pfet L=0.15U W=0.42U AS=0.1155P AD=0.07035P
+ PS=0.97U PD=0.755U
* device instance $638 r0 *1 53.083,-128.685 pfet
M$638 \$189 RESET_B|RST_B VPB|VPWR VPB|VPWR pfet L=0.15U W=0.42U AS=0.07035P
+ AD=0.1092P PS=0.755U PD=1.36U
* device instance $639 r0 *1 52.613,-127.505 pfet
M$639 D|PH_SAMPLE|SAMPLE|Y A|BUSY|X VPB|VPWR VPB|VPWR pfet L=0.15U W=1U
+ AS=0.26P AD=0.26P PS=2.52U PD=2.52U
* device instance $640 r0 *1 56.633,-127.6 pfet
M$640 \$227 A|D|PH_B9|Q|S VPB|VPWR VPB|VPWR pfet L=0.15U W=0.42U AS=0.15835P
+ AD=0.07665P PS=1.395U PD=0.785U
* device instance $641 r0 *1 57.148,-127.6 pfet
M$641 \$218 A0|DOUT9|Q \$227 VPB|VPWR pfet L=0.15U W=0.42U AS=0.07665P
+ AD=0.1932P PS=0.785U PD=1.34U
* device instance $642 r0 *1 58.218,-127.6 pfet
M$642 \$228 A1|COMP_OUT|OUTP \$218 VPB|VPWR pfet L=0.15U W=0.42U AS=0.1932P
+ AD=0.0441P PS=1.34U PD=0.63U
* device instance $643 r0 *1 58.578,-127.6 pfet
M$643 VPB|VPWR \$220 \$228 VPB|VPWR pfet L=0.15U W=0.42U AS=0.0441P AD=0.0693P
+ PS=0.63U PD=0.75U
* device instance $644 r0 *1 59.058,-127.6 pfet
M$644 \$220 A|D|PH_B9|Q|S VPB|VPWR VPB|VPWR pfet L=0.15U W=0.42U AS=0.0693P
+ AD=0.1176P PS=0.75U PD=1.4U
* device instance $645 r0 *1 56.088,-127.505 pfet
M$645 VPB|VPWR \$218 D|X$6 VPB|VPWR pfet L=0.15U W=1U AS=0.26P AD=0.15835P
+ PS=2.52U PD=1.395U
* device instance $646 r0 *1 29.868,-127.655 pfet
M$646 VPB|VPWR CLK|X \$203 VPB|VPWR pfet L=0.15U W=0.64U AS=0.1664P AD=0.0864P
+ PS=1.8U PD=0.91U
* device instance $647 r0 *1 30.288,-127.655 pfet
M$647 \$204 \$203 VPB|VPWR VPB|VPWR pfet L=0.15U W=0.64U AS=0.0864P AD=0.1664P
+ PS=0.91U PD=1.8U
* device instance $648 r0 *1 33.368,-123.455 pfet
M$648 \$240 \$238 VPB|VPWR VPB|VPWR pfet L=0.15U W=0.84U AS=0.2184P AD=0.12915P
+ PS=2.2U PD=1.185U
* device instance $649 r0 *1 33.863,-123.245 pfet
M$649 \$241 \$235 \$240 VPB|VPWR pfet L=0.15U W=0.42U AS=0.12915P AD=0.0588P
+ PS=1.185U PD=0.7U
* device instance $650 r0 *1 34.293,-123.245 pfet
M$650 \$254 \$236 \$241 VPB|VPWR pfet L=0.15U W=0.42U AS=0.0588P AD=0.0567P
+ PS=0.7U PD=0.69U
* device instance $651 r0 *1 34.713,-123.245 pfet
M$651 VPB|VPWR \$242 \$254 VPB|VPWR pfet L=0.15U W=0.42U AS=0.0567P AD=0.0819P
+ PS=0.69U PD=0.81U
* device instance $652 r0 *1 35.253,-123.245 pfet
M$652 \$242 RESET_B|RST_B VPB|VPWR VPB|VPWR pfet L=0.15U W=0.42U AS=0.0819P
+ AD=0.0567P PS=0.81U PD=0.69U
* device instance $653 r0 *1 35.673,-123.245 pfet
M$653 VPB|VPWR \$241 \$242 VPB|VPWR pfet L=0.15U W=0.42U AS=0.0567P AD=0.1134P
+ PS=0.69U PD=1.38U
* device instance $654 r0 *1 36.748,-123.535 pfet
M$654 C|D|PH_B3|Q|S \$242 VPB|VPWR VPB|VPWR pfet L=0.15U W=1U AS=0.3012P
+ AD=0.26P PS=2.66U PD=2.52U
* device instance $655 r0 *1 48.728,-127.215 pfet
M$655 \$223 D|PH_B2|Q|S \$212 VPB|VPWR pfet L=0.15U W=0.42U AS=0.1092P
+ AD=0.0693P PS=1.36U PD=0.75U
* device instance $656 r0 *1 49.208,-127.215 pfet
M$656 \$222 C|D|PH_B3|Q|S \$223 VPB|VPWR pfet L=0.15U W=0.42U AS=0.0693P
+ AD=0.0441P PS=0.75U PD=0.63U
* device instance $657 r0 *1 49.568,-127.215 pfet
M$657 \$224 B|D|PH_B4|Q|S \$222 VPB|VPWR pfet L=0.15U W=0.42U AS=0.0441P
+ AD=0.0693P PS=0.63U PD=0.75U
* device instance $658 r0 *1 50.048,-127.215 pfet
M$658 \$224 A|D|PH_B5|Q|S VPB|VPWR VPB|VPWR pfet L=0.15U W=0.42U AS=0.14825P
+ AD=0.0693P PS=1.34U PD=0.75U
* device instance $659 r0 *1 50.538,-127.505 pfet
M$659 B|X \$212 VPB|VPWR VPB|VPWR pfet L=0.15U W=1U AS=0.14825P AD=0.27P
+ PS=1.34U PD=2.54U
* device instance $660 r0 *1 53.798,-127.215 pfet
M$660 \$225 C|X \$216 VPB|VPWR pfet L=0.15U W=0.42U AS=0.1092P AD=0.0441P
+ PS=1.36U PD=0.63U
* device instance $661 r0 *1 54.158,-127.215 pfet
M$661 \$226 B|X \$225 VPB|VPWR pfet L=0.15U W=0.42U AS=0.0441P AD=0.0693P
+ PS=0.63U PD=0.75U
* device instance $662 r0 *1 54.638,-127.215 pfet
M$662 \$226 A|X VPB|VPWR VPB|VPWR pfet L=0.15U W=0.42U AS=0.14825P AD=0.0693P
+ PS=1.34U PD=0.75U
* device instance $663 r0 *1 55.128,-127.505 pfet
M$663 A|BUSY|X \$216 VPB|VPWR VPB|VPWR pfet L=0.15U W=1U AS=0.14825P AD=0.28P
+ PS=1.34U PD=2.56U
* device instance $664 r0 *1 54.068,-123.455 pfet
M$664 \$248 \$246 VPB|VPWR VPB|VPWR pfet L=0.15U W=0.84U AS=0.2184P AD=0.12915P
+ PS=2.2U PD=1.185U
* device instance $665 r0 *1 54.563,-123.245 pfet
M$665 \$249 \$243 \$248 VPB|VPWR pfet L=0.15U W=0.42U AS=0.12915P AD=0.0588P
+ PS=1.185U PD=0.7U
* device instance $666 r0 *1 54.993,-123.245 pfet
M$666 \$258 \$244 \$249 VPB|VPWR pfet L=0.15U W=0.42U AS=0.0588P AD=0.0567P
+ PS=0.7U PD=0.69U
* device instance $667 r0 *1 55.413,-123.245 pfet
M$667 VPB|VPWR \$250 \$258 VPB|VPWR pfet L=0.15U W=0.42U AS=0.0567P AD=0.0819P
+ PS=0.69U PD=0.81U
* device instance $668 r0 *1 55.953,-123.245 pfet
M$668 \$250 RESET_B|RST_B VPB|VPWR VPB|VPWR pfet L=0.15U W=0.42U AS=0.0819P
+ AD=0.0567P PS=0.81U PD=0.69U
* device instance $669 r0 *1 56.373,-123.245 pfet
M$669 VPB|VPWR \$249 \$250 VPB|VPWR pfet L=0.15U W=0.42U AS=0.0567P AD=0.1134P
+ PS=0.69U PD=1.38U
* device instance $670 r0 *1 57.448,-123.535 pfet
M$670 A0|DOUT9|Q \$250 VPB|VPWR VPB|VPWR pfet L=0.15U W=1U AS=0.3012P AD=0.26P
+ PS=2.66U PD=2.52U
* device instance $671 r0 *1 28.488,-123.385 pfet
M$671 VPB|VPWR CLK|X \$235 VPB|VPWR pfet L=0.15U W=0.64U AS=0.1664P AD=0.0864P
+ PS=1.8U PD=0.91U
* device instance $672 r0 *1 28.908,-123.385 pfet
M$672 \$236 \$235 VPB|VPWR VPB|VPWR pfet L=0.15U W=0.64U AS=0.0864P AD=0.1664P
+ PS=0.91U PD=1.8U
* device instance $673 r0 *1 30.243,-123.245 pfet
M$673 \$237 B|D|PH_B4|Q|S VPB|VPWR VPB|VPWR pfet L=0.15U W=0.42U AS=0.1092P
+ AD=0.0651P PS=1.36U PD=0.73U
* device instance $674 r0 *1 30.703,-123.245 pfet
M$674 \$238 \$236 \$237 VPB|VPWR pfet L=0.15U W=0.42U AS=0.0651P AD=0.07245P
+ PS=0.73U PD=0.765U
* device instance $675 r0 *1 31.198,-123.245 pfet
M$675 \$239 \$235 \$238 VPB|VPWR pfet L=0.15U W=0.42U AS=0.07245P AD=0.1155P
+ PS=0.765U PD=0.97U
* device instance $676 r0 *1 31.898,-123.245 pfet
M$676 VPB|VPWR \$240 \$239 VPB|VPWR pfet L=0.15U W=0.42U AS=0.1155P AD=0.07035P
+ PS=0.97U PD=0.755U
* device instance $677 r0 *1 32.383,-123.245 pfet
M$677 \$239 RESET_B|RST_B VPB|VPWR VPB|VPWR pfet L=0.15U W=0.42U AS=0.07035P
+ AD=0.1092P PS=0.755U PD=1.36U
* device instance $678 r0 *1 49.188,-123.385 pfet
M$678 VPB|VPWR CLK|X \$243 VPB|VPWR pfet L=0.15U W=0.64U AS=0.1664P AD=0.0864P
+ PS=1.8U PD=0.91U
* device instance $679 r0 *1 49.608,-123.385 pfet
M$679 \$244 \$243 VPB|VPWR VPB|VPWR pfet L=0.15U W=0.64U AS=0.0864P AD=0.1664P
+ PS=0.91U PD=1.8U
* device instance $680 r0 *1 50.943,-123.245 pfet
M$680 \$245 D|X$6 VPB|VPWR VPB|VPWR pfet L=0.15U W=0.42U AS=0.1092P AD=0.0651P
+ PS=1.36U PD=0.73U
* device instance $681 r0 *1 51.403,-123.245 pfet
M$681 \$246 \$244 \$245 VPB|VPWR pfet L=0.15U W=0.42U AS=0.0651P AD=0.07245P
+ PS=0.73U PD=0.765U
* device instance $682 r0 *1 51.898,-123.245 pfet
M$682 \$247 \$243 \$246 VPB|VPWR pfet L=0.15U W=0.42U AS=0.07245P AD=0.1155P
+ PS=0.765U PD=0.97U
* device instance $683 r0 *1 52.598,-123.245 pfet
M$683 VPB|VPWR \$248 \$247 VPB|VPWR pfet L=0.15U W=0.42U AS=0.1155P AD=0.07035P
+ PS=0.97U PD=0.755U
* device instance $684 r0 *1 53.083,-123.245 pfet
M$684 \$247 RESET_B|RST_B VPB|VPWR VPB|VPWR pfet L=0.15U W=0.42U AS=0.07035P
+ AD=0.1092P PS=0.755U PD=1.36U
* device instance $685 r0 *1 32.713,-122.16 pfet
M$685 \$285 B|D|PH_B4|Q|S VPB|VPWR VPB|VPWR pfet L=0.15U W=0.42U AS=0.15835P
+ AD=0.07665P PS=1.395U PD=0.785U
* device instance $686 r0 *1 33.228,-122.16 pfet
M$686 \$262 A|A0|DOUT4|Q|SELp4 \$285 VPB|VPWR pfet L=0.15U W=0.42U AS=0.07665P
+ AD=0.1932P PS=0.785U PD=1.34U
* device instance $687 r0 *1 34.298,-122.16 pfet
M$687 \$286 A1|COMP_OUT|OUTP \$262 VPB|VPWR pfet L=0.15U W=0.42U AS=0.1932P
+ AD=0.0441P PS=1.34U PD=0.63U
* device instance $688 r0 *1 34.658,-122.16 pfet
M$688 VPB|VPWR \$264 \$286 VPB|VPWR pfet L=0.15U W=0.42U AS=0.0441P AD=0.0693P
+ PS=0.63U PD=0.75U
* device instance $689 r0 *1 35.138,-122.16 pfet
M$689 \$264 B|D|PH_B4|Q|S VPB|VPWR VPB|VPWR pfet L=0.15U W=0.42U AS=0.0693P
+ AD=0.1176P PS=0.75U PD=1.4U
* device instance $690 r0 *1 32.168,-122.065 pfet
M$690 VPB|VPWR \$262 D|X$7 VPB|VPWR pfet L=0.15U W=1U AS=0.26P AD=0.15835P
+ PS=2.52U PD=1.395U
* device instance $691 r0 *1 36.308,-122.215 pfet
M$691 VPB|VPWR CLK|X \$265 VPB|VPWR pfet L=0.15U W=0.64U AS=0.1664P AD=0.0864P
+ PS=1.8U PD=0.91U
* device instance $692 r0 *1 36.728,-122.215 pfet
M$692 \$266 \$265 VPB|VPWR VPB|VPWR pfet L=0.15U W=0.64U AS=0.0864P AD=0.1664P
+ PS=0.91U PD=1.8U
* device instance $693 r0 *1 38.063,-122.355 pfet
M$693 \$267 D|PH_B2|Q|S VPB|VPWR VPB|VPWR pfet L=0.15U W=0.42U AS=0.1092P
+ AD=0.0651P PS=1.36U PD=0.73U
* device instance $694 r0 *1 38.523,-122.355 pfet
M$694 \$268 \$266 \$267 VPB|VPWR pfet L=0.15U W=0.42U AS=0.0651P AD=0.07245P
+ PS=0.73U PD=0.765U
* device instance $695 r0 *1 39.018,-122.355 pfet
M$695 \$269 \$265 \$268 VPB|VPWR pfet L=0.15U W=0.42U AS=0.07245P AD=0.1155P
+ PS=0.765U PD=0.97U
* device instance $696 r0 *1 39.718,-122.355 pfet
M$696 VPB|VPWR \$270 \$269 VPB|VPWR pfet L=0.15U W=0.42U AS=0.1155P AD=0.07035P
+ PS=0.97U PD=0.755U
* device instance $697 r0 *1 40.203,-122.355 pfet
M$697 \$269 RESET_B|RST_B VPB|VPWR VPB|VPWR pfet L=0.15U W=0.42U AS=0.07035P
+ AD=0.1092P PS=0.755U PD=1.36U
* device instance $698 r0 *1 41.683,-122.355 pfet
M$698 \$271 \$265 \$270 VPB|VPWR pfet L=0.15U W=0.42U AS=0.12915P AD=0.0588P
+ PS=1.185U PD=0.7U
* device instance $699 r0 *1 42.113,-122.355 pfet
M$699 \$287 \$266 \$271 VPB|VPWR pfet L=0.15U W=0.42U AS=0.0588P AD=0.0567P
+ PS=0.7U PD=0.69U
* device instance $700 r0 *1 42.533,-122.355 pfet
M$700 VPB|VPWR \$272 \$287 VPB|VPWR pfet L=0.15U W=0.42U AS=0.0567P AD=0.0819P
+ PS=0.69U PD=0.81U
* device instance $701 r0 *1 43.073,-122.355 pfet
M$701 \$272 RESET_B|RST_B VPB|VPWR VPB|VPWR pfet L=0.15U W=0.42U AS=0.0819P
+ AD=0.0567P PS=0.81U PD=0.69U
* device instance $702 r0 *1 43.493,-122.355 pfet
M$702 VPB|VPWR \$271 \$272 VPB|VPWR pfet L=0.15U W=0.42U AS=0.0567P AD=0.1134P
+ PS=0.69U PD=1.38U
* device instance $703 r0 *1 41.188,-122.145 pfet
M$703 \$270 \$268 VPB|VPWR VPB|VPWR pfet L=0.15U W=0.84U AS=0.2184P AD=0.12915P
+ PS=2.2U PD=1.185U
* device instance $704 r0 *1 44.568,-122.065 pfet
M$704 A|D|PH_B1|Q|S \$272 VPB|VPWR VPB|VPWR pfet L=0.15U W=1U AS=0.3012P
+ AD=0.26P PS=2.66U PD=2.52U
* device instance $705 r0 *1 47.893,-122.16 pfet
M$705 \$288 A|D|PH_B1|Q|S VPB|VPWR VPB|VPWR pfet L=0.15U W=0.42U AS=0.15835P
+ AD=0.07665P PS=1.395U PD=0.785U
* device instance $706 r0 *1 48.408,-122.16 pfet
M$706 \$274 A|A0|DOUT1|Q|SELp1 \$288 VPB|VPWR pfet L=0.15U W=0.42U AS=0.07665P
+ AD=0.1932P PS=0.785U PD=1.34U
* device instance $707 r0 *1 49.478,-122.16 pfet
M$707 \$289 A1|COMP_OUT|OUTP \$274 VPB|VPWR pfet L=0.15U W=0.42U AS=0.1932P
+ AD=0.0441P PS=1.34U PD=0.63U
* device instance $708 r0 *1 49.838,-122.16 pfet
M$708 VPB|VPWR \$277 \$289 VPB|VPWR pfet L=0.15U W=0.42U AS=0.0441P AD=0.0693P
+ PS=0.63U PD=0.75U
* device instance $709 r0 *1 50.318,-122.16 pfet
M$709 \$277 A|D|PH_B1|Q|S VPB|VPWR VPB|VPWR pfet L=0.15U W=0.42U AS=0.0693P
+ AD=0.1176P PS=0.75U PD=1.4U
* device instance $710 r0 *1 47.348,-122.065 pfet
M$710 VPB|VPWR \$274 D|X$8 VPB|VPWR pfet L=0.15U W=1U AS=0.26P AD=0.15835P
+ PS=2.52U PD=1.395U
* device instance $711 r0 *1 52.953,-122.16 pfet
M$711 \$290 B|D|PH_B0|Q|S VPB|VPWR VPB|VPWR pfet L=0.15U W=0.42U AS=0.15835P
+ AD=0.07665P PS=1.395U PD=0.785U
* device instance $712 r0 *1 53.468,-122.16 pfet
M$712 \$279 A|A0|DOUT0|Q|SELp0 \$290 VPB|VPWR pfet L=0.15U W=0.42U AS=0.07665P
+ AD=0.1932P PS=0.785U PD=1.34U
* device instance $713 r0 *1 54.538,-122.16 pfet
M$713 \$291 A1|COMP_OUT|OUTP \$279 VPB|VPWR pfet L=0.15U W=0.42U AS=0.1932P
+ AD=0.0441P PS=1.34U PD=0.63U
* device instance $714 r0 *1 54.898,-122.16 pfet
M$714 VPB|VPWR \$282 \$291 VPB|VPWR pfet L=0.15U W=0.42U AS=0.0441P AD=0.0693P
+ PS=0.63U PD=0.75U
* device instance $715 r0 *1 55.378,-122.16 pfet
M$715 \$282 B|D|PH_B0|Q|S VPB|VPWR VPB|VPWR pfet L=0.15U W=0.42U AS=0.0693P
+ AD=0.1176P PS=0.75U PD=1.4U
* device instance $716 r0 *1 52.408,-122.065 pfet
M$716 VPB|VPWR \$279 D|X$9 VPB|VPWR pfet L=0.15U W=1U AS=0.26P AD=0.15835P
+ PS=2.52U PD=1.395U
* device instance $717 r0 *1 28.488,-117.945 pfet
M$717 VPB|VPWR CLK|X \$304 VPB|VPWR pfet L=0.15U W=0.64U AS=0.1664P AD=0.0864P
+ PS=1.8U PD=0.91U
* device instance $718 r0 *1 28.908,-117.945 pfet
M$718 \$305 \$304 VPB|VPWR VPB|VPWR pfet L=0.15U W=0.64U AS=0.0864P AD=0.1664P
+ PS=0.91U PD=1.8U
* device instance $719 r0 *1 30.243,-117.805 pfet
M$719 \$306 D|X$4 VPB|VPWR VPB|VPWR pfet L=0.15U W=0.42U AS=0.1092P AD=0.0651P
+ PS=1.36U PD=0.73U
* device instance $720 r0 *1 30.703,-117.805 pfet
M$720 \$307 \$305 \$306 VPB|VPWR pfet L=0.15U W=0.42U AS=0.0651P AD=0.07245P
+ PS=0.73U PD=0.765U
* device instance $721 r0 *1 31.198,-117.805 pfet
M$721 \$308 \$304 \$307 VPB|VPWR pfet L=0.15U W=0.42U AS=0.07245P AD=0.1155P
+ PS=0.765U PD=0.97U
* device instance $722 r0 *1 31.898,-117.805 pfet
M$722 VPB|VPWR \$309 \$308 VPB|VPWR pfet L=0.15U W=0.42U AS=0.1155P AD=0.07035P
+ PS=0.97U PD=0.755U
* device instance $723 r0 *1 32.383,-117.805 pfet
M$723 \$308 RESET_B|RST_B VPB|VPWR VPB|VPWR pfet L=0.15U W=0.42U AS=0.07035P
+ AD=0.1092P PS=0.755U PD=1.36U
* device instance $724 r0 *1 31.163,-116.915 pfet
M$724 \$332 D|X$7 VPB|VPWR VPB|VPWR pfet L=0.15U W=0.42U AS=0.1092P AD=0.0651P
+ PS=1.36U PD=0.73U
* device instance $725 r0 *1 31.623,-116.915 pfet
M$725 \$333 \$331 \$332 VPB|VPWR pfet L=0.15U W=0.42U AS=0.0651P AD=0.07245P
+ PS=0.73U PD=0.765U
* device instance $726 r0 *1 32.118,-116.915 pfet
M$726 \$334 \$330 \$333 VPB|VPWR pfet L=0.15U W=0.42U AS=0.07245P AD=0.1155P
+ PS=0.765U PD=0.97U
* device instance $727 r0 *1 32.818,-116.915 pfet
M$727 VPB|VPWR \$335 \$334 VPB|VPWR pfet L=0.15U W=0.42U AS=0.1155P AD=0.07035P
+ PS=0.97U PD=0.755U
* device instance $728 r0 *1 33.303,-116.915 pfet
M$728 \$334 RESET_B|RST_B VPB|VPWR VPB|VPWR pfet L=0.15U W=0.42U AS=0.07035P
+ AD=0.1092P PS=0.755U PD=1.36U
* device instance $729 r0 *1 33.368,-118.015 pfet
M$729 \$309 \$307 VPB|VPWR VPB|VPWR pfet L=0.15U W=0.84U AS=0.2184P AD=0.12915P
+ PS=2.2U PD=1.185U
* device instance $730 r0 *1 33.863,-117.805 pfet
M$730 \$310 \$304 \$309 VPB|VPWR pfet L=0.15U W=0.42U AS=0.12915P AD=0.0588P
+ PS=1.185U PD=0.7U
* device instance $731 r0 *1 34.293,-117.805 pfet
M$731 \$322 \$305 \$310 VPB|VPWR pfet L=0.15U W=0.42U AS=0.0588P AD=0.0567P
+ PS=0.7U PD=0.69U
* device instance $732 r0 *1 34.713,-117.805 pfet
M$732 VPB|VPWR \$311 \$322 VPB|VPWR pfet L=0.15U W=0.42U AS=0.0567P AD=0.0819P
+ PS=0.69U PD=0.81U
* device instance $733 r0 *1 35.253,-117.805 pfet
M$733 \$311 RESET_B|RST_B VPB|VPWR VPB|VPWR pfet L=0.15U W=0.42U AS=0.0819P
+ AD=0.0567P PS=0.81U PD=0.69U
* device instance $734 r0 *1 35.673,-117.805 pfet
M$734 VPB|VPWR \$310 \$311 VPB|VPWR pfet L=0.15U W=0.42U AS=0.0567P AD=0.1134P
+ PS=0.69U PD=1.38U
* device instance $735 r0 *1 34.783,-116.915 pfet
M$735 \$336 \$330 \$335 VPB|VPWR pfet L=0.15U W=0.42U AS=0.12915P AD=0.0588P
+ PS=1.185U PD=0.7U
* device instance $736 r0 *1 35.213,-116.915 pfet
M$736 \$356 \$331 \$336 VPB|VPWR pfet L=0.15U W=0.42U AS=0.0588P AD=0.0567P
+ PS=0.7U PD=0.69U
* device instance $737 r0 *1 35.633,-116.915 pfet
M$737 VPB|VPWR \$337 \$356 VPB|VPWR pfet L=0.15U W=0.42U AS=0.0567P AD=0.0819P
+ PS=0.69U PD=0.81U
* device instance $738 r0 *1 36.173,-116.915 pfet
M$738 \$337 RESET_B|RST_B VPB|VPWR VPB|VPWR pfet L=0.15U W=0.42U AS=0.0819P
+ AD=0.0567P PS=0.81U PD=0.69U
* device instance $739 r0 *1 36.593,-116.915 pfet
M$739 VPB|VPWR \$336 \$337 VPB|VPWR pfet L=0.15U W=0.42U AS=0.0567P AD=0.1134P
+ PS=0.69U PD=1.38U
* device instance $740 r0 *1 34.288,-116.705 pfet
M$740 \$335 \$333 VPB|VPWR VPB|VPWR pfet L=0.15U W=0.84U AS=0.2184P AD=0.12915P
+ PS=2.2U PD=1.185U
* device instance $741 r0 *1 36.748,-118.095 pfet
M$741 A|A0|DOUT3|Q|SELp3 \$311 VPB|VPWR VPB|VPWR pfet L=0.15U W=1U AS=0.3012P
+ AD=0.26P PS=2.66U PD=2.52U
* device instance $742 r0 *1 37.668,-116.625 pfet
M$742 A|A0|DOUT4|Q|SELp4 \$337 VPB|VPWR VPB|VPWR pfet L=0.15U W=1U AS=0.3012P
+ AD=0.26P PS=2.66U PD=2.52U
* device instance $743 r0 *1 38.608,-116.625 pfet
M$743 VPB|VPWR A|X$1 \$338 VPB|VPWR pfet L=0.15U W=1U AS=0.26P AD=0.135P
+ PS=2.52U PD=1.27U
* device instance $744 r0 *1 39.028,-116.625 pfet
M$744 CLK|X \$338 VPB|VPWR VPB|VPWR pfet L=0.15U W=1U AS=0.135P AD=0.135P
+ PS=1.27U PD=1.27U
* device instance $745 r0 *1 39.448,-116.625 pfet
M$745 VPB|VPWR \$338 CLK|X VPB|VPWR pfet L=0.15U W=1U AS=0.135P AD=0.135P
+ PS=1.27U PD=1.27U
* device instance $746 r0 *1 39.868,-116.625 pfet
M$746 CLK|X \$338 VPB|VPWR VPB|VPWR pfet L=0.15U W=1U AS=0.135P AD=0.135P
+ PS=1.27U PD=1.27U
* device instance $747 r0 *1 40.288,-116.625 pfet
M$747 VPB|VPWR \$338 CLK|X VPB|VPWR pfet L=0.15U W=1U AS=0.135P AD=0.26P
+ PS=1.27U PD=2.52U
* device instance $748 r0 *1 44.043,-116.915 pfet
M$748 \$341 A|D|PH_B1|Q|S VPB|VPWR VPB|VPWR pfet L=0.15U W=0.42U AS=0.1092P
+ AD=0.0651P PS=1.36U PD=0.73U
* device instance $749 r0 *1 44.503,-116.915 pfet
M$749 \$342 \$340 \$341 VPB|VPWR pfet L=0.15U W=0.42U AS=0.0651P AD=0.07245P
+ PS=0.73U PD=0.765U
* device instance $750 r0 *1 44.998,-116.915 pfet
M$750 \$343 \$339 \$342 VPB|VPWR pfet L=0.15U W=0.42U AS=0.07245P AD=0.1155P
+ PS=0.765U PD=0.97U
* device instance $751 r0 *1 45.698,-116.915 pfet
M$751 VPB|VPWR \$344 \$343 VPB|VPWR pfet L=0.15U W=0.42U AS=0.1155P AD=0.07035P
+ PS=0.97U PD=0.755U
* device instance $752 r0 *1 46.183,-116.915 pfet
M$752 \$343 RESET_B|RST_B VPB|VPWR VPB|VPWR pfet L=0.15U W=0.42U AS=0.07035P
+ AD=0.1092P PS=0.755U PD=1.36U
* device instance $753 r0 *1 47.663,-116.915 pfet
M$753 \$345 \$339 \$344 VPB|VPWR pfet L=0.15U W=0.42U AS=0.12915P AD=0.0588P
+ PS=1.185U PD=0.7U
* device instance $754 r0 *1 48.093,-116.915 pfet
M$754 \$357 \$340 \$345 VPB|VPWR pfet L=0.15U W=0.42U AS=0.0588P AD=0.0567P
+ PS=0.7U PD=0.69U
* device instance $755 r0 *1 48.513,-116.915 pfet
M$755 VPB|VPWR \$346 \$357 VPB|VPWR pfet L=0.15U W=0.42U AS=0.0567P AD=0.0819P
+ PS=0.69U PD=0.81U
* device instance $756 r0 *1 49.053,-116.915 pfet
M$756 \$346 RESET_B|RST_B VPB|VPWR VPB|VPWR pfet L=0.15U W=0.42U AS=0.0819P
+ AD=0.0567P PS=0.81U PD=0.69U
* device instance $757 r0 *1 49.473,-116.915 pfet
M$757 VPB|VPWR \$345 \$346 VPB|VPWR pfet L=0.15U W=0.42U AS=0.0567P AD=0.1134P
+ PS=0.69U PD=1.38U
* device instance $758 r0 *1 47.168,-116.705 pfet
M$758 \$344 \$342 VPB|VPWR VPB|VPWR pfet L=0.15U W=0.84U AS=0.2184P AD=0.12915P
+ PS=2.2U PD=1.185U
* device instance $759 r0 *1 49.648,-117.945 pfet
M$759 VPB|VPWR CLK|X \$312 VPB|VPWR pfet L=0.15U W=0.64U AS=0.1664P AD=0.0864P
+ PS=1.8U PD=0.91U
* device instance $760 r0 *1 50.068,-117.945 pfet
M$760 \$313 \$312 VPB|VPWR VPB|VPWR pfet L=0.15U W=0.64U AS=0.0864P AD=0.1664P
+ PS=0.91U PD=1.8U
* device instance $761 r0 *1 50.548,-116.625 pfet
M$761 B|D|PH_B0|Q|S \$346 VPB|VPWR VPB|VPWR pfet L=0.15U W=1U AS=0.3012P
+ AD=0.26P PS=2.66U PD=2.52U
* device instance $762 r0 *1 51.403,-117.805 pfet
M$762 \$314 B|D|PH_B0|Q|S VPB|VPWR VPB|VPWR pfet L=0.15U W=0.42U AS=0.1092P
+ AD=0.0651P PS=1.36U PD=0.73U
* device instance $763 r0 *1 51.863,-117.805 pfet
M$763 \$315 \$313 \$314 VPB|VPWR pfet L=0.15U W=0.42U AS=0.0651P AD=0.07245P
+ PS=0.73U PD=0.765U
* device instance $764 r0 *1 52.358,-117.805 pfet
M$764 \$316 \$312 \$315 VPB|VPWR pfet L=0.15U W=0.42U AS=0.07245P AD=0.1155P
+ PS=0.765U PD=0.97U
* device instance $765 r0 *1 53.058,-117.805 pfet
M$765 VPB|VPWR \$317 \$316 VPB|VPWR pfet L=0.15U W=0.42U AS=0.1155P AD=0.07035P
+ PS=0.97U PD=0.755U
* device instance $766 r0 *1 53.543,-117.805 pfet
M$766 \$316 RESET_B|RST_B VPB|VPWR VPB|VPWR pfet L=0.15U W=0.42U AS=0.07035P
+ AD=0.1092P PS=0.755U PD=1.36U
* device instance $767 r0 *1 53.703,-116.915 pfet
M$767 \$349 D|X$8 VPB|VPWR VPB|VPWR pfet L=0.15U W=0.42U AS=0.1092P AD=0.0651P
+ PS=1.36U PD=0.73U
* device instance $768 r0 *1 54.163,-116.915 pfet
M$768 \$350 \$348 \$349 VPB|VPWR pfet L=0.15U W=0.42U AS=0.0651P AD=0.07245P
+ PS=0.73U PD=0.765U
* device instance $769 r0 *1 54.658,-116.915 pfet
M$769 \$351 \$347 \$350 VPB|VPWR pfet L=0.15U W=0.42U AS=0.07245P AD=0.1155P
+ PS=0.765U PD=0.97U
* device instance $770 r0 *1 55.358,-116.915 pfet
M$770 VPB|VPWR \$352 \$351 VPB|VPWR pfet L=0.15U W=0.42U AS=0.1155P AD=0.07035P
+ PS=0.97U PD=0.755U
* device instance $771 r0 *1 55.843,-116.915 pfet
M$771 \$351 RESET_B|RST_B VPB|VPWR VPB|VPWR pfet L=0.15U W=0.42U AS=0.07035P
+ AD=0.1092P PS=0.755U PD=1.36U
* device instance $772 r0 *1 54.528,-118.015 pfet
M$772 \$317 \$315 VPB|VPWR VPB|VPWR pfet L=0.15U W=0.84U AS=0.2184P AD=0.12915P
+ PS=2.2U PD=1.185U
* device instance $773 r0 *1 55.023,-117.805 pfet
M$773 \$318 \$312 \$317 VPB|VPWR pfet L=0.15U W=0.42U AS=0.12915P AD=0.0588P
+ PS=1.185U PD=0.7U
* device instance $774 r0 *1 55.453,-117.805 pfet
M$774 \$327 \$313 \$318 VPB|VPWR pfet L=0.15U W=0.42U AS=0.0588P AD=0.0567P
+ PS=0.7U PD=0.69U
* device instance $775 r0 *1 55.873,-117.805 pfet
M$775 VPB|VPWR \$319 \$327 VPB|VPWR pfet L=0.15U W=0.42U AS=0.0567P AD=0.0819P
+ PS=0.69U PD=0.81U
* device instance $776 r0 *1 56.413,-117.805 pfet
M$776 \$319 RESET_B|RST_B VPB|VPWR VPB|VPWR pfet L=0.15U W=0.42U AS=0.0819P
+ AD=0.0567P PS=0.81U PD=0.69U
* device instance $777 r0 *1 56.833,-117.805 pfet
M$777 VPB|VPWR \$318 \$319 VPB|VPWR pfet L=0.15U W=0.42U AS=0.0567P AD=0.1134P
+ PS=0.69U PD=1.38U
* device instance $778 r0 *1 56.558,-121.775 pfet
M$778 \$292 C|PH_EOC|Q \$284 VPB|VPWR pfet L=0.15U W=0.42U AS=0.1092P
+ AD=0.0441P PS=1.36U PD=0.63U
* device instance $779 r0 *1 56.918,-121.775 pfet
M$779 \$293 B|D|PH_B0|Q|S \$292 VPB|VPWR pfet L=0.15U W=0.42U AS=0.0441P
+ AD=0.0693P PS=0.63U PD=0.75U
* device instance $780 r0 *1 57.398,-121.775 pfet
M$780 \$293 A|D|PH_B1|Q|S VPB|VPWR VPB|VPWR pfet L=0.15U W=0.42U AS=0.14825P
+ AD=0.0693P PS=1.34U PD=0.75U
* device instance $781 r0 *1 57.888,-122.065 pfet
M$781 C|X \$284 VPB|VPWR VPB|VPWR pfet L=0.15U W=1U AS=0.14825P AD=0.28P
+ PS=1.34U PD=2.56U
* device instance $782 r0 *1 57.323,-116.915 pfet
M$782 \$353 \$347 \$352 VPB|VPWR pfet L=0.15U W=0.42U AS=0.12915P AD=0.0588P
+ PS=1.185U PD=0.7U
* device instance $783 r0 *1 57.753,-116.915 pfet
M$783 \$358 \$348 \$353 VPB|VPWR pfet L=0.15U W=0.42U AS=0.0588P AD=0.0567P
+ PS=0.7U PD=0.69U
* device instance $784 r0 *1 58.173,-116.915 pfet
M$784 VPB|VPWR \$354 \$358 VPB|VPWR pfet L=0.15U W=0.42U AS=0.0567P AD=0.0819P
+ PS=0.69U PD=0.81U
* device instance $785 r0 *1 58.713,-116.915 pfet
M$785 \$354 RESET_B|RST_B VPB|VPWR VPB|VPWR pfet L=0.15U W=0.42U AS=0.0819P
+ AD=0.0567P PS=0.81U PD=0.69U
* device instance $786 r0 *1 59.133,-116.915 pfet
M$786 VPB|VPWR \$353 \$354 VPB|VPWR pfet L=0.15U W=0.42U AS=0.0567P AD=0.1134P
+ PS=0.69U PD=1.38U
* device instance $787 r0 *1 56.828,-116.705 pfet
M$787 \$352 \$350 VPB|VPWR VPB|VPWR pfet L=0.15U W=0.84U AS=0.2184P AD=0.12915P
+ PS=2.2U PD=1.185U
* device instance $788 r0 *1 57.908,-118.095 pfet
M$788 C|PH_EOC|Q \$319 VPB|VPWR VPB|VPWR pfet L=0.15U W=1U AS=0.3012P AD=0.26P
+ PS=2.66U PD=2.52U
* device instance $789 r0 *1 60.208,-116.625 pfet
M$789 A|A0|DOUT1|Q|SELp1 \$354 VPB|VPWR VPB|VPWR pfet L=0.15U W=1U AS=0.3012P
+ AD=0.26P PS=2.66U PD=2.52U
* device instance $790 r0 *1 91.583,-116.625 pfet
M$790 SELn4|Y A|A0|DOUT4|Q|SELp4 VPB|VPWR$1 VPB|VPWR$1 pfet L=0.15U W=1U
+ AS=0.26P AD=0.26P PS=2.52U PD=2.52U
* device instance $791 r0 *1 28.488,-112.505 pfet
M$791 VPB|VPWR CLK|X \$371 VPB|VPWR pfet L=0.15U W=0.64U AS=0.1664P AD=0.0864P
+ PS=1.8U PD=0.91U
* device instance $792 r0 *1 28.908,-112.505 pfet
M$792 \$372 \$371 VPB|VPWR VPB|VPWR pfet L=0.15U W=0.64U AS=0.0864P AD=0.1664P
+ PS=0.91U PD=1.8U
* device instance $793 r0 *1 29.408,-116.775 pfet
M$793 VPB|VPWR CLK|X \$330 VPB|VPWR pfet L=0.15U W=0.64U AS=0.1664P AD=0.0864P
+ PS=1.8U PD=0.91U
* device instance $794 r0 *1 29.828,-116.775 pfet
M$794 \$331 \$330 VPB|VPWR VPB|VPWR pfet L=0.15U W=0.64U AS=0.0864P AD=0.1664P
+ PS=0.91U PD=1.8U
* device instance $795 r0 *1 30.243,-112.365 pfet
M$795 \$373 C|D|PH_B3|Q|S VPB|VPWR VPB|VPWR pfet L=0.15U W=0.42U AS=0.1092P
+ AD=0.0651P PS=1.36U PD=0.73U
* device instance $796 r0 *1 30.703,-112.365 pfet
M$796 \$374 \$372 \$373 VPB|VPWR pfet L=0.15U W=0.42U AS=0.0651P AD=0.07245P
+ PS=0.73U PD=0.765U
* device instance $797 r0 *1 31.198,-112.365 pfet
M$797 \$375 \$371 \$374 VPB|VPWR pfet L=0.15U W=0.42U AS=0.07245P AD=0.1155P
+ PS=0.765U PD=0.97U
* device instance $798 r0 *1 31.898,-112.365 pfet
M$798 VPB|VPWR \$376 \$375 VPB|VPWR pfet L=0.15U W=0.42U AS=0.1155P AD=0.07035P
+ PS=0.97U PD=0.755U
* device instance $799 r0 *1 32.383,-112.365 pfet
M$799 \$375 RESET_B|RST_B VPB|VPWR VPB|VPWR pfet L=0.15U W=0.42U AS=0.07035P
+ AD=0.1092P PS=0.755U PD=1.36U
* device instance $800 r0 *1 33.368,-112.575 pfet
M$800 \$376 \$374 VPB|VPWR VPB|VPWR pfet L=0.15U W=0.84U AS=0.2184P AD=0.12915P
+ PS=2.2U PD=1.185U
* device instance $801 r0 *1 33.863,-112.365 pfet
M$801 \$377 \$371 \$376 VPB|VPWR pfet L=0.15U W=0.42U AS=0.12915P AD=0.0588P
+ PS=1.185U PD=0.7U
* device instance $802 r0 *1 34.293,-112.365 pfet
M$802 \$391 \$372 \$377 VPB|VPWR pfet L=0.15U W=0.42U AS=0.0588P AD=0.0567P
+ PS=0.7U PD=0.69U
* device instance $803 r0 *1 34.713,-112.365 pfet
M$803 VPB|VPWR \$378 \$391 VPB|VPWR pfet L=0.15U W=0.42U AS=0.0567P AD=0.0819P
+ PS=0.69U PD=0.81U
* device instance $804 r0 *1 35.253,-112.365 pfet
M$804 \$378 RESET_B|RST_B VPB|VPWR VPB|VPWR pfet L=0.15U W=0.42U AS=0.0819P
+ AD=0.0567P PS=0.81U PD=0.69U
* device instance $805 r0 *1 35.673,-112.365 pfet
M$805 VPB|VPWR \$377 \$378 VPB|VPWR pfet L=0.15U W=0.42U AS=0.0567P AD=0.1134P
+ PS=0.69U PD=1.38U
* device instance $806 r0 *1 36.748,-112.655 pfet
M$806 D|PH_B2|Q|S \$378 VPB|VPWR VPB|VPWR pfet L=0.15U W=1U AS=0.3012P AD=0.26P
+ PS=2.66U PD=2.52U
* device instance $807 r0 *1 42.288,-116.775 pfet
M$807 VPB|VPWR CLK|X \$339 VPB|VPWR pfet L=0.15U W=0.64U AS=0.1664P AD=0.0864P
+ PS=1.8U PD=0.91U
* device instance $808 r0 *1 42.708,-116.775 pfet
M$808 \$340 \$339 VPB|VPWR VPB|VPWR pfet L=0.15U W=0.64U AS=0.0864P AD=0.1664P
+ PS=0.91U PD=1.8U
* device instance $809 r0 *1 51.948,-116.775 pfet
M$809 VPB|VPWR CLK|X \$347 VPB|VPWR pfet L=0.15U W=0.64U AS=0.1664P AD=0.0864P
+ PS=1.8U PD=0.91U
* device instance $810 r0 *1 52.368,-116.775 pfet
M$810 \$348 \$347 VPB|VPWR VPB|VPWR pfet L=0.15U W=0.64U AS=0.0864P AD=0.1664P
+ PS=0.91U PD=1.8U
* device instance $811 r0 *1 51.948,-112.505 pfet
M$811 VPB|VPWR CLK|X \$379 VPB|VPWR pfet L=0.15U W=0.64U AS=0.1664P AD=0.0864P
+ PS=1.8U PD=0.91U
* device instance $812 r0 *1 52.368,-112.505 pfet
M$812 \$380 \$379 VPB|VPWR VPB|VPWR pfet L=0.15U W=0.64U AS=0.0864P AD=0.1664P
+ PS=0.91U PD=1.8U
* device instance $813 r0 *1 53.703,-112.365 pfet
M$813 \$381 D|X$9 VPB|VPWR VPB|VPWR pfet L=0.15U W=0.42U AS=0.1092P AD=0.0651P
+ PS=1.36U PD=0.73U
* device instance $814 r0 *1 54.163,-112.365 pfet
M$814 \$382 \$380 \$381 VPB|VPWR pfet L=0.15U W=0.42U AS=0.0651P AD=0.07245P
+ PS=0.73U PD=0.765U
* device instance $815 r0 *1 54.658,-112.365 pfet
M$815 \$383 \$379 \$382 VPB|VPWR pfet L=0.15U W=0.42U AS=0.07245P AD=0.1155P
+ PS=0.765U PD=0.97U
* device instance $816 r0 *1 55.358,-112.365 pfet
M$816 VPB|VPWR \$384 \$383 VPB|VPWR pfet L=0.15U W=0.42U AS=0.1155P AD=0.07035P
+ PS=0.97U PD=0.755U
* device instance $817 r0 *1 55.843,-112.365 pfet
M$817 \$383 RESET_B|RST_B VPB|VPWR VPB|VPWR pfet L=0.15U W=0.42U AS=0.07035P
+ AD=0.1092P PS=0.755U PD=1.36U
* device instance $818 r0 *1 56.828,-112.575 pfet
M$818 \$384 \$382 VPB|VPWR VPB|VPWR pfet L=0.15U W=0.84U AS=0.2184P AD=0.12915P
+ PS=2.2U PD=1.185U
* device instance $819 r0 *1 57.323,-112.365 pfet
M$819 \$385 \$379 \$384 VPB|VPWR pfet L=0.15U W=0.42U AS=0.12915P AD=0.0588P
+ PS=1.185U PD=0.7U
* device instance $820 r0 *1 57.753,-112.365 pfet
M$820 \$396 \$380 \$385 VPB|VPWR pfet L=0.15U W=0.42U AS=0.0588P AD=0.0567P
+ PS=0.7U PD=0.69U
* device instance $821 r0 *1 58.173,-112.365 pfet
M$821 VPB|VPWR \$386 \$396 VPB|VPWR pfet L=0.15U W=0.42U AS=0.0567P AD=0.0819P
+ PS=0.69U PD=0.81U
* device instance $822 r0 *1 58.713,-112.365 pfet
M$822 \$386 RESET_B|RST_B VPB|VPWR VPB|VPWR pfet L=0.15U W=0.42U AS=0.0819P
+ AD=0.0567P PS=0.81U PD=0.69U
* device instance $823 r0 *1 59.133,-112.365 pfet
M$823 VPB|VPWR \$385 \$386 VPB|VPWR pfet L=0.15U W=0.42U AS=0.0567P AD=0.1134P
+ PS=0.69U PD=1.38U
* device instance $824 r0 *1 60.208,-112.655 pfet
M$824 A|A0|DOUT0|Q|SELp0 \$386 VPB|VPWR VPB|VPWR pfet L=0.15U W=1U AS=0.3012P
+ AD=0.26P PS=2.66U PD=2.52U
* device instance $825 r0 *1 91.583,-101.775 pfet
M$825 SELn7|Y A|A0|DOUT7|Q|SELp7 VPB|VPWR$1 VPB|VPWR$1 pfet L=0.15U W=1U
+ AS=0.26P AD=0.26P PS=2.52U PD=2.52U
* device instance $826 r0 *1 91.583,-111.185 pfet
M$826 SELn5|Y A|A0|DOUT5|Q|SELp5 VPB|VPWR$1 VPB|VPWR$1 pfet L=0.15U W=1U
+ AS=0.26P AD=0.26P PS=2.52U PD=2.52U
* device instance $827 r0 *1 91.583,-107.215 pfet
M$827 SELn8|Y A|A0|DOUT8|Q|SELp8 VPB|VPWR$1 VPB|VPWR$1 pfet L=0.15U W=1U
+ AS=0.26P AD=0.26P PS=2.52U PD=2.52U
* device instance $828 r0 *1 91.583,-105.745 pfet
M$828 SELn2|Y A|A0|DOUT2|Q|SELp2 VPB|VPWR$1 VPB|VPWR$1 pfet L=0.15U W=1U
+ AS=0.26P AD=0.26P PS=2.52U PD=2.52U
* device instance $829 r0 *1 91.583,-112.655 pfet
M$829 SELn6|Y A|A0|DOUT6|Q|SELp6 VPB|VPWR$1 VPB|VPWR$1 pfet L=0.15U W=1U
+ AS=0.26P AD=0.26P PS=2.52U PD=2.52U
* device instance $830 r0 *1 92.963,-107.215 pfet
M$830 SELn3|Y A|A0|DOUT3|Q|SELp3 VPB|VPWR$1 VPB|VPWR$1 pfet L=0.15U W=1U
+ AS=0.26P AD=0.26P PS=2.52U PD=2.52U
* device instance $831 r0 *1 91.583,-100.305 pfet
M$831 SELn0|Y A|A0|DOUT0|Q|SELp0 VPB|VPWR$1 VPB|VPWR$1 pfet L=0.15U W=1U
+ AS=0.26P AD=0.26P PS=2.52U PD=2.52U
* device instance $832 r0 *1 91.583,-96.335 pfet
M$832 SELn1|Y A|A0|DOUT1|Q|SELp1 VPB|VPWR$1 VPB|VPWR$1 pfet L=0.15U W=1U
+ AS=0.26P AD=0.26P PS=2.52U PD=2.52U
* device instance $833 r0 *1 4.545,-26.58 pfet
M$833 \$407 A|A0|DOUT0|Q|SELp0 VREFP VDD pfet L=0.15U W=2U AS=0.94P AD=0.94P
+ PS=4.94U PD=4.94U
* device instance $834 r0 *1 15.545,-26.58 pfet
M$834 \$408 A|A0|DOUT1|Q|SELp1 VREFP VDD pfet L=0.15U W=2U AS=0.94P AD=0.94P
+ PS=4.94U PD=4.94U
* device instance $835 r0 *1 26.545,-26.58 pfet
M$835 \$409 A|A0|DOUT2|Q|SELp2 VREFP VDD pfet L=0.15U W=2U AS=0.94P AD=0.94P
+ PS=4.94U PD=4.94U
* device instance $836 r0 *1 37.545,-26.58 pfet
M$836 \$410 A|A0|DOUT3|Q|SELp3 VREFP VDD pfet L=0.15U W=2U AS=0.94P AD=0.94P
+ PS=4.94U PD=4.94U
* device instance $837 r0 *1 48.545,-26.58 pfet
M$837 \$411 A|A0|DOUT4|Q|SELp4 VREFP VDD pfet L=0.15U W=2U AS=0.94P AD=0.94P
+ PS=4.94U PD=4.94U
* device instance $838 r0 *1 59.545,-26.58 pfet
M$838 \$412 A|A0|DOUT5|Q|SELp5 VREFP VDD pfet L=0.15U W=2U AS=0.94P AD=0.94P
+ PS=4.94U PD=4.94U
* device instance $839 r0 *1 70.545,-26.58 pfet
M$839 \$425 A|A0|DOUT6|Q|SELp6 VREFP VDD pfet L=0.15U W=2U AS=0.94P AD=0.94P
+ PS=4.94U PD=4.94U
* device instance $840 r0 *1 81.545,-26.58 pfet
M$840 \$424 A|A0|DOUT7|Q|SELp7 VREFP VDD pfet L=0.15U W=2U AS=0.94P AD=0.94P
+ PS=4.94U PD=4.94U
* device instance $841 r0 *1 92.545,-26.58 pfet
M$841 \$423 A|A0|DOUT8|Q|SELp8 VREFP VDD pfet L=0.15U W=2U AS=0.94P AD=0.94P
+ PS=4.94U PD=4.94U
* device instance $842 r0 *1 103.545,-26.58 pfet
M$842 \$413 SELn0|Y VREFP VDD pfet L=0.15U W=2U AS=0.94P AD=0.94P PS=4.94U
+ PD=4.94U
* device instance $843 r0 *1 114.545,-26.58 pfet
M$843 \$414 SELn1|Y VREFP VDD pfet L=0.15U W=2U AS=0.94P AD=0.94P PS=4.94U
+ PD=4.94U
* device instance $844 r0 *1 125.545,-26.58 pfet
M$844 \$415 SELn2|Y VREFP VDD pfet L=0.15U W=2U AS=0.94P AD=0.94P PS=4.94U
+ PD=4.94U
* device instance $845 r0 *1 136.545,-26.58 pfet
M$845 \$416 SELn3|Y VREFP VDD pfet L=0.15U W=2U AS=0.94P AD=0.94P PS=4.94U
+ PD=4.94U
* device instance $846 r0 *1 147.545,-26.58 pfet
M$846 \$417 SELn4|Y VREFP VDD pfet L=0.15U W=2U AS=0.94P AD=0.94P PS=4.94U
+ PD=4.94U
* device instance $847 r0 *1 158.545,-26.58 pfet
M$847 \$422 SELn5|Y VREFP VDD pfet L=0.15U W=2U AS=0.94P AD=0.94P PS=4.94U
+ PD=4.94U
* device instance $848 r0 *1 169.545,-26.58 pfet
M$848 \$421 SELn6|Y VREFP VDD pfet L=0.15U W=2U AS=0.94P AD=0.94P PS=4.94U
+ PD=4.94U
* device instance $849 r0 *1 180.545,-26.58 pfet
M$849 \$420 SELn7|Y VREFP VDD pfet L=0.15U W=2U AS=0.94P AD=0.94P PS=4.94U
+ PD=4.94U
* device instance $850 r0 *1 191.545,-26.58 pfet
M$850 \$419 SELn8|Y VREFP VDD pfet L=0.15U W=2U AS=0.94P AD=0.94P PS=4.94U
+ PD=4.94U
* device instance $851 r0 *1 66.495,88.75 pfet
M$851 BOOST_P D|PH_SAMPLE|SAMPLE|Y VDD BOOST_P pfet L=0.5U W=1U AS=0.42P
+ AD=0.42P PS=2.84U PD=2.84U
* device instance $852 r0 *1 69.57,88.75 pfet
M$852 \$430 \$439 BOOST_P BOOST_P pfet L=0.15U W=1U AS=0.47P AD=0.47P PS=2.94U
+ PD=2.94U
* device instance $853 r0 *1 74.71,88.75 pfet
M$853 \$432 \$439 VINP VDD pfet L=0.15U W=1U AS=0.47P AD=0.47P PS=2.94U PD=2.94U
* device instance $854 r0 *1 77.91,88.75 pfet
M$854 BPREF_P \$439 VCM VDD pfet L=0.15U W=1U AS=0.47P AD=0.47P PS=2.94U
+ PD=2.94U
* device instance $855 r0 *1 81.11,89.25 pfet
M$855 \$439 D|PH_SAMPLE|SAMPLE|Y VDD VDD pfet L=0.15U W=2U AS=0.94P AD=0.94P
+ PS=4.94U PD=4.94U
* device instance $856 r0 *1 84.31,88.75 pfet
M$856 BPREF_N \$439 VCM VDD pfet L=0.15U W=1U AS=0.47P AD=0.47P PS=2.94U
+ PD=2.94U
* device instance $857 r0 *1 87.51,88.75 pfet
M$857 \$437 \$439 VINN VDD pfet L=0.15U W=1U AS=0.47P AD=0.47P PS=2.94U PD=2.94U
* device instance $858 r0 *1 92.65,88.75 pfet
M$858 \$438 \$439 BOOST_N BOOST_N pfet L=0.15U W=1U AS=0.47P AD=0.47P PS=2.94U
+ PD=2.94U
* device instance $859 r0 *1 95.975,88.75 pfet
M$859 BOOST_N D|PH_SAMPLE|SAMPLE|Y VDD BOOST_N pfet L=0.5U W=1U AS=0.42P
+ AD=0.42P PS=2.84U PD=2.84U
* device instance $860 r0 *1 115.07,198.41 pfet
M$860 OUTN A1|COMP_OUT|OUTP VDD VDD pfet L=0.5U W=8U AS=3.36P AD=3.36P
+ PS=16.84U PD=16.84U
* device instance $861 r0 *1 115.07,189.19 pfet
M$861 A1|COMP_OUT|OUTP OUTN VDD VDD pfet L=0.5U W=8U AS=3.36P AD=3.36P
+ PS=16.84U PD=16.84U
* device instance $862 r0 *1 118.87,202.41 pfet
M$862 OUTN A|CLK VDD VDD pfet L=0.5U W=16U AS=6.72P AD=6.72P PS=32.84U PD=32.84U
* device instance $863 r0 *1 118.87,185.19 pfet
M$863 A1|COMP_OUT|OUTP A|CLK VDD VDD pfet L=0.5U W=16U AS=6.72P AD=6.72P
+ PS=32.84U PD=32.84U
* device instance $864 r0 *1 0,0.35 sky130_fd_pr__model__cap_mim
C$864 \$423 TOP_P|VINP 8.647288e-15 sky130_fd_pr__model__cap_mim
* device instance $865 r0 *1 3.4,0.35 sky130_fd_pr__model__cap_mim
C$865 \$424 TOP_P|VINP 8.647288e-15 sky130_fd_pr__model__cap_mim
* device instance $866 r0 *1 6.8,0.35 sky130_fd_pr__model__cap_mim
C$866 \$423 TOP_P|VINP 8.647288e-15 sky130_fd_pr__model__cap_mim
* device instance $867 r0 *1 10.2,0.35 sky130_fd_pr__model__cap_mim
C$867 \$425 TOP_P|VINP 8.647288e-15 sky130_fd_pr__model__cap_mim
* device instance $868 r0 *1 13.6,0.35 sky130_fd_pr__model__cap_mim
C$868 \$423 TOP_P|VINP 8.647288e-15 sky130_fd_pr__model__cap_mim
* device instance $869 r0 *1 17,0.35 sky130_fd_pr__model__cap_mim
C$869 \$424 TOP_P|VINP 8.647288e-15 sky130_fd_pr__model__cap_mim
* device instance $870 r0 *1 20.4,0.35 sky130_fd_pr__model__cap_mim
C$870 \$423 TOP_P|VINP 8.647288e-15 sky130_fd_pr__model__cap_mim
* device instance $871 r0 *1 23.8,0.35 sky130_fd_pr__model__cap_mim
C$871 \$412 TOP_P|VINP 8.647288e-15 sky130_fd_pr__model__cap_mim
* device instance $872 r0 *1 27.2,0.35 sky130_fd_pr__model__cap_mim
C$872 \$423 TOP_P|VINP 8.647288e-15 sky130_fd_pr__model__cap_mim
* device instance $873 r0 *1 30.6,0.35 sky130_fd_pr__model__cap_mim
C$873 \$424 TOP_P|VINP 8.647288e-15 sky130_fd_pr__model__cap_mim
* device instance $874 r0 *1 34,0.35 sky130_fd_pr__model__cap_mim
C$874 \$423 TOP_P|VINP 8.647288e-15 sky130_fd_pr__model__cap_mim
* device instance $875 r0 *1 37.4,0.35 sky130_fd_pr__model__cap_mim
C$875 \$425 TOP_P|VINP 8.647288e-15 sky130_fd_pr__model__cap_mim
* device instance $876 r0 *1 40.8,0.35 sky130_fd_pr__model__cap_mim
C$876 \$423 TOP_P|VINP 8.647288e-15 sky130_fd_pr__model__cap_mim
* device instance $877 r0 *1 44.2,0.35 sky130_fd_pr__model__cap_mim
C$877 \$424 TOP_P|VINP 8.647288e-15 sky130_fd_pr__model__cap_mim
* device instance $878 r0 *1 47.6,0.35 sky130_fd_pr__model__cap_mim
C$878 \$423 TOP_P|VINP 8.647288e-15 sky130_fd_pr__model__cap_mim
* device instance $879 r0 *1 51,0.35 sky130_fd_pr__model__cap_mim
C$879 \$411 TOP_P|VINP 8.647288e-15 sky130_fd_pr__model__cap_mim
* device instance $880 r0 *1 54.4,0.35 sky130_fd_pr__model__cap_mim
C$880 \$423 TOP_P|VINP 8.647288e-15 sky130_fd_pr__model__cap_mim
* device instance $881 r0 *1 57.8,0.35 sky130_fd_pr__model__cap_mim
C$881 \$424 TOP_P|VINP 8.647288e-15 sky130_fd_pr__model__cap_mim
* device instance $882 r0 *1 61.2,0.35 sky130_fd_pr__model__cap_mim
C$882 \$423 TOP_P|VINP 8.647288e-15 sky130_fd_pr__model__cap_mim
* device instance $883 r0 *1 64.6,0.35 sky130_fd_pr__model__cap_mim
C$883 \$425 TOP_P|VINP 8.647288e-15 sky130_fd_pr__model__cap_mim
* device instance $884 r0 *1 68,0.35 sky130_fd_pr__model__cap_mim
C$884 \$423 TOP_P|VINP 8.647288e-15 sky130_fd_pr__model__cap_mim
* device instance $885 r0 *1 71.4,0.35 sky130_fd_pr__model__cap_mim
C$885 \$424 TOP_P|VINP 8.647288e-15 sky130_fd_pr__model__cap_mim
* device instance $886 r0 *1 74.8,0.35 sky130_fd_pr__model__cap_mim
C$886 \$423 TOP_P|VINP 8.647288e-15 sky130_fd_pr__model__cap_mim
* device instance $887 r0 *1 78.2,0.35 sky130_fd_pr__model__cap_mim
C$887 \$412 TOP_P|VINP 8.647288e-15 sky130_fd_pr__model__cap_mim
* device instance $888 r0 *1 81.6,0.35 sky130_fd_pr__model__cap_mim
C$888 \$423 TOP_P|VINP 8.647288e-15 sky130_fd_pr__model__cap_mim
* device instance $889 r0 *1 85,0.35 sky130_fd_pr__model__cap_mim
C$889 \$424 TOP_P|VINP 8.647288e-15 sky130_fd_pr__model__cap_mim
* device instance $890 r0 *1 88.4,0.35 sky130_fd_pr__model__cap_mim
C$890 \$423 TOP_P|VINP 8.647288e-15 sky130_fd_pr__model__cap_mim
* device instance $891 r0 *1 91.8,0.35 sky130_fd_pr__model__cap_mim
C$891 \$425 TOP_P|VINP 8.647288e-15 sky130_fd_pr__model__cap_mim
* device instance $892 r0 *1 95.2,0.35 sky130_fd_pr__model__cap_mim
C$892 \$423 TOP_P|VINP 8.647288e-15 sky130_fd_pr__model__cap_mim
* device instance $893 r0 *1 98.6,0.35 sky130_fd_pr__model__cap_mim
C$893 \$424 TOP_P|VINP 8.647288e-15 sky130_fd_pr__model__cap_mim
* device instance $894 r0 *1 102,0.35 sky130_fd_pr__model__cap_mim
C$894 \$423 TOP_P|VINP 8.647288e-15 sky130_fd_pr__model__cap_mim
* device instance $895 r0 *1 105.4,0.35 sky130_fd_pr__model__cap_mim
C$895 \$410 TOP_P|VINP 8.647288e-15 sky130_fd_pr__model__cap_mim
* device instance $896 r0 *1 108.8,0.35 sky130_fd_pr__model__cap_mim
C$896 \$407 TOP_P|VINP 8.647288e-15 sky130_fd_pr__model__cap_mim
* device instance $897 r0 *1 112.2,0.35 sky130_fd_pr__model__cap_mim
C$897 \$423 TOP_P|VINP 8.647288e-15 sky130_fd_pr__model__cap_mim
* device instance $898 r0 *1 115.6,0.35 sky130_fd_pr__model__cap_mim
C$898 \$424 TOP_P|VINP 8.647288e-15 sky130_fd_pr__model__cap_mim
* device instance $899 r0 *1 119,0.35 sky130_fd_pr__model__cap_mim
C$899 \$423 TOP_P|VINP 8.647288e-15 sky130_fd_pr__model__cap_mim
* device instance $900 r0 *1 122.4,0.35 sky130_fd_pr__model__cap_mim
C$900 \$425 TOP_P|VINP 8.647288e-15 sky130_fd_pr__model__cap_mim
* device instance $901 r0 *1 125.8,0.35 sky130_fd_pr__model__cap_mim
C$901 \$423 TOP_P|VINP 8.647288e-15 sky130_fd_pr__model__cap_mim
* device instance $902 r0 *1 129.2,0.35 sky130_fd_pr__model__cap_mim
C$902 \$424 TOP_P|VINP 8.647288e-15 sky130_fd_pr__model__cap_mim
* device instance $903 r0 *1 132.6,0.35 sky130_fd_pr__model__cap_mim
C$903 \$423 TOP_P|VINP 8.647288e-15 sky130_fd_pr__model__cap_mim
* device instance $904 r0 *1 136,0.35 sky130_fd_pr__model__cap_mim
C$904 \$412 TOP_P|VINP 8.647288e-15 sky130_fd_pr__model__cap_mim
* device instance $905 r0 *1 139.4,0.35 sky130_fd_pr__model__cap_mim
C$905 \$423 TOP_P|VINP 8.647288e-15 sky130_fd_pr__model__cap_mim
* device instance $906 r0 *1 142.8,0.35 sky130_fd_pr__model__cap_mim
C$906 \$424 TOP_P|VINP 8.647288e-15 sky130_fd_pr__model__cap_mim
* device instance $907 r0 *1 146.2,0.35 sky130_fd_pr__model__cap_mim
C$907 \$423 TOP_P|VINP 8.647288e-15 sky130_fd_pr__model__cap_mim
* device instance $908 r0 *1 149.6,0.35 sky130_fd_pr__model__cap_mim
C$908 \$425 TOP_P|VINP 8.647288e-15 sky130_fd_pr__model__cap_mim
* device instance $909 r0 *1 153,0.35 sky130_fd_pr__model__cap_mim
C$909 \$423 TOP_P|VINP 8.647288e-15 sky130_fd_pr__model__cap_mim
* device instance $910 r0 *1 156.4,0.35 sky130_fd_pr__model__cap_mim
C$910 \$424 TOP_P|VINP 8.647288e-15 sky130_fd_pr__model__cap_mim
* device instance $911 r0 *1 159.8,0.35 sky130_fd_pr__model__cap_mim
C$911 \$423 TOP_P|VINP 8.647288e-15 sky130_fd_pr__model__cap_mim
* device instance $912 r0 *1 163.2,0.35 sky130_fd_pr__model__cap_mim
C$912 \$411 TOP_P|VINP 8.647288e-15 sky130_fd_pr__model__cap_mim
* device instance $913 r0 *1 166.6,0.35 sky130_fd_pr__model__cap_mim
C$913 \$423 TOP_P|VINP 8.647288e-15 sky130_fd_pr__model__cap_mim
* device instance $914 r0 *1 170,0.35 sky130_fd_pr__model__cap_mim
C$914 \$424 TOP_P|VINP 8.647288e-15 sky130_fd_pr__model__cap_mim
* device instance $915 r0 *1 173.4,0.35 sky130_fd_pr__model__cap_mim
C$915 \$423 TOP_P|VINP 8.647288e-15 sky130_fd_pr__model__cap_mim
* device instance $916 r0 *1 176.8,0.35 sky130_fd_pr__model__cap_mim
C$916 \$425 TOP_P|VINP 8.647288e-15 sky130_fd_pr__model__cap_mim
* device instance $917 r0 *1 180.2,0.35 sky130_fd_pr__model__cap_mim
C$917 \$423 TOP_P|VINP 8.647288e-15 sky130_fd_pr__model__cap_mim
* device instance $918 r0 *1 183.6,0.35 sky130_fd_pr__model__cap_mim
C$918 \$424 TOP_P|VINP 8.647288e-15 sky130_fd_pr__model__cap_mim
* device instance $919 r0 *1 187,0.35 sky130_fd_pr__model__cap_mim
C$919 \$423 TOP_P|VINP 8.647288e-15 sky130_fd_pr__model__cap_mim
* device instance $920 r0 *1 190.4,0.35 sky130_fd_pr__model__cap_mim
C$920 \$412 TOP_P|VINP 8.647288e-15 sky130_fd_pr__model__cap_mim
* device instance $921 r0 *1 193.8,0.35 sky130_fd_pr__model__cap_mim
C$921 \$423 TOP_P|VINP 8.647288e-15 sky130_fd_pr__model__cap_mim
* device instance $922 r0 *1 197.2,0.35 sky130_fd_pr__model__cap_mim
C$922 \$424 TOP_P|VINP 8.647288e-15 sky130_fd_pr__model__cap_mim
* device instance $923 r0 *1 200.6,0.35 sky130_fd_pr__model__cap_mim
C$923 \$423 TOP_P|VINP 8.647288e-15 sky130_fd_pr__model__cap_mim
* device instance $924 r0 *1 204,0.35 sky130_fd_pr__model__cap_mim
C$924 \$425 TOP_P|VINP 8.647288e-15 sky130_fd_pr__model__cap_mim
* device instance $925 r0 *1 207.4,0.35 sky130_fd_pr__model__cap_mim
C$925 \$423 TOP_P|VINP 8.647288e-15 sky130_fd_pr__model__cap_mim
* device instance $926 r0 *1 210.8,0.35 sky130_fd_pr__model__cap_mim
C$926 \$424 TOP_P|VINP 8.647288e-15 sky130_fd_pr__model__cap_mim
* device instance $927 r0 *1 214.2,0.35 sky130_fd_pr__model__cap_mim
C$927 \$423 TOP_P|VINP 8.647288e-15 sky130_fd_pr__model__cap_mim
* device instance $928 r0 *1 0,3.75 sky130_fd_pr__model__cap_mim
C$928 \$419 TOP_N|VINN 8.647288e-15 sky130_fd_pr__model__cap_mim
* device instance $929 r0 *1 3.4,3.75 sky130_fd_pr__model__cap_mim
C$929 \$420 TOP_N|VINN 8.647288e-15 sky130_fd_pr__model__cap_mim
* device instance $930 r0 *1 6.8,3.75 sky130_fd_pr__model__cap_mim
C$930 \$419 TOP_N|VINN 8.647288e-15 sky130_fd_pr__model__cap_mim
* device instance $931 r0 *1 10.2,3.75 sky130_fd_pr__model__cap_mim
C$931 \$421 TOP_N|VINN 8.647288e-15 sky130_fd_pr__model__cap_mim
* device instance $932 r0 *1 13.6,3.75 sky130_fd_pr__model__cap_mim
C$932 \$419 TOP_N|VINN 8.647288e-15 sky130_fd_pr__model__cap_mim
* device instance $933 r0 *1 17,3.75 sky130_fd_pr__model__cap_mim
C$933 \$420 TOP_N|VINN 8.647288e-15 sky130_fd_pr__model__cap_mim
* device instance $934 r0 *1 20.4,3.75 sky130_fd_pr__model__cap_mim
C$934 \$419 TOP_N|VINN 8.647288e-15 sky130_fd_pr__model__cap_mim
* device instance $935 r0 *1 23.8,3.75 sky130_fd_pr__model__cap_mim
C$935 \$422 TOP_N|VINN 8.647288e-15 sky130_fd_pr__model__cap_mim
* device instance $936 r0 *1 27.2,3.75 sky130_fd_pr__model__cap_mim
C$936 \$419 TOP_N|VINN 8.647288e-15 sky130_fd_pr__model__cap_mim
* device instance $937 r0 *1 30.6,3.75 sky130_fd_pr__model__cap_mim
C$937 \$420 TOP_N|VINN 8.647288e-15 sky130_fd_pr__model__cap_mim
* device instance $938 r0 *1 34,3.75 sky130_fd_pr__model__cap_mim
C$938 \$419 TOP_N|VINN 8.647288e-15 sky130_fd_pr__model__cap_mim
* device instance $939 r0 *1 37.4,3.75 sky130_fd_pr__model__cap_mim
C$939 \$421 TOP_N|VINN 8.647288e-15 sky130_fd_pr__model__cap_mim
* device instance $940 r0 *1 40.8,3.75 sky130_fd_pr__model__cap_mim
C$940 \$419 TOP_N|VINN 8.647288e-15 sky130_fd_pr__model__cap_mim
* device instance $941 r0 *1 44.2,3.75 sky130_fd_pr__model__cap_mim
C$941 \$420 TOP_N|VINN 8.647288e-15 sky130_fd_pr__model__cap_mim
* device instance $942 r0 *1 47.6,3.75 sky130_fd_pr__model__cap_mim
C$942 \$419 TOP_N|VINN 8.647288e-15 sky130_fd_pr__model__cap_mim
* device instance $943 r0 *1 51,3.75 sky130_fd_pr__model__cap_mim
C$943 \$417 TOP_N|VINN 8.647288e-15 sky130_fd_pr__model__cap_mim
* device instance $944 r0 *1 54.4,3.75 sky130_fd_pr__model__cap_mim
C$944 \$419 TOP_N|VINN 8.647288e-15 sky130_fd_pr__model__cap_mim
* device instance $945 r0 *1 57.8,3.75 sky130_fd_pr__model__cap_mim
C$945 \$420 TOP_N|VINN 8.647288e-15 sky130_fd_pr__model__cap_mim
* device instance $946 r0 *1 61.2,3.75 sky130_fd_pr__model__cap_mim
C$946 \$419 TOP_N|VINN 8.647288e-15 sky130_fd_pr__model__cap_mim
* device instance $947 r0 *1 64.6,3.75 sky130_fd_pr__model__cap_mim
C$947 \$421 TOP_N|VINN 8.647288e-15 sky130_fd_pr__model__cap_mim
* device instance $948 r0 *1 68,3.75 sky130_fd_pr__model__cap_mim
C$948 \$419 TOP_N|VINN 8.647288e-15 sky130_fd_pr__model__cap_mim
* device instance $949 r0 *1 71.4,3.75 sky130_fd_pr__model__cap_mim
C$949 \$420 TOP_N|VINN 8.647288e-15 sky130_fd_pr__model__cap_mim
* device instance $950 r0 *1 74.8,3.75 sky130_fd_pr__model__cap_mim
C$950 \$419 TOP_N|VINN 8.647288e-15 sky130_fd_pr__model__cap_mim
* device instance $951 r0 *1 78.2,3.75 sky130_fd_pr__model__cap_mim
C$951 \$422 TOP_N|VINN 8.647288e-15 sky130_fd_pr__model__cap_mim
* device instance $952 r0 *1 81.6,3.75 sky130_fd_pr__model__cap_mim
C$952 \$419 TOP_N|VINN 8.647288e-15 sky130_fd_pr__model__cap_mim
* device instance $953 r0 *1 85,3.75 sky130_fd_pr__model__cap_mim
C$953 \$420 TOP_N|VINN 8.647288e-15 sky130_fd_pr__model__cap_mim
* device instance $954 r0 *1 88.4,3.75 sky130_fd_pr__model__cap_mim
C$954 \$419 TOP_N|VINN 8.647288e-15 sky130_fd_pr__model__cap_mim
* device instance $955 r0 *1 91.8,3.75 sky130_fd_pr__model__cap_mim
C$955 \$421 TOP_N|VINN 8.647288e-15 sky130_fd_pr__model__cap_mim
* device instance $956 r0 *1 95.2,3.75 sky130_fd_pr__model__cap_mim
C$956 \$419 TOP_N|VINN 8.647288e-15 sky130_fd_pr__model__cap_mim
* device instance $957 r0 *1 98.6,3.75 sky130_fd_pr__model__cap_mim
C$957 \$420 TOP_N|VINN 8.647288e-15 sky130_fd_pr__model__cap_mim
* device instance $958 r0 *1 102,3.75 sky130_fd_pr__model__cap_mim
C$958 \$419 TOP_N|VINN 8.647288e-15 sky130_fd_pr__model__cap_mim
* device instance $959 r0 *1 105.4,3.75 sky130_fd_pr__model__cap_mim
C$959 \$416 TOP_N|VINN 8.647288e-15 sky130_fd_pr__model__cap_mim
* device instance $960 r0 *1 108.8,3.75 sky130_fd_pr__model__cap_mim
C$960 \$413 TOP_N|VINN 8.647288e-15 sky130_fd_pr__model__cap_mim
* device instance $961 r0 *1 112.2,3.75 sky130_fd_pr__model__cap_mim
C$961 \$419 TOP_N|VINN 8.647288e-15 sky130_fd_pr__model__cap_mim
* device instance $962 r0 *1 115.6,3.75 sky130_fd_pr__model__cap_mim
C$962 \$420 TOP_N|VINN 8.647288e-15 sky130_fd_pr__model__cap_mim
* device instance $963 r0 *1 119,3.75 sky130_fd_pr__model__cap_mim
C$963 \$419 TOP_N|VINN 8.647288e-15 sky130_fd_pr__model__cap_mim
* device instance $964 r0 *1 122.4,3.75 sky130_fd_pr__model__cap_mim
C$964 \$421 TOP_N|VINN 8.647288e-15 sky130_fd_pr__model__cap_mim
* device instance $965 r0 *1 125.8,3.75 sky130_fd_pr__model__cap_mim
C$965 \$419 TOP_N|VINN 8.647288e-15 sky130_fd_pr__model__cap_mim
* device instance $966 r0 *1 129.2,3.75 sky130_fd_pr__model__cap_mim
C$966 \$420 TOP_N|VINN 8.647288e-15 sky130_fd_pr__model__cap_mim
* device instance $967 r0 *1 132.6,3.75 sky130_fd_pr__model__cap_mim
C$967 \$419 TOP_N|VINN 8.647288e-15 sky130_fd_pr__model__cap_mim
* device instance $968 r0 *1 136,3.75 sky130_fd_pr__model__cap_mim
C$968 \$422 TOP_N|VINN 8.647288e-15 sky130_fd_pr__model__cap_mim
* device instance $969 r0 *1 139.4,3.75 sky130_fd_pr__model__cap_mim
C$969 \$419 TOP_N|VINN 8.647288e-15 sky130_fd_pr__model__cap_mim
* device instance $970 r0 *1 142.8,3.75 sky130_fd_pr__model__cap_mim
C$970 \$420 TOP_N|VINN 8.647288e-15 sky130_fd_pr__model__cap_mim
* device instance $971 r0 *1 146.2,3.75 sky130_fd_pr__model__cap_mim
C$971 \$419 TOP_N|VINN 8.647288e-15 sky130_fd_pr__model__cap_mim
* device instance $972 r0 *1 149.6,3.75 sky130_fd_pr__model__cap_mim
C$972 \$421 TOP_N|VINN 8.647288e-15 sky130_fd_pr__model__cap_mim
* device instance $973 r0 *1 153,3.75 sky130_fd_pr__model__cap_mim
C$973 \$419 TOP_N|VINN 8.647288e-15 sky130_fd_pr__model__cap_mim
* device instance $974 r0 *1 156.4,3.75 sky130_fd_pr__model__cap_mim
C$974 \$420 TOP_N|VINN 8.647288e-15 sky130_fd_pr__model__cap_mim
* device instance $975 r0 *1 159.8,3.75 sky130_fd_pr__model__cap_mim
C$975 \$419 TOP_N|VINN 8.647288e-15 sky130_fd_pr__model__cap_mim
* device instance $976 r0 *1 163.2,3.75 sky130_fd_pr__model__cap_mim
C$976 \$417 TOP_N|VINN 8.647288e-15 sky130_fd_pr__model__cap_mim
* device instance $977 r0 *1 166.6,3.75 sky130_fd_pr__model__cap_mim
C$977 \$419 TOP_N|VINN 8.647288e-15 sky130_fd_pr__model__cap_mim
* device instance $978 r0 *1 170,3.75 sky130_fd_pr__model__cap_mim
C$978 \$420 TOP_N|VINN 8.647288e-15 sky130_fd_pr__model__cap_mim
* device instance $979 r0 *1 173.4,3.75 sky130_fd_pr__model__cap_mim
C$979 \$419 TOP_N|VINN 8.647288e-15 sky130_fd_pr__model__cap_mim
* device instance $980 r0 *1 176.8,3.75 sky130_fd_pr__model__cap_mim
C$980 \$421 TOP_N|VINN 8.647288e-15 sky130_fd_pr__model__cap_mim
* device instance $981 r0 *1 180.2,3.75 sky130_fd_pr__model__cap_mim
C$981 \$419 TOP_N|VINN 8.647288e-15 sky130_fd_pr__model__cap_mim
* device instance $982 r0 *1 183.6,3.75 sky130_fd_pr__model__cap_mim
C$982 \$420 TOP_N|VINN 8.647288e-15 sky130_fd_pr__model__cap_mim
* device instance $983 r0 *1 187,3.75 sky130_fd_pr__model__cap_mim
C$983 \$419 TOP_N|VINN 8.647288e-15 sky130_fd_pr__model__cap_mim
* device instance $984 r0 *1 190.4,3.75 sky130_fd_pr__model__cap_mim
C$984 \$422 TOP_N|VINN 8.647288e-15 sky130_fd_pr__model__cap_mim
* device instance $985 r0 *1 193.8,3.75 sky130_fd_pr__model__cap_mim
C$985 \$419 TOP_N|VINN 8.647288e-15 sky130_fd_pr__model__cap_mim
* device instance $986 r0 *1 197.2,3.75 sky130_fd_pr__model__cap_mim
C$986 \$420 TOP_N|VINN 8.647288e-15 sky130_fd_pr__model__cap_mim
* device instance $987 r0 *1 200.6,3.75 sky130_fd_pr__model__cap_mim
C$987 \$419 TOP_N|VINN 8.647288e-15 sky130_fd_pr__model__cap_mim
* device instance $988 r0 *1 204,3.75 sky130_fd_pr__model__cap_mim
C$988 \$421 TOP_N|VINN 8.647288e-15 sky130_fd_pr__model__cap_mim
* device instance $989 r0 *1 207.4,3.75 sky130_fd_pr__model__cap_mim
C$989 \$419 TOP_N|VINN 8.647288e-15 sky130_fd_pr__model__cap_mim
* device instance $990 r0 *1 210.8,3.75 sky130_fd_pr__model__cap_mim
C$990 \$420 TOP_N|VINN 8.647288e-15 sky130_fd_pr__model__cap_mim
* device instance $991 r0 *1 214.2,3.75 sky130_fd_pr__model__cap_mim
C$991 \$419 TOP_N|VINN 8.647288e-15 sky130_fd_pr__model__cap_mim
* device instance $992 r0 *1 0,7.15 sky130_fd_pr__model__cap_mim
C$992 \$423 TOP_P|VINP 8.647288e-15 sky130_fd_pr__model__cap_mim
* device instance $993 r0 *1 3.4,7.15 sky130_fd_pr__model__cap_mim
C$993 \$424 TOP_P|VINP 8.647288e-15 sky130_fd_pr__model__cap_mim
* device instance $994 r0 *1 6.8,7.15 sky130_fd_pr__model__cap_mim
C$994 \$423 TOP_P|VINP 8.647288e-15 sky130_fd_pr__model__cap_mim
* device instance $995 r0 *1 10.2,7.15 sky130_fd_pr__model__cap_mim
C$995 \$425 TOP_P|VINP 8.647288e-15 sky130_fd_pr__model__cap_mim
* device instance $996 r0 *1 13.6,7.15 sky130_fd_pr__model__cap_mim
C$996 \$423 TOP_P|VINP 8.647288e-15 sky130_fd_pr__model__cap_mim
* device instance $997 r0 *1 17,7.15 sky130_fd_pr__model__cap_mim
C$997 \$424 TOP_P|VINP 8.647288e-15 sky130_fd_pr__model__cap_mim
* device instance $998 r0 *1 20.4,7.15 sky130_fd_pr__model__cap_mim
C$998 \$423 TOP_P|VINP 8.647288e-15 sky130_fd_pr__model__cap_mim
* device instance $999 r0 *1 23.8,7.15 sky130_fd_pr__model__cap_mim
C$999 \$412 TOP_P|VINP 8.647288e-15 sky130_fd_pr__model__cap_mim
* device instance $1000 r0 *1 27.2,7.15 sky130_fd_pr__model__cap_mim
C$1000 \$423 TOP_P|VINP 8.647288e-15 sky130_fd_pr__model__cap_mim
* device instance $1001 r0 *1 30.6,7.15 sky130_fd_pr__model__cap_mim
C$1001 \$424 TOP_P|VINP 8.647288e-15 sky130_fd_pr__model__cap_mim
* device instance $1002 r0 *1 34,7.15 sky130_fd_pr__model__cap_mim
C$1002 \$423 TOP_P|VINP 8.647288e-15 sky130_fd_pr__model__cap_mim
* device instance $1003 r0 *1 37.4,7.15 sky130_fd_pr__model__cap_mim
C$1003 \$425 TOP_P|VINP 8.647288e-15 sky130_fd_pr__model__cap_mim
* device instance $1004 r0 *1 40.8,7.15 sky130_fd_pr__model__cap_mim
C$1004 \$423 TOP_P|VINP 8.647288e-15 sky130_fd_pr__model__cap_mim
* device instance $1005 r0 *1 44.2,7.15 sky130_fd_pr__model__cap_mim
C$1005 \$424 TOP_P|VINP 8.647288e-15 sky130_fd_pr__model__cap_mim
* device instance $1006 r0 *1 47.6,7.15 sky130_fd_pr__model__cap_mim
C$1006 \$423 TOP_P|VINP 8.647288e-15 sky130_fd_pr__model__cap_mim
* device instance $1007 r0 *1 51,7.15 sky130_fd_pr__model__cap_mim
C$1007 \$411 TOP_P|VINP 8.647288e-15 sky130_fd_pr__model__cap_mim
* device instance $1008 r0 *1 54.4,7.15 sky130_fd_pr__model__cap_mim
C$1008 \$423 TOP_P|VINP 8.647288e-15 sky130_fd_pr__model__cap_mim
* device instance $1009 r0 *1 57.8,7.15 sky130_fd_pr__model__cap_mim
C$1009 \$424 TOP_P|VINP 8.647288e-15 sky130_fd_pr__model__cap_mim
* device instance $1010 r0 *1 61.2,7.15 sky130_fd_pr__model__cap_mim
C$1010 \$423 TOP_P|VINP 8.647288e-15 sky130_fd_pr__model__cap_mim
* device instance $1011 r0 *1 64.6,7.15 sky130_fd_pr__model__cap_mim
C$1011 \$425 TOP_P|VINP 8.647288e-15 sky130_fd_pr__model__cap_mim
* device instance $1012 r0 *1 68,7.15 sky130_fd_pr__model__cap_mim
C$1012 \$423 TOP_P|VINP 8.647288e-15 sky130_fd_pr__model__cap_mim
* device instance $1013 r0 *1 71.4,7.15 sky130_fd_pr__model__cap_mim
C$1013 \$424 TOP_P|VINP 8.647288e-15 sky130_fd_pr__model__cap_mim
* device instance $1014 r0 *1 74.8,7.15 sky130_fd_pr__model__cap_mim
C$1014 \$423 TOP_P|VINP 8.647288e-15 sky130_fd_pr__model__cap_mim
* device instance $1015 r0 *1 78.2,7.15 sky130_fd_pr__model__cap_mim
C$1015 \$412 TOP_P|VINP 8.647288e-15 sky130_fd_pr__model__cap_mim
* device instance $1016 r0 *1 81.6,7.15 sky130_fd_pr__model__cap_mim
C$1016 \$423 TOP_P|VINP 8.647288e-15 sky130_fd_pr__model__cap_mim
* device instance $1017 r0 *1 85,7.15 sky130_fd_pr__model__cap_mim
C$1017 \$424 TOP_P|VINP 8.647288e-15 sky130_fd_pr__model__cap_mim
* device instance $1018 r0 *1 88.4,7.15 sky130_fd_pr__model__cap_mim
C$1018 \$423 TOP_P|VINP 8.647288e-15 sky130_fd_pr__model__cap_mim
* device instance $1019 r0 *1 91.8,7.15 sky130_fd_pr__model__cap_mim
C$1019 \$425 TOP_P|VINP 8.647288e-15 sky130_fd_pr__model__cap_mim
* device instance $1020 r0 *1 95.2,7.15 sky130_fd_pr__model__cap_mim
C$1020 \$423 TOP_P|VINP 8.647288e-15 sky130_fd_pr__model__cap_mim
* device instance $1021 r0 *1 98.6,7.15 sky130_fd_pr__model__cap_mim
C$1021 \$424 TOP_P|VINP 8.647288e-15 sky130_fd_pr__model__cap_mim
* device instance $1022 r0 *1 102,7.15 sky130_fd_pr__model__cap_mim
C$1022 \$423 TOP_P|VINP 8.647288e-15 sky130_fd_pr__model__cap_mim
* device instance $1023 r0 *1 105.4,7.15 sky130_fd_pr__model__cap_mim
C$1023 \$410 TOP_P|VINP 8.647288e-15 sky130_fd_pr__model__cap_mim
* device instance $1024 r0 *1 108.8,7.15 sky130_fd_pr__model__cap_mim
C$1024 \$409 TOP_P|VINP 8.647288e-15 sky130_fd_pr__model__cap_mim
* device instance $1025 r0 *1 112.2,7.15 sky130_fd_pr__model__cap_mim
C$1025 \$423 TOP_P|VINP 8.647288e-15 sky130_fd_pr__model__cap_mim
* device instance $1026 r0 *1 115.6,7.15 sky130_fd_pr__model__cap_mim
C$1026 \$424 TOP_P|VINP 8.647288e-15 sky130_fd_pr__model__cap_mim
* device instance $1027 r0 *1 119,7.15 sky130_fd_pr__model__cap_mim
C$1027 \$423 TOP_P|VINP 8.647288e-15 sky130_fd_pr__model__cap_mim
* device instance $1028 r0 *1 122.4,7.15 sky130_fd_pr__model__cap_mim
C$1028 \$425 TOP_P|VINP 8.647288e-15 sky130_fd_pr__model__cap_mim
* device instance $1029 r0 *1 125.8,7.15 sky130_fd_pr__model__cap_mim
C$1029 \$423 TOP_P|VINP 8.647288e-15 sky130_fd_pr__model__cap_mim
* device instance $1030 r0 *1 129.2,7.15 sky130_fd_pr__model__cap_mim
C$1030 \$424 TOP_P|VINP 8.647288e-15 sky130_fd_pr__model__cap_mim
* device instance $1031 r0 *1 132.6,7.15 sky130_fd_pr__model__cap_mim
C$1031 \$423 TOP_P|VINP 8.647288e-15 sky130_fd_pr__model__cap_mim
* device instance $1032 r0 *1 136,7.15 sky130_fd_pr__model__cap_mim
C$1032 \$412 TOP_P|VINP 8.647288e-15 sky130_fd_pr__model__cap_mim
* device instance $1033 r0 *1 139.4,7.15 sky130_fd_pr__model__cap_mim
C$1033 \$423 TOP_P|VINP 8.647288e-15 sky130_fd_pr__model__cap_mim
* device instance $1034 r0 *1 142.8,7.15 sky130_fd_pr__model__cap_mim
C$1034 \$424 TOP_P|VINP 8.647288e-15 sky130_fd_pr__model__cap_mim
* device instance $1035 r0 *1 146.2,7.15 sky130_fd_pr__model__cap_mim
C$1035 \$423 TOP_P|VINP 8.647288e-15 sky130_fd_pr__model__cap_mim
* device instance $1036 r0 *1 149.6,7.15 sky130_fd_pr__model__cap_mim
C$1036 \$425 TOP_P|VINP 8.647288e-15 sky130_fd_pr__model__cap_mim
* device instance $1037 r0 *1 153,7.15 sky130_fd_pr__model__cap_mim
C$1037 \$423 TOP_P|VINP 8.647288e-15 sky130_fd_pr__model__cap_mim
* device instance $1038 r0 *1 156.4,7.15 sky130_fd_pr__model__cap_mim
C$1038 \$424 TOP_P|VINP 8.647288e-15 sky130_fd_pr__model__cap_mim
* device instance $1039 r0 *1 159.8,7.15 sky130_fd_pr__model__cap_mim
C$1039 \$423 TOP_P|VINP 8.647288e-15 sky130_fd_pr__model__cap_mim
* device instance $1040 r0 *1 163.2,7.15 sky130_fd_pr__model__cap_mim
C$1040 \$411 TOP_P|VINP 8.647288e-15 sky130_fd_pr__model__cap_mim
* device instance $1041 r0 *1 166.6,7.15 sky130_fd_pr__model__cap_mim
C$1041 \$423 TOP_P|VINP 8.647288e-15 sky130_fd_pr__model__cap_mim
* device instance $1042 r0 *1 170,7.15 sky130_fd_pr__model__cap_mim
C$1042 \$424 TOP_P|VINP 8.647288e-15 sky130_fd_pr__model__cap_mim
* device instance $1043 r0 *1 173.4,7.15 sky130_fd_pr__model__cap_mim
C$1043 \$423 TOP_P|VINP 8.647288e-15 sky130_fd_pr__model__cap_mim
* device instance $1044 r0 *1 176.8,7.15 sky130_fd_pr__model__cap_mim
C$1044 \$425 TOP_P|VINP 8.647288e-15 sky130_fd_pr__model__cap_mim
* device instance $1045 r0 *1 180.2,7.15 sky130_fd_pr__model__cap_mim
C$1045 \$423 TOP_P|VINP 8.647288e-15 sky130_fd_pr__model__cap_mim
* device instance $1046 r0 *1 183.6,7.15 sky130_fd_pr__model__cap_mim
C$1046 \$424 TOP_P|VINP 8.647288e-15 sky130_fd_pr__model__cap_mim
* device instance $1047 r0 *1 187,7.15 sky130_fd_pr__model__cap_mim
C$1047 \$423 TOP_P|VINP 8.647288e-15 sky130_fd_pr__model__cap_mim
* device instance $1048 r0 *1 190.4,7.15 sky130_fd_pr__model__cap_mim
C$1048 \$412 TOP_P|VINP 8.647288e-15 sky130_fd_pr__model__cap_mim
* device instance $1049 r0 *1 193.8,7.15 sky130_fd_pr__model__cap_mim
C$1049 \$423 TOP_P|VINP 8.647288e-15 sky130_fd_pr__model__cap_mim
* device instance $1050 r0 *1 197.2,7.15 sky130_fd_pr__model__cap_mim
C$1050 \$424 TOP_P|VINP 8.647288e-15 sky130_fd_pr__model__cap_mim
* device instance $1051 r0 *1 200.6,7.15 sky130_fd_pr__model__cap_mim
C$1051 \$423 TOP_P|VINP 8.647288e-15 sky130_fd_pr__model__cap_mim
* device instance $1052 r0 *1 204,7.15 sky130_fd_pr__model__cap_mim
C$1052 \$425 TOP_P|VINP 8.647288e-15 sky130_fd_pr__model__cap_mim
* device instance $1053 r0 *1 207.4,7.15 sky130_fd_pr__model__cap_mim
C$1053 \$423 TOP_P|VINP 8.647288e-15 sky130_fd_pr__model__cap_mim
* device instance $1054 r0 *1 210.8,7.15 sky130_fd_pr__model__cap_mim
C$1054 \$424 TOP_P|VINP 8.647288e-15 sky130_fd_pr__model__cap_mim
* device instance $1055 r0 *1 214.2,7.15 sky130_fd_pr__model__cap_mim
C$1055 \$423 TOP_P|VINP 8.647288e-15 sky130_fd_pr__model__cap_mim
* device instance $1056 r0 *1 0,10.55 sky130_fd_pr__model__cap_mim
C$1056 \$419 TOP_N|VINN 8.647288e-15 sky130_fd_pr__model__cap_mim
* device instance $1057 r0 *1 3.4,10.55 sky130_fd_pr__model__cap_mim
C$1057 \$420 TOP_N|VINN 8.647288e-15 sky130_fd_pr__model__cap_mim
* device instance $1058 r0 *1 6.8,10.55 sky130_fd_pr__model__cap_mim
C$1058 \$419 TOP_N|VINN 8.647288e-15 sky130_fd_pr__model__cap_mim
* device instance $1059 r0 *1 10.2,10.55 sky130_fd_pr__model__cap_mim
C$1059 \$421 TOP_N|VINN 8.647288e-15 sky130_fd_pr__model__cap_mim
* device instance $1060 r0 *1 13.6,10.55 sky130_fd_pr__model__cap_mim
C$1060 \$419 TOP_N|VINN 8.647288e-15 sky130_fd_pr__model__cap_mim
* device instance $1061 r0 *1 17,10.55 sky130_fd_pr__model__cap_mim
C$1061 \$420 TOP_N|VINN 8.647288e-15 sky130_fd_pr__model__cap_mim
* device instance $1062 r0 *1 20.4,10.55 sky130_fd_pr__model__cap_mim
C$1062 \$419 TOP_N|VINN 8.647288e-15 sky130_fd_pr__model__cap_mim
* device instance $1063 r0 *1 23.8,10.55 sky130_fd_pr__model__cap_mim
C$1063 \$422 TOP_N|VINN 8.647288e-15 sky130_fd_pr__model__cap_mim
* device instance $1064 r0 *1 27.2,10.55 sky130_fd_pr__model__cap_mim
C$1064 \$419 TOP_N|VINN 8.647288e-15 sky130_fd_pr__model__cap_mim
* device instance $1065 r0 *1 30.6,10.55 sky130_fd_pr__model__cap_mim
C$1065 \$420 TOP_N|VINN 8.647288e-15 sky130_fd_pr__model__cap_mim
* device instance $1066 r0 *1 34,10.55 sky130_fd_pr__model__cap_mim
C$1066 \$419 TOP_N|VINN 8.647288e-15 sky130_fd_pr__model__cap_mim
* device instance $1067 r0 *1 37.4,10.55 sky130_fd_pr__model__cap_mim
C$1067 \$421 TOP_N|VINN 8.647288e-15 sky130_fd_pr__model__cap_mim
* device instance $1068 r0 *1 40.8,10.55 sky130_fd_pr__model__cap_mim
C$1068 \$419 TOP_N|VINN 8.647288e-15 sky130_fd_pr__model__cap_mim
* device instance $1069 r0 *1 44.2,10.55 sky130_fd_pr__model__cap_mim
C$1069 \$420 TOP_N|VINN 8.647288e-15 sky130_fd_pr__model__cap_mim
* device instance $1070 r0 *1 47.6,10.55 sky130_fd_pr__model__cap_mim
C$1070 \$419 TOP_N|VINN 8.647288e-15 sky130_fd_pr__model__cap_mim
* device instance $1071 r0 *1 51,10.55 sky130_fd_pr__model__cap_mim
C$1071 \$417 TOP_N|VINN 8.647288e-15 sky130_fd_pr__model__cap_mim
* device instance $1072 r0 *1 54.4,10.55 sky130_fd_pr__model__cap_mim
C$1072 \$419 TOP_N|VINN 8.647288e-15 sky130_fd_pr__model__cap_mim
* device instance $1073 r0 *1 57.8,10.55 sky130_fd_pr__model__cap_mim
C$1073 \$420 TOP_N|VINN 8.647288e-15 sky130_fd_pr__model__cap_mim
* device instance $1074 r0 *1 61.2,10.55 sky130_fd_pr__model__cap_mim
C$1074 \$419 TOP_N|VINN 8.647288e-15 sky130_fd_pr__model__cap_mim
* device instance $1075 r0 *1 64.6,10.55 sky130_fd_pr__model__cap_mim
C$1075 \$421 TOP_N|VINN 8.647288e-15 sky130_fd_pr__model__cap_mim
* device instance $1076 r0 *1 68,10.55 sky130_fd_pr__model__cap_mim
C$1076 \$419 TOP_N|VINN 8.647288e-15 sky130_fd_pr__model__cap_mim
* device instance $1077 r0 *1 71.4,10.55 sky130_fd_pr__model__cap_mim
C$1077 \$420 TOP_N|VINN 8.647288e-15 sky130_fd_pr__model__cap_mim
* device instance $1078 r0 *1 74.8,10.55 sky130_fd_pr__model__cap_mim
C$1078 \$419 TOP_N|VINN 8.647288e-15 sky130_fd_pr__model__cap_mim
* device instance $1079 r0 *1 78.2,10.55 sky130_fd_pr__model__cap_mim
C$1079 \$422 TOP_N|VINN 8.647288e-15 sky130_fd_pr__model__cap_mim
* device instance $1080 r0 *1 81.6,10.55 sky130_fd_pr__model__cap_mim
C$1080 \$419 TOP_N|VINN 8.647288e-15 sky130_fd_pr__model__cap_mim
* device instance $1081 r0 *1 85,10.55 sky130_fd_pr__model__cap_mim
C$1081 \$420 TOP_N|VINN 8.647288e-15 sky130_fd_pr__model__cap_mim
* device instance $1082 r0 *1 88.4,10.55 sky130_fd_pr__model__cap_mim
C$1082 \$419 TOP_N|VINN 8.647288e-15 sky130_fd_pr__model__cap_mim
* device instance $1083 r0 *1 91.8,10.55 sky130_fd_pr__model__cap_mim
C$1083 \$421 TOP_N|VINN 8.647288e-15 sky130_fd_pr__model__cap_mim
* device instance $1084 r0 *1 95.2,10.55 sky130_fd_pr__model__cap_mim
C$1084 \$419 TOP_N|VINN 8.647288e-15 sky130_fd_pr__model__cap_mim
* device instance $1085 r0 *1 98.6,10.55 sky130_fd_pr__model__cap_mim
C$1085 \$420 TOP_N|VINN 8.647288e-15 sky130_fd_pr__model__cap_mim
* device instance $1086 r0 *1 102,10.55 sky130_fd_pr__model__cap_mim
C$1086 \$419 TOP_N|VINN 8.647288e-15 sky130_fd_pr__model__cap_mim
* device instance $1087 r0 *1 105.4,10.55 sky130_fd_pr__model__cap_mim
C$1087 \$416 TOP_N|VINN 8.647288e-15 sky130_fd_pr__model__cap_mim
* device instance $1088 r0 *1 108.8,10.55 sky130_fd_pr__model__cap_mim
C$1088 \$415 TOP_N|VINN 8.647288e-15 sky130_fd_pr__model__cap_mim
* device instance $1089 r0 *1 112.2,10.55 sky130_fd_pr__model__cap_mim
C$1089 \$419 TOP_N|VINN 8.647288e-15 sky130_fd_pr__model__cap_mim
* device instance $1090 r0 *1 115.6,10.55 sky130_fd_pr__model__cap_mim
C$1090 \$420 TOP_N|VINN 8.647288e-15 sky130_fd_pr__model__cap_mim
* device instance $1091 r0 *1 119,10.55 sky130_fd_pr__model__cap_mim
C$1091 \$419 TOP_N|VINN 8.647288e-15 sky130_fd_pr__model__cap_mim
* device instance $1092 r0 *1 122.4,10.55 sky130_fd_pr__model__cap_mim
C$1092 \$421 TOP_N|VINN 8.647288e-15 sky130_fd_pr__model__cap_mim
* device instance $1093 r0 *1 125.8,10.55 sky130_fd_pr__model__cap_mim
C$1093 \$419 TOP_N|VINN 8.647288e-15 sky130_fd_pr__model__cap_mim
* device instance $1094 r0 *1 129.2,10.55 sky130_fd_pr__model__cap_mim
C$1094 \$420 TOP_N|VINN 8.647288e-15 sky130_fd_pr__model__cap_mim
* device instance $1095 r0 *1 132.6,10.55 sky130_fd_pr__model__cap_mim
C$1095 \$419 TOP_N|VINN 8.647288e-15 sky130_fd_pr__model__cap_mim
* device instance $1096 r0 *1 136,10.55 sky130_fd_pr__model__cap_mim
C$1096 \$422 TOP_N|VINN 8.647288e-15 sky130_fd_pr__model__cap_mim
* device instance $1097 r0 *1 139.4,10.55 sky130_fd_pr__model__cap_mim
C$1097 \$419 TOP_N|VINN 8.647288e-15 sky130_fd_pr__model__cap_mim
* device instance $1098 r0 *1 142.8,10.55 sky130_fd_pr__model__cap_mim
C$1098 \$420 TOP_N|VINN 8.647288e-15 sky130_fd_pr__model__cap_mim
* device instance $1099 r0 *1 146.2,10.55 sky130_fd_pr__model__cap_mim
C$1099 \$419 TOP_N|VINN 8.647288e-15 sky130_fd_pr__model__cap_mim
* device instance $1100 r0 *1 149.6,10.55 sky130_fd_pr__model__cap_mim
C$1100 \$421 TOP_N|VINN 8.647288e-15 sky130_fd_pr__model__cap_mim
* device instance $1101 r0 *1 153,10.55 sky130_fd_pr__model__cap_mim
C$1101 \$419 TOP_N|VINN 8.647288e-15 sky130_fd_pr__model__cap_mim
* device instance $1102 r0 *1 156.4,10.55 sky130_fd_pr__model__cap_mim
C$1102 \$420 TOP_N|VINN 8.647288e-15 sky130_fd_pr__model__cap_mim
* device instance $1103 r0 *1 159.8,10.55 sky130_fd_pr__model__cap_mim
C$1103 \$419 TOP_N|VINN 8.647288e-15 sky130_fd_pr__model__cap_mim
* device instance $1104 r0 *1 163.2,10.55 sky130_fd_pr__model__cap_mim
C$1104 \$417 TOP_N|VINN 8.647288e-15 sky130_fd_pr__model__cap_mim
* device instance $1105 r0 *1 166.6,10.55 sky130_fd_pr__model__cap_mim
C$1105 \$419 TOP_N|VINN 8.647288e-15 sky130_fd_pr__model__cap_mim
* device instance $1106 r0 *1 170,10.55 sky130_fd_pr__model__cap_mim
C$1106 \$420 TOP_N|VINN 8.647288e-15 sky130_fd_pr__model__cap_mim
* device instance $1107 r0 *1 173.4,10.55 sky130_fd_pr__model__cap_mim
C$1107 \$419 TOP_N|VINN 8.647288e-15 sky130_fd_pr__model__cap_mim
* device instance $1108 r0 *1 176.8,10.55 sky130_fd_pr__model__cap_mim
C$1108 \$421 TOP_N|VINN 8.647288e-15 sky130_fd_pr__model__cap_mim
* device instance $1109 r0 *1 180.2,10.55 sky130_fd_pr__model__cap_mim
C$1109 \$419 TOP_N|VINN 8.647288e-15 sky130_fd_pr__model__cap_mim
* device instance $1110 r0 *1 183.6,10.55 sky130_fd_pr__model__cap_mim
C$1110 \$420 TOP_N|VINN 8.647288e-15 sky130_fd_pr__model__cap_mim
* device instance $1111 r0 *1 187,10.55 sky130_fd_pr__model__cap_mim
C$1111 \$419 TOP_N|VINN 8.647288e-15 sky130_fd_pr__model__cap_mim
* device instance $1112 r0 *1 190.4,10.55 sky130_fd_pr__model__cap_mim
C$1112 \$422 TOP_N|VINN 8.647288e-15 sky130_fd_pr__model__cap_mim
* device instance $1113 r0 *1 193.8,10.55 sky130_fd_pr__model__cap_mim
C$1113 \$419 TOP_N|VINN 8.647288e-15 sky130_fd_pr__model__cap_mim
* device instance $1114 r0 *1 197.2,10.55 sky130_fd_pr__model__cap_mim
C$1114 \$420 TOP_N|VINN 8.647288e-15 sky130_fd_pr__model__cap_mim
* device instance $1115 r0 *1 200.6,10.55 sky130_fd_pr__model__cap_mim
C$1115 \$419 TOP_N|VINN 8.647288e-15 sky130_fd_pr__model__cap_mim
* device instance $1116 r0 *1 204,10.55 sky130_fd_pr__model__cap_mim
C$1116 \$421 TOP_N|VINN 8.647288e-15 sky130_fd_pr__model__cap_mim
* device instance $1117 r0 *1 207.4,10.55 sky130_fd_pr__model__cap_mim
C$1117 \$419 TOP_N|VINN 8.647288e-15 sky130_fd_pr__model__cap_mim
* device instance $1118 r0 *1 210.8,10.55 sky130_fd_pr__model__cap_mim
C$1118 \$420 TOP_N|VINN 8.647288e-15 sky130_fd_pr__model__cap_mim
* device instance $1119 r0 *1 214.2,10.55 sky130_fd_pr__model__cap_mim
C$1119 \$419 TOP_N|VINN 8.647288e-15 sky130_fd_pr__model__cap_mim
* device instance $1120 r0 *1 0,13.95 sky130_fd_pr__model__cap_mim
C$1120 \$423 TOP_P|VINP 8.647288e-15 sky130_fd_pr__model__cap_mim
* device instance $1121 r0 *1 3.4,13.95 sky130_fd_pr__model__cap_mim
C$1121 \$424 TOP_P|VINP 8.647288e-15 sky130_fd_pr__model__cap_mim
* device instance $1122 r0 *1 6.8,13.95 sky130_fd_pr__model__cap_mim
C$1122 \$423 TOP_P|VINP 8.647288e-15 sky130_fd_pr__model__cap_mim
* device instance $1123 r0 *1 10.2,13.95 sky130_fd_pr__model__cap_mim
C$1123 \$425 TOP_P|VINP 8.647288e-15 sky130_fd_pr__model__cap_mim
* device instance $1124 r0 *1 13.6,13.95 sky130_fd_pr__model__cap_mim
C$1124 \$423 TOP_P|VINP 8.647288e-15 sky130_fd_pr__model__cap_mim
* device instance $1125 r0 *1 17,13.95 sky130_fd_pr__model__cap_mim
C$1125 \$424 TOP_P|VINP 8.647288e-15 sky130_fd_pr__model__cap_mim
* device instance $1126 r0 *1 20.4,13.95 sky130_fd_pr__model__cap_mim
C$1126 \$423 TOP_P|VINP 8.647288e-15 sky130_fd_pr__model__cap_mim
* device instance $1127 r0 *1 23.8,13.95 sky130_fd_pr__model__cap_mim
C$1127 \$412 TOP_P|VINP 8.647288e-15 sky130_fd_pr__model__cap_mim
* device instance $1128 r0 *1 27.2,13.95 sky130_fd_pr__model__cap_mim
C$1128 \$423 TOP_P|VINP 8.647288e-15 sky130_fd_pr__model__cap_mim
* device instance $1129 r0 *1 30.6,13.95 sky130_fd_pr__model__cap_mim
C$1129 \$424 TOP_P|VINP 8.647288e-15 sky130_fd_pr__model__cap_mim
* device instance $1130 r0 *1 34,13.95 sky130_fd_pr__model__cap_mim
C$1130 \$423 TOP_P|VINP 8.647288e-15 sky130_fd_pr__model__cap_mim
* device instance $1131 r0 *1 37.4,13.95 sky130_fd_pr__model__cap_mim
C$1131 \$425 TOP_P|VINP 8.647288e-15 sky130_fd_pr__model__cap_mim
* device instance $1132 r0 *1 40.8,13.95 sky130_fd_pr__model__cap_mim
C$1132 \$423 TOP_P|VINP 8.647288e-15 sky130_fd_pr__model__cap_mim
* device instance $1133 r0 *1 44.2,13.95 sky130_fd_pr__model__cap_mim
C$1133 \$424 TOP_P|VINP 8.647288e-15 sky130_fd_pr__model__cap_mim
* device instance $1134 r0 *1 47.6,13.95 sky130_fd_pr__model__cap_mim
C$1134 \$423 TOP_P|VINP 8.647288e-15 sky130_fd_pr__model__cap_mim
* device instance $1135 r0 *1 51,13.95 sky130_fd_pr__model__cap_mim
C$1135 \$411 TOP_P|VINP 8.647288e-15 sky130_fd_pr__model__cap_mim
* device instance $1136 r0 *1 54.4,13.95 sky130_fd_pr__model__cap_mim
C$1136 \$423 TOP_P|VINP 8.647288e-15 sky130_fd_pr__model__cap_mim
* device instance $1137 r0 *1 57.8,13.95 sky130_fd_pr__model__cap_mim
C$1137 \$424 TOP_P|VINP 8.647288e-15 sky130_fd_pr__model__cap_mim
* device instance $1138 r0 *1 61.2,13.95 sky130_fd_pr__model__cap_mim
C$1138 \$423 TOP_P|VINP 8.647288e-15 sky130_fd_pr__model__cap_mim
* device instance $1139 r0 *1 64.6,13.95 sky130_fd_pr__model__cap_mim
C$1139 \$425 TOP_P|VINP 8.647288e-15 sky130_fd_pr__model__cap_mim
* device instance $1140 r0 *1 68,13.95 sky130_fd_pr__model__cap_mim
C$1140 \$423 TOP_P|VINP 8.647288e-15 sky130_fd_pr__model__cap_mim
* device instance $1141 r0 *1 71.4,13.95 sky130_fd_pr__model__cap_mim
C$1141 \$424 TOP_P|VINP 8.647288e-15 sky130_fd_pr__model__cap_mim
* device instance $1142 r0 *1 74.8,13.95 sky130_fd_pr__model__cap_mim
C$1142 \$423 TOP_P|VINP 8.647288e-15 sky130_fd_pr__model__cap_mim
* device instance $1143 r0 *1 78.2,13.95 sky130_fd_pr__model__cap_mim
C$1143 \$412 TOP_P|VINP 8.647288e-15 sky130_fd_pr__model__cap_mim
* device instance $1144 r0 *1 81.6,13.95 sky130_fd_pr__model__cap_mim
C$1144 \$423 TOP_P|VINP 8.647288e-15 sky130_fd_pr__model__cap_mim
* device instance $1145 r0 *1 85,13.95 sky130_fd_pr__model__cap_mim
C$1145 \$424 TOP_P|VINP 8.647288e-15 sky130_fd_pr__model__cap_mim
* device instance $1146 r0 *1 88.4,13.95 sky130_fd_pr__model__cap_mim
C$1146 \$423 TOP_P|VINP 8.647288e-15 sky130_fd_pr__model__cap_mim
* device instance $1147 r0 *1 91.8,13.95 sky130_fd_pr__model__cap_mim
C$1147 \$425 TOP_P|VINP 8.647288e-15 sky130_fd_pr__model__cap_mim
* device instance $1148 r0 *1 95.2,13.95 sky130_fd_pr__model__cap_mim
C$1148 \$423 TOP_P|VINP 8.647288e-15 sky130_fd_pr__model__cap_mim
* device instance $1149 r0 *1 98.6,13.95 sky130_fd_pr__model__cap_mim
C$1149 \$424 TOP_P|VINP 8.647288e-15 sky130_fd_pr__model__cap_mim
* device instance $1150 r0 *1 102,13.95 sky130_fd_pr__model__cap_mim
C$1150 \$423 TOP_P|VINP 8.647288e-15 sky130_fd_pr__model__cap_mim
* device instance $1151 r0 *1 105.4,13.95 sky130_fd_pr__model__cap_mim
C$1151 \$410 TOP_P|VINP 8.647288e-15 sky130_fd_pr__model__cap_mim
* device instance $1152 r0 *1 108.8,13.95 sky130_fd_pr__model__cap_mim
C$1152 \$408 TOP_P|VINP 8.647288e-15 sky130_fd_pr__model__cap_mim
* device instance $1153 r0 *1 112.2,13.95 sky130_fd_pr__model__cap_mim
C$1153 \$423 TOP_P|VINP 8.647288e-15 sky130_fd_pr__model__cap_mim
* device instance $1154 r0 *1 115.6,13.95 sky130_fd_pr__model__cap_mim
C$1154 \$424 TOP_P|VINP 8.647288e-15 sky130_fd_pr__model__cap_mim
* device instance $1155 r0 *1 119,13.95 sky130_fd_pr__model__cap_mim
C$1155 \$423 TOP_P|VINP 8.647288e-15 sky130_fd_pr__model__cap_mim
* device instance $1156 r0 *1 122.4,13.95 sky130_fd_pr__model__cap_mim
C$1156 \$425 TOP_P|VINP 8.647288e-15 sky130_fd_pr__model__cap_mim
* device instance $1157 r0 *1 125.8,13.95 sky130_fd_pr__model__cap_mim
C$1157 \$423 TOP_P|VINP 8.647288e-15 sky130_fd_pr__model__cap_mim
* device instance $1158 r0 *1 129.2,13.95 sky130_fd_pr__model__cap_mim
C$1158 \$424 TOP_P|VINP 8.647288e-15 sky130_fd_pr__model__cap_mim
* device instance $1159 r0 *1 132.6,13.95 sky130_fd_pr__model__cap_mim
C$1159 \$423 TOP_P|VINP 8.647288e-15 sky130_fd_pr__model__cap_mim
* device instance $1160 r0 *1 136,13.95 sky130_fd_pr__model__cap_mim
C$1160 \$412 TOP_P|VINP 8.647288e-15 sky130_fd_pr__model__cap_mim
* device instance $1161 r0 *1 139.4,13.95 sky130_fd_pr__model__cap_mim
C$1161 \$423 TOP_P|VINP 8.647288e-15 sky130_fd_pr__model__cap_mim
* device instance $1162 r0 *1 142.8,13.95 sky130_fd_pr__model__cap_mim
C$1162 \$424 TOP_P|VINP 8.647288e-15 sky130_fd_pr__model__cap_mim
* device instance $1163 r0 *1 146.2,13.95 sky130_fd_pr__model__cap_mim
C$1163 \$423 TOP_P|VINP 8.647288e-15 sky130_fd_pr__model__cap_mim
* device instance $1164 r0 *1 149.6,13.95 sky130_fd_pr__model__cap_mim
C$1164 \$425 TOP_P|VINP 8.647288e-15 sky130_fd_pr__model__cap_mim
* device instance $1165 r0 *1 153,13.95 sky130_fd_pr__model__cap_mim
C$1165 \$423 TOP_P|VINP 8.647288e-15 sky130_fd_pr__model__cap_mim
* device instance $1166 r0 *1 156.4,13.95 sky130_fd_pr__model__cap_mim
C$1166 \$424 TOP_P|VINP 8.647288e-15 sky130_fd_pr__model__cap_mim
* device instance $1167 r0 *1 159.8,13.95 sky130_fd_pr__model__cap_mim
C$1167 \$423 TOP_P|VINP 8.647288e-15 sky130_fd_pr__model__cap_mim
* device instance $1168 r0 *1 163.2,13.95 sky130_fd_pr__model__cap_mim
C$1168 \$411 TOP_P|VINP 8.647288e-15 sky130_fd_pr__model__cap_mim
* device instance $1169 r0 *1 166.6,13.95 sky130_fd_pr__model__cap_mim
C$1169 \$423 TOP_P|VINP 8.647288e-15 sky130_fd_pr__model__cap_mim
* device instance $1170 r0 *1 170,13.95 sky130_fd_pr__model__cap_mim
C$1170 \$424 TOP_P|VINP 8.647288e-15 sky130_fd_pr__model__cap_mim
* device instance $1171 r0 *1 173.4,13.95 sky130_fd_pr__model__cap_mim
C$1171 \$423 TOP_P|VINP 8.647288e-15 sky130_fd_pr__model__cap_mim
* device instance $1172 r0 *1 176.8,13.95 sky130_fd_pr__model__cap_mim
C$1172 \$425 TOP_P|VINP 8.647288e-15 sky130_fd_pr__model__cap_mim
* device instance $1173 r0 *1 180.2,13.95 sky130_fd_pr__model__cap_mim
C$1173 \$423 TOP_P|VINP 8.647288e-15 sky130_fd_pr__model__cap_mim
* device instance $1174 r0 *1 183.6,13.95 sky130_fd_pr__model__cap_mim
C$1174 \$424 TOP_P|VINP 8.647288e-15 sky130_fd_pr__model__cap_mim
* device instance $1175 r0 *1 187,13.95 sky130_fd_pr__model__cap_mim
C$1175 \$423 TOP_P|VINP 8.647288e-15 sky130_fd_pr__model__cap_mim
* device instance $1176 r0 *1 190.4,13.95 sky130_fd_pr__model__cap_mim
C$1176 \$412 TOP_P|VINP 8.647288e-15 sky130_fd_pr__model__cap_mim
* device instance $1177 r0 *1 193.8,13.95 sky130_fd_pr__model__cap_mim
C$1177 \$423 TOP_P|VINP 8.647288e-15 sky130_fd_pr__model__cap_mim
* device instance $1178 r0 *1 197.2,13.95 sky130_fd_pr__model__cap_mim
C$1178 \$424 TOP_P|VINP 8.647288e-15 sky130_fd_pr__model__cap_mim
* device instance $1179 r0 *1 200.6,13.95 sky130_fd_pr__model__cap_mim
C$1179 \$423 TOP_P|VINP 8.647288e-15 sky130_fd_pr__model__cap_mim
* device instance $1180 r0 *1 204,13.95 sky130_fd_pr__model__cap_mim
C$1180 \$425 TOP_P|VINP 8.647288e-15 sky130_fd_pr__model__cap_mim
* device instance $1181 r0 *1 207.4,13.95 sky130_fd_pr__model__cap_mim
C$1181 \$423 TOP_P|VINP 8.647288e-15 sky130_fd_pr__model__cap_mim
* device instance $1182 r0 *1 210.8,13.95 sky130_fd_pr__model__cap_mim
C$1182 \$424 TOP_P|VINP 8.647288e-15 sky130_fd_pr__model__cap_mim
* device instance $1183 r0 *1 214.2,13.95 sky130_fd_pr__model__cap_mim
C$1183 \$423 TOP_P|VINP 8.647288e-15 sky130_fd_pr__model__cap_mim
* device instance $1184 r0 *1 0,17.35 sky130_fd_pr__model__cap_mim
C$1184 \$419 TOP_N|VINN 8.647288e-15 sky130_fd_pr__model__cap_mim
* device instance $1185 r0 *1 3.4,17.35 sky130_fd_pr__model__cap_mim
C$1185 \$420 TOP_N|VINN 8.647288e-15 sky130_fd_pr__model__cap_mim
* device instance $1186 r0 *1 6.8,17.35 sky130_fd_pr__model__cap_mim
C$1186 \$419 TOP_N|VINN 8.647288e-15 sky130_fd_pr__model__cap_mim
* device instance $1187 r0 *1 10.2,17.35 sky130_fd_pr__model__cap_mim
C$1187 \$421 TOP_N|VINN 8.647288e-15 sky130_fd_pr__model__cap_mim
* device instance $1188 r0 *1 13.6,17.35 sky130_fd_pr__model__cap_mim
C$1188 \$419 TOP_N|VINN 8.647288e-15 sky130_fd_pr__model__cap_mim
* device instance $1189 r0 *1 17,17.35 sky130_fd_pr__model__cap_mim
C$1189 \$420 TOP_N|VINN 8.647288e-15 sky130_fd_pr__model__cap_mim
* device instance $1190 r0 *1 20.4,17.35 sky130_fd_pr__model__cap_mim
C$1190 \$419 TOP_N|VINN 8.647288e-15 sky130_fd_pr__model__cap_mim
* device instance $1191 r0 *1 23.8,17.35 sky130_fd_pr__model__cap_mim
C$1191 \$422 TOP_N|VINN 8.647288e-15 sky130_fd_pr__model__cap_mim
* device instance $1192 r0 *1 27.2,17.35 sky130_fd_pr__model__cap_mim
C$1192 \$419 TOP_N|VINN 8.647288e-15 sky130_fd_pr__model__cap_mim
* device instance $1193 r0 *1 30.6,17.35 sky130_fd_pr__model__cap_mim
C$1193 \$420 TOP_N|VINN 8.647288e-15 sky130_fd_pr__model__cap_mim
* device instance $1194 r0 *1 34,17.35 sky130_fd_pr__model__cap_mim
C$1194 \$419 TOP_N|VINN 8.647288e-15 sky130_fd_pr__model__cap_mim
* device instance $1195 r0 *1 37.4,17.35 sky130_fd_pr__model__cap_mim
C$1195 \$421 TOP_N|VINN 8.647288e-15 sky130_fd_pr__model__cap_mim
* device instance $1196 r0 *1 40.8,17.35 sky130_fd_pr__model__cap_mim
C$1196 \$419 TOP_N|VINN 8.647288e-15 sky130_fd_pr__model__cap_mim
* device instance $1197 r0 *1 44.2,17.35 sky130_fd_pr__model__cap_mim
C$1197 \$420 TOP_N|VINN 8.647288e-15 sky130_fd_pr__model__cap_mim
* device instance $1198 r0 *1 47.6,17.35 sky130_fd_pr__model__cap_mim
C$1198 \$419 TOP_N|VINN 8.647288e-15 sky130_fd_pr__model__cap_mim
* device instance $1199 r0 *1 51,17.35 sky130_fd_pr__model__cap_mim
C$1199 \$417 TOP_N|VINN 8.647288e-15 sky130_fd_pr__model__cap_mim
* device instance $1200 r0 *1 54.4,17.35 sky130_fd_pr__model__cap_mim
C$1200 \$419 TOP_N|VINN 8.647288e-15 sky130_fd_pr__model__cap_mim
* device instance $1201 r0 *1 57.8,17.35 sky130_fd_pr__model__cap_mim
C$1201 \$420 TOP_N|VINN 8.647288e-15 sky130_fd_pr__model__cap_mim
* device instance $1202 r0 *1 61.2,17.35 sky130_fd_pr__model__cap_mim
C$1202 \$419 TOP_N|VINN 8.647288e-15 sky130_fd_pr__model__cap_mim
* device instance $1203 r0 *1 64.6,17.35 sky130_fd_pr__model__cap_mim
C$1203 \$421 TOP_N|VINN 8.647288e-15 sky130_fd_pr__model__cap_mim
* device instance $1204 r0 *1 68,17.35 sky130_fd_pr__model__cap_mim
C$1204 \$419 TOP_N|VINN 8.647288e-15 sky130_fd_pr__model__cap_mim
* device instance $1205 r0 *1 71.4,17.35 sky130_fd_pr__model__cap_mim
C$1205 \$420 TOP_N|VINN 8.647288e-15 sky130_fd_pr__model__cap_mim
* device instance $1206 r0 *1 74.8,17.35 sky130_fd_pr__model__cap_mim
C$1206 \$419 TOP_N|VINN 8.647288e-15 sky130_fd_pr__model__cap_mim
* device instance $1207 r0 *1 78.2,17.35 sky130_fd_pr__model__cap_mim
C$1207 \$422 TOP_N|VINN 8.647288e-15 sky130_fd_pr__model__cap_mim
* device instance $1208 r0 *1 81.6,17.35 sky130_fd_pr__model__cap_mim
C$1208 \$419 TOP_N|VINN 8.647288e-15 sky130_fd_pr__model__cap_mim
* device instance $1209 r0 *1 85,17.35 sky130_fd_pr__model__cap_mim
C$1209 \$420 TOP_N|VINN 8.647288e-15 sky130_fd_pr__model__cap_mim
* device instance $1210 r0 *1 88.4,17.35 sky130_fd_pr__model__cap_mim
C$1210 \$419 TOP_N|VINN 8.647288e-15 sky130_fd_pr__model__cap_mim
* device instance $1211 r0 *1 91.8,17.35 sky130_fd_pr__model__cap_mim
C$1211 \$421 TOP_N|VINN 8.647288e-15 sky130_fd_pr__model__cap_mim
* device instance $1212 r0 *1 95.2,17.35 sky130_fd_pr__model__cap_mim
C$1212 \$419 TOP_N|VINN 8.647288e-15 sky130_fd_pr__model__cap_mim
* device instance $1213 r0 *1 98.6,17.35 sky130_fd_pr__model__cap_mim
C$1213 \$420 TOP_N|VINN 8.647288e-15 sky130_fd_pr__model__cap_mim
* device instance $1214 r0 *1 102,17.35 sky130_fd_pr__model__cap_mim
C$1214 \$419 TOP_N|VINN 8.647288e-15 sky130_fd_pr__model__cap_mim
* device instance $1215 r0 *1 105.4,17.35 sky130_fd_pr__model__cap_mim
C$1215 \$416 TOP_N|VINN 8.647288e-15 sky130_fd_pr__model__cap_mim
* device instance $1216 r0 *1 108.8,17.35 sky130_fd_pr__model__cap_mim
C$1216 \$414 TOP_N|VINN 8.647288e-15 sky130_fd_pr__model__cap_mim
* device instance $1217 r0 *1 112.2,17.35 sky130_fd_pr__model__cap_mim
C$1217 \$419 TOP_N|VINN 8.647288e-15 sky130_fd_pr__model__cap_mim
* device instance $1218 r0 *1 115.6,17.35 sky130_fd_pr__model__cap_mim
C$1218 \$420 TOP_N|VINN 8.647288e-15 sky130_fd_pr__model__cap_mim
* device instance $1219 r0 *1 119,17.35 sky130_fd_pr__model__cap_mim
C$1219 \$419 TOP_N|VINN 8.647288e-15 sky130_fd_pr__model__cap_mim
* device instance $1220 r0 *1 122.4,17.35 sky130_fd_pr__model__cap_mim
C$1220 \$421 TOP_N|VINN 8.647288e-15 sky130_fd_pr__model__cap_mim
* device instance $1221 r0 *1 125.8,17.35 sky130_fd_pr__model__cap_mim
C$1221 \$419 TOP_N|VINN 8.647288e-15 sky130_fd_pr__model__cap_mim
* device instance $1222 r0 *1 129.2,17.35 sky130_fd_pr__model__cap_mim
C$1222 \$420 TOP_N|VINN 8.647288e-15 sky130_fd_pr__model__cap_mim
* device instance $1223 r0 *1 132.6,17.35 sky130_fd_pr__model__cap_mim
C$1223 \$419 TOP_N|VINN 8.647288e-15 sky130_fd_pr__model__cap_mim
* device instance $1224 r0 *1 136,17.35 sky130_fd_pr__model__cap_mim
C$1224 \$422 TOP_N|VINN 8.647288e-15 sky130_fd_pr__model__cap_mim
* device instance $1225 r0 *1 139.4,17.35 sky130_fd_pr__model__cap_mim
C$1225 \$419 TOP_N|VINN 8.647288e-15 sky130_fd_pr__model__cap_mim
* device instance $1226 r0 *1 142.8,17.35 sky130_fd_pr__model__cap_mim
C$1226 \$420 TOP_N|VINN 8.647288e-15 sky130_fd_pr__model__cap_mim
* device instance $1227 r0 *1 146.2,17.35 sky130_fd_pr__model__cap_mim
C$1227 \$419 TOP_N|VINN 8.647288e-15 sky130_fd_pr__model__cap_mim
* device instance $1228 r0 *1 149.6,17.35 sky130_fd_pr__model__cap_mim
C$1228 \$421 TOP_N|VINN 8.647288e-15 sky130_fd_pr__model__cap_mim
* device instance $1229 r0 *1 153,17.35 sky130_fd_pr__model__cap_mim
C$1229 \$419 TOP_N|VINN 8.647288e-15 sky130_fd_pr__model__cap_mim
* device instance $1230 r0 *1 156.4,17.35 sky130_fd_pr__model__cap_mim
C$1230 \$420 TOP_N|VINN 8.647288e-15 sky130_fd_pr__model__cap_mim
* device instance $1231 r0 *1 159.8,17.35 sky130_fd_pr__model__cap_mim
C$1231 \$419 TOP_N|VINN 8.647288e-15 sky130_fd_pr__model__cap_mim
* device instance $1232 r0 *1 163.2,17.35 sky130_fd_pr__model__cap_mim
C$1232 \$417 TOP_N|VINN 8.647288e-15 sky130_fd_pr__model__cap_mim
* device instance $1233 r0 *1 166.6,17.35 sky130_fd_pr__model__cap_mim
C$1233 \$419 TOP_N|VINN 8.647288e-15 sky130_fd_pr__model__cap_mim
* device instance $1234 r0 *1 170,17.35 sky130_fd_pr__model__cap_mim
C$1234 \$420 TOP_N|VINN 8.647288e-15 sky130_fd_pr__model__cap_mim
* device instance $1235 r0 *1 173.4,17.35 sky130_fd_pr__model__cap_mim
C$1235 \$419 TOP_N|VINN 8.647288e-15 sky130_fd_pr__model__cap_mim
* device instance $1236 r0 *1 176.8,17.35 sky130_fd_pr__model__cap_mim
C$1236 \$421 TOP_N|VINN 8.647288e-15 sky130_fd_pr__model__cap_mim
* device instance $1237 r0 *1 180.2,17.35 sky130_fd_pr__model__cap_mim
C$1237 \$419 TOP_N|VINN 8.647288e-15 sky130_fd_pr__model__cap_mim
* device instance $1238 r0 *1 183.6,17.35 sky130_fd_pr__model__cap_mim
C$1238 \$420 TOP_N|VINN 8.647288e-15 sky130_fd_pr__model__cap_mim
* device instance $1239 r0 *1 187,17.35 sky130_fd_pr__model__cap_mim
C$1239 \$419 TOP_N|VINN 8.647288e-15 sky130_fd_pr__model__cap_mim
* device instance $1240 r0 *1 190.4,17.35 sky130_fd_pr__model__cap_mim
C$1240 \$422 TOP_N|VINN 8.647288e-15 sky130_fd_pr__model__cap_mim
* device instance $1241 r0 *1 193.8,17.35 sky130_fd_pr__model__cap_mim
C$1241 \$419 TOP_N|VINN 8.647288e-15 sky130_fd_pr__model__cap_mim
* device instance $1242 r0 *1 197.2,17.35 sky130_fd_pr__model__cap_mim
C$1242 \$420 TOP_N|VINN 8.647288e-15 sky130_fd_pr__model__cap_mim
* device instance $1243 r0 *1 200.6,17.35 sky130_fd_pr__model__cap_mim
C$1243 \$419 TOP_N|VINN 8.647288e-15 sky130_fd_pr__model__cap_mim
* device instance $1244 r0 *1 204,17.35 sky130_fd_pr__model__cap_mim
C$1244 \$421 TOP_N|VINN 8.647288e-15 sky130_fd_pr__model__cap_mim
* device instance $1245 r0 *1 207.4,17.35 sky130_fd_pr__model__cap_mim
C$1245 \$419 TOP_N|VINN 8.647288e-15 sky130_fd_pr__model__cap_mim
* device instance $1246 r0 *1 210.8,17.35 sky130_fd_pr__model__cap_mim
C$1246 \$420 TOP_N|VINN 8.647288e-15 sky130_fd_pr__model__cap_mim
* device instance $1247 r0 *1 214.2,17.35 sky130_fd_pr__model__cap_mim
C$1247 \$419 TOP_N|VINN 8.647288e-15 sky130_fd_pr__model__cap_mim
* device instance $1248 r0 *1 0,20.75 sky130_fd_pr__model__cap_mim
C$1248 \$423 TOP_P|VINP 8.647288e-15 sky130_fd_pr__model__cap_mim
* device instance $1249 r0 *1 3.4,20.75 sky130_fd_pr__model__cap_mim
C$1249 \$424 TOP_P|VINP 8.647288e-15 sky130_fd_pr__model__cap_mim
* device instance $1250 r0 *1 6.8,20.75 sky130_fd_pr__model__cap_mim
C$1250 \$423 TOP_P|VINP 8.647288e-15 sky130_fd_pr__model__cap_mim
* device instance $1251 r0 *1 10.2,20.75 sky130_fd_pr__model__cap_mim
C$1251 \$425 TOP_P|VINP 8.647288e-15 sky130_fd_pr__model__cap_mim
* device instance $1252 r0 *1 13.6,20.75 sky130_fd_pr__model__cap_mim
C$1252 \$423 TOP_P|VINP 8.647288e-15 sky130_fd_pr__model__cap_mim
* device instance $1253 r0 *1 17,20.75 sky130_fd_pr__model__cap_mim
C$1253 \$424 TOP_P|VINP 8.647288e-15 sky130_fd_pr__model__cap_mim
* device instance $1254 r0 *1 20.4,20.75 sky130_fd_pr__model__cap_mim
C$1254 \$423 TOP_P|VINP 8.647288e-15 sky130_fd_pr__model__cap_mim
* device instance $1255 r0 *1 23.8,20.75 sky130_fd_pr__model__cap_mim
C$1255 \$412 TOP_P|VINP 8.647288e-15 sky130_fd_pr__model__cap_mim
* device instance $1256 r0 *1 27.2,20.75 sky130_fd_pr__model__cap_mim
C$1256 \$423 TOP_P|VINP 8.647288e-15 sky130_fd_pr__model__cap_mim
* device instance $1257 r0 *1 30.6,20.75 sky130_fd_pr__model__cap_mim
C$1257 \$424 TOP_P|VINP 8.647288e-15 sky130_fd_pr__model__cap_mim
* device instance $1258 r0 *1 34,20.75 sky130_fd_pr__model__cap_mim
C$1258 \$423 TOP_P|VINP 8.647288e-15 sky130_fd_pr__model__cap_mim
* device instance $1259 r0 *1 37.4,20.75 sky130_fd_pr__model__cap_mim
C$1259 \$425 TOP_P|VINP 8.647288e-15 sky130_fd_pr__model__cap_mim
* device instance $1260 r0 *1 40.8,20.75 sky130_fd_pr__model__cap_mim
C$1260 \$423 TOP_P|VINP 8.647288e-15 sky130_fd_pr__model__cap_mim
* device instance $1261 r0 *1 44.2,20.75 sky130_fd_pr__model__cap_mim
C$1261 \$424 TOP_P|VINP 8.647288e-15 sky130_fd_pr__model__cap_mim
* device instance $1262 r0 *1 47.6,20.75 sky130_fd_pr__model__cap_mim
C$1262 \$423 TOP_P|VINP 8.647288e-15 sky130_fd_pr__model__cap_mim
* device instance $1263 r0 *1 51,20.75 sky130_fd_pr__model__cap_mim
C$1263 \$411 TOP_P|VINP 8.647288e-15 sky130_fd_pr__model__cap_mim
* device instance $1264 r0 *1 54.4,20.75 sky130_fd_pr__model__cap_mim
C$1264 \$423 TOP_P|VINP 8.647288e-15 sky130_fd_pr__model__cap_mim
* device instance $1265 r0 *1 57.8,20.75 sky130_fd_pr__model__cap_mim
C$1265 \$424 TOP_P|VINP 8.647288e-15 sky130_fd_pr__model__cap_mim
* device instance $1266 r0 *1 61.2,20.75 sky130_fd_pr__model__cap_mim
C$1266 \$423 TOP_P|VINP 8.647288e-15 sky130_fd_pr__model__cap_mim
* device instance $1267 r0 *1 64.6,20.75 sky130_fd_pr__model__cap_mim
C$1267 \$425 TOP_P|VINP 8.647288e-15 sky130_fd_pr__model__cap_mim
* device instance $1268 r0 *1 68,20.75 sky130_fd_pr__model__cap_mim
C$1268 \$423 TOP_P|VINP 8.647288e-15 sky130_fd_pr__model__cap_mim
* device instance $1269 r0 *1 71.4,20.75 sky130_fd_pr__model__cap_mim
C$1269 \$424 TOP_P|VINP 8.647288e-15 sky130_fd_pr__model__cap_mim
* device instance $1270 r0 *1 74.8,20.75 sky130_fd_pr__model__cap_mim
C$1270 \$423 TOP_P|VINP 8.647288e-15 sky130_fd_pr__model__cap_mim
* device instance $1271 r0 *1 78.2,20.75 sky130_fd_pr__model__cap_mim
C$1271 \$412 TOP_P|VINP 8.647288e-15 sky130_fd_pr__model__cap_mim
* device instance $1272 r0 *1 81.6,20.75 sky130_fd_pr__model__cap_mim
C$1272 \$423 TOP_P|VINP 8.647288e-15 sky130_fd_pr__model__cap_mim
* device instance $1273 r0 *1 85,20.75 sky130_fd_pr__model__cap_mim
C$1273 \$424 TOP_P|VINP 8.647288e-15 sky130_fd_pr__model__cap_mim
* device instance $1274 r0 *1 88.4,20.75 sky130_fd_pr__model__cap_mim
C$1274 \$423 TOP_P|VINP 8.647288e-15 sky130_fd_pr__model__cap_mim
* device instance $1275 r0 *1 91.8,20.75 sky130_fd_pr__model__cap_mim
C$1275 \$425 TOP_P|VINP 8.647288e-15 sky130_fd_pr__model__cap_mim
* device instance $1276 r0 *1 95.2,20.75 sky130_fd_pr__model__cap_mim
C$1276 \$423 TOP_P|VINP 8.647288e-15 sky130_fd_pr__model__cap_mim
* device instance $1277 r0 *1 98.6,20.75 sky130_fd_pr__model__cap_mim
C$1277 \$424 TOP_P|VINP 8.647288e-15 sky130_fd_pr__model__cap_mim
* device instance $1278 r0 *1 102,20.75 sky130_fd_pr__model__cap_mim
C$1278 \$423 TOP_P|VINP 8.647288e-15 sky130_fd_pr__model__cap_mim
* device instance $1279 r0 *1 105.4,20.75 sky130_fd_pr__model__cap_mim
C$1279 \$410 TOP_P|VINP 8.647288e-15 sky130_fd_pr__model__cap_mim
* device instance $1280 r0 *1 108.8,20.75 sky130_fd_pr__model__cap_mim
C$1280 \$409 TOP_P|VINP 8.647288e-15 sky130_fd_pr__model__cap_mim
* device instance $1281 r0 *1 112.2,20.75 sky130_fd_pr__model__cap_mim
C$1281 \$423 TOP_P|VINP 8.647288e-15 sky130_fd_pr__model__cap_mim
* device instance $1282 r0 *1 115.6,20.75 sky130_fd_pr__model__cap_mim
C$1282 \$424 TOP_P|VINP 8.647288e-15 sky130_fd_pr__model__cap_mim
* device instance $1283 r0 *1 119,20.75 sky130_fd_pr__model__cap_mim
C$1283 \$423 TOP_P|VINP 8.647288e-15 sky130_fd_pr__model__cap_mim
* device instance $1284 r0 *1 122.4,20.75 sky130_fd_pr__model__cap_mim
C$1284 \$425 TOP_P|VINP 8.647288e-15 sky130_fd_pr__model__cap_mim
* device instance $1285 r0 *1 125.8,20.75 sky130_fd_pr__model__cap_mim
C$1285 \$423 TOP_P|VINP 8.647288e-15 sky130_fd_pr__model__cap_mim
* device instance $1286 r0 *1 129.2,20.75 sky130_fd_pr__model__cap_mim
C$1286 \$424 TOP_P|VINP 8.647288e-15 sky130_fd_pr__model__cap_mim
* device instance $1287 r0 *1 132.6,20.75 sky130_fd_pr__model__cap_mim
C$1287 \$423 TOP_P|VINP 8.647288e-15 sky130_fd_pr__model__cap_mim
* device instance $1288 r0 *1 136,20.75 sky130_fd_pr__model__cap_mim
C$1288 \$412 TOP_P|VINP 8.647288e-15 sky130_fd_pr__model__cap_mim
* device instance $1289 r0 *1 139.4,20.75 sky130_fd_pr__model__cap_mim
C$1289 \$423 TOP_P|VINP 8.647288e-15 sky130_fd_pr__model__cap_mim
* device instance $1290 r0 *1 142.8,20.75 sky130_fd_pr__model__cap_mim
C$1290 \$424 TOP_P|VINP 8.647288e-15 sky130_fd_pr__model__cap_mim
* device instance $1291 r0 *1 146.2,20.75 sky130_fd_pr__model__cap_mim
C$1291 \$423 TOP_P|VINP 8.647288e-15 sky130_fd_pr__model__cap_mim
* device instance $1292 r0 *1 149.6,20.75 sky130_fd_pr__model__cap_mim
C$1292 \$425 TOP_P|VINP 8.647288e-15 sky130_fd_pr__model__cap_mim
* device instance $1293 r0 *1 153,20.75 sky130_fd_pr__model__cap_mim
C$1293 \$423 TOP_P|VINP 8.647288e-15 sky130_fd_pr__model__cap_mim
* device instance $1294 r0 *1 156.4,20.75 sky130_fd_pr__model__cap_mim
C$1294 \$424 TOP_P|VINP 8.647288e-15 sky130_fd_pr__model__cap_mim
* device instance $1295 r0 *1 159.8,20.75 sky130_fd_pr__model__cap_mim
C$1295 \$423 TOP_P|VINP 8.647288e-15 sky130_fd_pr__model__cap_mim
* device instance $1296 r0 *1 163.2,20.75 sky130_fd_pr__model__cap_mim
C$1296 \$411 TOP_P|VINP 8.647288e-15 sky130_fd_pr__model__cap_mim
* device instance $1297 r0 *1 166.6,20.75 sky130_fd_pr__model__cap_mim
C$1297 \$423 TOP_P|VINP 8.647288e-15 sky130_fd_pr__model__cap_mim
* device instance $1298 r0 *1 170,20.75 sky130_fd_pr__model__cap_mim
C$1298 \$424 TOP_P|VINP 8.647288e-15 sky130_fd_pr__model__cap_mim
* device instance $1299 r0 *1 173.4,20.75 sky130_fd_pr__model__cap_mim
C$1299 \$423 TOP_P|VINP 8.647288e-15 sky130_fd_pr__model__cap_mim
* device instance $1300 r0 *1 176.8,20.75 sky130_fd_pr__model__cap_mim
C$1300 \$425 TOP_P|VINP 8.647288e-15 sky130_fd_pr__model__cap_mim
* device instance $1301 r0 *1 180.2,20.75 sky130_fd_pr__model__cap_mim
C$1301 \$423 TOP_P|VINP 8.647288e-15 sky130_fd_pr__model__cap_mim
* device instance $1302 r0 *1 183.6,20.75 sky130_fd_pr__model__cap_mim
C$1302 \$424 TOP_P|VINP 8.647288e-15 sky130_fd_pr__model__cap_mim
* device instance $1303 r0 *1 187,20.75 sky130_fd_pr__model__cap_mim
C$1303 \$423 TOP_P|VINP 8.647288e-15 sky130_fd_pr__model__cap_mim
* device instance $1304 r0 *1 190.4,20.75 sky130_fd_pr__model__cap_mim
C$1304 \$412 TOP_P|VINP 8.647288e-15 sky130_fd_pr__model__cap_mim
* device instance $1305 r0 *1 193.8,20.75 sky130_fd_pr__model__cap_mim
C$1305 \$423 TOP_P|VINP 8.647288e-15 sky130_fd_pr__model__cap_mim
* device instance $1306 r0 *1 197.2,20.75 sky130_fd_pr__model__cap_mim
C$1306 \$424 TOP_P|VINP 8.647288e-15 sky130_fd_pr__model__cap_mim
* device instance $1307 r0 *1 200.6,20.75 sky130_fd_pr__model__cap_mim
C$1307 \$423 TOP_P|VINP 8.647288e-15 sky130_fd_pr__model__cap_mim
* device instance $1308 r0 *1 204,20.75 sky130_fd_pr__model__cap_mim
C$1308 \$425 TOP_P|VINP 8.647288e-15 sky130_fd_pr__model__cap_mim
* device instance $1309 r0 *1 207.4,20.75 sky130_fd_pr__model__cap_mim
C$1309 \$423 TOP_P|VINP 8.647288e-15 sky130_fd_pr__model__cap_mim
* device instance $1310 r0 *1 210.8,20.75 sky130_fd_pr__model__cap_mim
C$1310 \$424 TOP_P|VINP 8.647288e-15 sky130_fd_pr__model__cap_mim
* device instance $1311 r0 *1 214.2,20.75 sky130_fd_pr__model__cap_mim
C$1311 \$423 TOP_P|VINP 8.647288e-15 sky130_fd_pr__model__cap_mim
* device instance $1312 r0 *1 0,24.15 sky130_fd_pr__model__cap_mim
C$1312 \$419 TOP_N|VINN 8.647288e-15 sky130_fd_pr__model__cap_mim
* device instance $1313 r0 *1 3.4,24.15 sky130_fd_pr__model__cap_mim
C$1313 \$420 TOP_N|VINN 8.647288e-15 sky130_fd_pr__model__cap_mim
* device instance $1314 r0 *1 6.8,24.15 sky130_fd_pr__model__cap_mim
C$1314 \$419 TOP_N|VINN 8.647288e-15 sky130_fd_pr__model__cap_mim
* device instance $1315 r0 *1 10.2,24.15 sky130_fd_pr__model__cap_mim
C$1315 \$421 TOP_N|VINN 8.647288e-15 sky130_fd_pr__model__cap_mim
* device instance $1316 r0 *1 13.6,24.15 sky130_fd_pr__model__cap_mim
C$1316 \$419 TOP_N|VINN 8.647288e-15 sky130_fd_pr__model__cap_mim
* device instance $1317 r0 *1 17,24.15 sky130_fd_pr__model__cap_mim
C$1317 \$420 TOP_N|VINN 8.647288e-15 sky130_fd_pr__model__cap_mim
* device instance $1318 r0 *1 20.4,24.15 sky130_fd_pr__model__cap_mim
C$1318 \$419 TOP_N|VINN 8.647288e-15 sky130_fd_pr__model__cap_mim
* device instance $1319 r0 *1 23.8,24.15 sky130_fd_pr__model__cap_mim
C$1319 \$422 TOP_N|VINN 8.647288e-15 sky130_fd_pr__model__cap_mim
* device instance $1320 r0 *1 27.2,24.15 sky130_fd_pr__model__cap_mim
C$1320 \$419 TOP_N|VINN 8.647288e-15 sky130_fd_pr__model__cap_mim
* device instance $1321 r0 *1 30.6,24.15 sky130_fd_pr__model__cap_mim
C$1321 \$420 TOP_N|VINN 8.647288e-15 sky130_fd_pr__model__cap_mim
* device instance $1322 r0 *1 34,24.15 sky130_fd_pr__model__cap_mim
C$1322 \$419 TOP_N|VINN 8.647288e-15 sky130_fd_pr__model__cap_mim
* device instance $1323 r0 *1 37.4,24.15 sky130_fd_pr__model__cap_mim
C$1323 \$421 TOP_N|VINN 8.647288e-15 sky130_fd_pr__model__cap_mim
* device instance $1324 r0 *1 40.8,24.15 sky130_fd_pr__model__cap_mim
C$1324 \$419 TOP_N|VINN 8.647288e-15 sky130_fd_pr__model__cap_mim
* device instance $1325 r0 *1 44.2,24.15 sky130_fd_pr__model__cap_mim
C$1325 \$420 TOP_N|VINN 8.647288e-15 sky130_fd_pr__model__cap_mim
* device instance $1326 r0 *1 47.6,24.15 sky130_fd_pr__model__cap_mim
C$1326 \$419 TOP_N|VINN 8.647288e-15 sky130_fd_pr__model__cap_mim
* device instance $1327 r0 *1 51,24.15 sky130_fd_pr__model__cap_mim
C$1327 \$417 TOP_N|VINN 8.647288e-15 sky130_fd_pr__model__cap_mim
* device instance $1328 r0 *1 54.4,24.15 sky130_fd_pr__model__cap_mim
C$1328 \$419 TOP_N|VINN 8.647288e-15 sky130_fd_pr__model__cap_mim
* device instance $1329 r0 *1 57.8,24.15 sky130_fd_pr__model__cap_mim
C$1329 \$420 TOP_N|VINN 8.647288e-15 sky130_fd_pr__model__cap_mim
* device instance $1330 r0 *1 61.2,24.15 sky130_fd_pr__model__cap_mim
C$1330 \$419 TOP_N|VINN 8.647288e-15 sky130_fd_pr__model__cap_mim
* device instance $1331 r0 *1 64.6,24.15 sky130_fd_pr__model__cap_mim
C$1331 \$421 TOP_N|VINN 8.647288e-15 sky130_fd_pr__model__cap_mim
* device instance $1332 r0 *1 68,24.15 sky130_fd_pr__model__cap_mim
C$1332 \$419 TOP_N|VINN 8.647288e-15 sky130_fd_pr__model__cap_mim
* device instance $1333 r0 *1 71.4,24.15 sky130_fd_pr__model__cap_mim
C$1333 \$420 TOP_N|VINN 8.647288e-15 sky130_fd_pr__model__cap_mim
* device instance $1334 r0 *1 74.8,24.15 sky130_fd_pr__model__cap_mim
C$1334 \$419 TOP_N|VINN 8.647288e-15 sky130_fd_pr__model__cap_mim
* device instance $1335 r0 *1 78.2,24.15 sky130_fd_pr__model__cap_mim
C$1335 \$422 TOP_N|VINN 8.647288e-15 sky130_fd_pr__model__cap_mim
* device instance $1336 r0 *1 81.6,24.15 sky130_fd_pr__model__cap_mim
C$1336 \$419 TOP_N|VINN 8.647288e-15 sky130_fd_pr__model__cap_mim
* device instance $1337 r0 *1 85,24.15 sky130_fd_pr__model__cap_mim
C$1337 \$420 TOP_N|VINN 8.647288e-15 sky130_fd_pr__model__cap_mim
* device instance $1338 r0 *1 88.4,24.15 sky130_fd_pr__model__cap_mim
C$1338 \$419 TOP_N|VINN 8.647288e-15 sky130_fd_pr__model__cap_mim
* device instance $1339 r0 *1 91.8,24.15 sky130_fd_pr__model__cap_mim
C$1339 \$421 TOP_N|VINN 8.647288e-15 sky130_fd_pr__model__cap_mim
* device instance $1340 r0 *1 95.2,24.15 sky130_fd_pr__model__cap_mim
C$1340 \$419 TOP_N|VINN 8.647288e-15 sky130_fd_pr__model__cap_mim
* device instance $1341 r0 *1 98.6,24.15 sky130_fd_pr__model__cap_mim
C$1341 \$420 TOP_N|VINN 8.647288e-15 sky130_fd_pr__model__cap_mim
* device instance $1342 r0 *1 102,24.15 sky130_fd_pr__model__cap_mim
C$1342 \$419 TOP_N|VINN 8.647288e-15 sky130_fd_pr__model__cap_mim
* device instance $1343 r0 *1 105.4,24.15 sky130_fd_pr__model__cap_mim
C$1343 \$416 TOP_N|VINN 8.647288e-15 sky130_fd_pr__model__cap_mim
* device instance $1344 r0 *1 108.8,24.15 sky130_fd_pr__model__cap_mim
C$1344 \$415 TOP_N|VINN 8.647288e-15 sky130_fd_pr__model__cap_mim
* device instance $1345 r0 *1 112.2,24.15 sky130_fd_pr__model__cap_mim
C$1345 \$419 TOP_N|VINN 8.647288e-15 sky130_fd_pr__model__cap_mim
* device instance $1346 r0 *1 115.6,24.15 sky130_fd_pr__model__cap_mim
C$1346 \$420 TOP_N|VINN 8.647288e-15 sky130_fd_pr__model__cap_mim
* device instance $1347 r0 *1 119,24.15 sky130_fd_pr__model__cap_mim
C$1347 \$419 TOP_N|VINN 8.647288e-15 sky130_fd_pr__model__cap_mim
* device instance $1348 r0 *1 122.4,24.15 sky130_fd_pr__model__cap_mim
C$1348 \$421 TOP_N|VINN 8.647288e-15 sky130_fd_pr__model__cap_mim
* device instance $1349 r0 *1 125.8,24.15 sky130_fd_pr__model__cap_mim
C$1349 \$419 TOP_N|VINN 8.647288e-15 sky130_fd_pr__model__cap_mim
* device instance $1350 r0 *1 129.2,24.15 sky130_fd_pr__model__cap_mim
C$1350 \$420 TOP_N|VINN 8.647288e-15 sky130_fd_pr__model__cap_mim
* device instance $1351 r0 *1 132.6,24.15 sky130_fd_pr__model__cap_mim
C$1351 \$419 TOP_N|VINN 8.647288e-15 sky130_fd_pr__model__cap_mim
* device instance $1352 r0 *1 136,24.15 sky130_fd_pr__model__cap_mim
C$1352 \$422 TOP_N|VINN 8.647288e-15 sky130_fd_pr__model__cap_mim
* device instance $1353 r0 *1 139.4,24.15 sky130_fd_pr__model__cap_mim
C$1353 \$419 TOP_N|VINN 8.647288e-15 sky130_fd_pr__model__cap_mim
* device instance $1354 r0 *1 142.8,24.15 sky130_fd_pr__model__cap_mim
C$1354 \$420 TOP_N|VINN 8.647288e-15 sky130_fd_pr__model__cap_mim
* device instance $1355 r0 *1 146.2,24.15 sky130_fd_pr__model__cap_mim
C$1355 \$419 TOP_N|VINN 8.647288e-15 sky130_fd_pr__model__cap_mim
* device instance $1356 r0 *1 149.6,24.15 sky130_fd_pr__model__cap_mim
C$1356 \$421 TOP_N|VINN 8.647288e-15 sky130_fd_pr__model__cap_mim
* device instance $1357 r0 *1 153,24.15 sky130_fd_pr__model__cap_mim
C$1357 \$419 TOP_N|VINN 8.647288e-15 sky130_fd_pr__model__cap_mim
* device instance $1358 r0 *1 156.4,24.15 sky130_fd_pr__model__cap_mim
C$1358 \$420 TOP_N|VINN 8.647288e-15 sky130_fd_pr__model__cap_mim
* device instance $1359 r0 *1 159.8,24.15 sky130_fd_pr__model__cap_mim
C$1359 \$419 TOP_N|VINN 8.647288e-15 sky130_fd_pr__model__cap_mim
* device instance $1360 r0 *1 163.2,24.15 sky130_fd_pr__model__cap_mim
C$1360 \$417 TOP_N|VINN 8.647288e-15 sky130_fd_pr__model__cap_mim
* device instance $1361 r0 *1 166.6,24.15 sky130_fd_pr__model__cap_mim
C$1361 \$419 TOP_N|VINN 8.647288e-15 sky130_fd_pr__model__cap_mim
* device instance $1362 r0 *1 170,24.15 sky130_fd_pr__model__cap_mim
C$1362 \$420 TOP_N|VINN 8.647288e-15 sky130_fd_pr__model__cap_mim
* device instance $1363 r0 *1 173.4,24.15 sky130_fd_pr__model__cap_mim
C$1363 \$419 TOP_N|VINN 8.647288e-15 sky130_fd_pr__model__cap_mim
* device instance $1364 r0 *1 176.8,24.15 sky130_fd_pr__model__cap_mim
C$1364 \$421 TOP_N|VINN 8.647288e-15 sky130_fd_pr__model__cap_mim
* device instance $1365 r0 *1 180.2,24.15 sky130_fd_pr__model__cap_mim
C$1365 \$419 TOP_N|VINN 8.647288e-15 sky130_fd_pr__model__cap_mim
* device instance $1366 r0 *1 183.6,24.15 sky130_fd_pr__model__cap_mim
C$1366 \$420 TOP_N|VINN 8.647288e-15 sky130_fd_pr__model__cap_mim
* device instance $1367 r0 *1 187,24.15 sky130_fd_pr__model__cap_mim
C$1367 \$419 TOP_N|VINN 8.647288e-15 sky130_fd_pr__model__cap_mim
* device instance $1368 r0 *1 190.4,24.15 sky130_fd_pr__model__cap_mim
C$1368 \$422 TOP_N|VINN 8.647288e-15 sky130_fd_pr__model__cap_mim
* device instance $1369 r0 *1 193.8,24.15 sky130_fd_pr__model__cap_mim
C$1369 \$419 TOP_N|VINN 8.647288e-15 sky130_fd_pr__model__cap_mim
* device instance $1370 r0 *1 197.2,24.15 sky130_fd_pr__model__cap_mim
C$1370 \$420 TOP_N|VINN 8.647288e-15 sky130_fd_pr__model__cap_mim
* device instance $1371 r0 *1 200.6,24.15 sky130_fd_pr__model__cap_mim
C$1371 \$419 TOP_N|VINN 8.647288e-15 sky130_fd_pr__model__cap_mim
* device instance $1372 r0 *1 204,24.15 sky130_fd_pr__model__cap_mim
C$1372 \$421 TOP_N|VINN 8.647288e-15 sky130_fd_pr__model__cap_mim
* device instance $1373 r0 *1 207.4,24.15 sky130_fd_pr__model__cap_mim
C$1373 \$419 TOP_N|VINN 8.647288e-15 sky130_fd_pr__model__cap_mim
* device instance $1374 r0 *1 210.8,24.15 sky130_fd_pr__model__cap_mim
C$1374 \$420 TOP_N|VINN 8.647288e-15 sky130_fd_pr__model__cap_mim
* device instance $1375 r0 *1 214.2,24.15 sky130_fd_pr__model__cap_mim
C$1375 \$419 TOP_N|VINN 8.647288e-15 sky130_fd_pr__model__cap_mim
* device instance $1376 r0 *1 0,27.55 sky130_fd_pr__model__cap_mim
C$1376 \$419 TOP_N|VINN 8.647288e-15 sky130_fd_pr__model__cap_mim
* device instance $1377 r0 *1 3.4,27.55 sky130_fd_pr__model__cap_mim
C$1377 \$420 TOP_N|VINN 8.647288e-15 sky130_fd_pr__model__cap_mim
* device instance $1378 r0 *1 6.8,27.55 sky130_fd_pr__model__cap_mim
C$1378 \$419 TOP_N|VINN 8.647288e-15 sky130_fd_pr__model__cap_mim
* device instance $1379 r0 *1 10.2,27.55 sky130_fd_pr__model__cap_mim
C$1379 \$421 TOP_N|VINN 8.647288e-15 sky130_fd_pr__model__cap_mim
* device instance $1380 r0 *1 13.6,27.55 sky130_fd_pr__model__cap_mim
C$1380 \$419 TOP_N|VINN 8.647288e-15 sky130_fd_pr__model__cap_mim
* device instance $1381 r0 *1 17,27.55 sky130_fd_pr__model__cap_mim
C$1381 \$420 TOP_N|VINN 8.647288e-15 sky130_fd_pr__model__cap_mim
* device instance $1382 r0 *1 20.4,27.55 sky130_fd_pr__model__cap_mim
C$1382 \$419 TOP_N|VINN 8.647288e-15 sky130_fd_pr__model__cap_mim
* device instance $1383 r0 *1 23.8,27.55 sky130_fd_pr__model__cap_mim
C$1383 \$422 TOP_N|VINN 8.647288e-15 sky130_fd_pr__model__cap_mim
* device instance $1384 r0 *1 27.2,27.55 sky130_fd_pr__model__cap_mim
C$1384 \$419 TOP_N|VINN 8.647288e-15 sky130_fd_pr__model__cap_mim
* device instance $1385 r0 *1 30.6,27.55 sky130_fd_pr__model__cap_mim
C$1385 \$420 TOP_N|VINN 8.647288e-15 sky130_fd_pr__model__cap_mim
* device instance $1386 r0 *1 34,27.55 sky130_fd_pr__model__cap_mim
C$1386 \$419 TOP_N|VINN 8.647288e-15 sky130_fd_pr__model__cap_mim
* device instance $1387 r0 *1 37.4,27.55 sky130_fd_pr__model__cap_mim
C$1387 \$421 TOP_N|VINN 8.647288e-15 sky130_fd_pr__model__cap_mim
* device instance $1388 r0 *1 40.8,27.55 sky130_fd_pr__model__cap_mim
C$1388 \$419 TOP_N|VINN 8.647288e-15 sky130_fd_pr__model__cap_mim
* device instance $1389 r0 *1 44.2,27.55 sky130_fd_pr__model__cap_mim
C$1389 \$420 TOP_N|VINN 8.647288e-15 sky130_fd_pr__model__cap_mim
* device instance $1390 r0 *1 47.6,27.55 sky130_fd_pr__model__cap_mim
C$1390 \$419 TOP_N|VINN 8.647288e-15 sky130_fd_pr__model__cap_mim
* device instance $1391 r0 *1 51,27.55 sky130_fd_pr__model__cap_mim
C$1391 \$417 TOP_N|VINN 8.647288e-15 sky130_fd_pr__model__cap_mim
* device instance $1392 r0 *1 54.4,27.55 sky130_fd_pr__model__cap_mim
C$1392 \$419 TOP_N|VINN 8.647288e-15 sky130_fd_pr__model__cap_mim
* device instance $1393 r0 *1 57.8,27.55 sky130_fd_pr__model__cap_mim
C$1393 \$420 TOP_N|VINN 8.647288e-15 sky130_fd_pr__model__cap_mim
* device instance $1394 r0 *1 61.2,27.55 sky130_fd_pr__model__cap_mim
C$1394 \$419 TOP_N|VINN 8.647288e-15 sky130_fd_pr__model__cap_mim
* device instance $1395 r0 *1 64.6,27.55 sky130_fd_pr__model__cap_mim
C$1395 \$421 TOP_N|VINN 8.647288e-15 sky130_fd_pr__model__cap_mim
* device instance $1396 r0 *1 68,27.55 sky130_fd_pr__model__cap_mim
C$1396 \$419 TOP_N|VINN 8.647288e-15 sky130_fd_pr__model__cap_mim
* device instance $1397 r0 *1 71.4,27.55 sky130_fd_pr__model__cap_mim
C$1397 \$420 TOP_N|VINN 8.647288e-15 sky130_fd_pr__model__cap_mim
* device instance $1398 r0 *1 74.8,27.55 sky130_fd_pr__model__cap_mim
C$1398 \$419 TOP_N|VINN 8.647288e-15 sky130_fd_pr__model__cap_mim
* device instance $1399 r0 *1 78.2,27.55 sky130_fd_pr__model__cap_mim
C$1399 \$422 TOP_N|VINN 8.647288e-15 sky130_fd_pr__model__cap_mim
* device instance $1400 r0 *1 81.6,27.55 sky130_fd_pr__model__cap_mim
C$1400 \$419 TOP_N|VINN 8.647288e-15 sky130_fd_pr__model__cap_mim
* device instance $1401 r0 *1 85,27.55 sky130_fd_pr__model__cap_mim
C$1401 \$420 TOP_N|VINN 8.647288e-15 sky130_fd_pr__model__cap_mim
* device instance $1402 r0 *1 88.4,27.55 sky130_fd_pr__model__cap_mim
C$1402 \$419 TOP_N|VINN 8.647288e-15 sky130_fd_pr__model__cap_mim
* device instance $1403 r0 *1 91.8,27.55 sky130_fd_pr__model__cap_mim
C$1403 \$421 TOP_N|VINN 8.647288e-15 sky130_fd_pr__model__cap_mim
* device instance $1404 r0 *1 95.2,27.55 sky130_fd_pr__model__cap_mim
C$1404 \$419 TOP_N|VINN 8.647288e-15 sky130_fd_pr__model__cap_mim
* device instance $1405 r0 *1 98.6,27.55 sky130_fd_pr__model__cap_mim
C$1405 \$420 TOP_N|VINN 8.647288e-15 sky130_fd_pr__model__cap_mim
* device instance $1406 r0 *1 102,27.55 sky130_fd_pr__model__cap_mim
C$1406 \$419 TOP_N|VINN 8.647288e-15 sky130_fd_pr__model__cap_mim
* device instance $1407 r0 *1 105.4,27.55 sky130_fd_pr__model__cap_mim
C$1407 \$416 TOP_N|VINN 8.647288e-15 sky130_fd_pr__model__cap_mim
* device instance $1408 r0 *1 108.8,27.55 sky130_fd_pr__model__cap_mim
C$1408 \$415 TOP_N|VINN 8.647288e-15 sky130_fd_pr__model__cap_mim
* device instance $1409 r0 *1 112.2,27.55 sky130_fd_pr__model__cap_mim
C$1409 \$419 TOP_N|VINN 8.647288e-15 sky130_fd_pr__model__cap_mim
* device instance $1410 r0 *1 115.6,27.55 sky130_fd_pr__model__cap_mim
C$1410 \$420 TOP_N|VINN 8.647288e-15 sky130_fd_pr__model__cap_mim
* device instance $1411 r0 *1 119,27.55 sky130_fd_pr__model__cap_mim
C$1411 \$419 TOP_N|VINN 8.647288e-15 sky130_fd_pr__model__cap_mim
* device instance $1412 r0 *1 122.4,27.55 sky130_fd_pr__model__cap_mim
C$1412 \$421 TOP_N|VINN 8.647288e-15 sky130_fd_pr__model__cap_mim
* device instance $1413 r0 *1 125.8,27.55 sky130_fd_pr__model__cap_mim
C$1413 \$419 TOP_N|VINN 8.647288e-15 sky130_fd_pr__model__cap_mim
* device instance $1414 r0 *1 129.2,27.55 sky130_fd_pr__model__cap_mim
C$1414 \$420 TOP_N|VINN 8.647288e-15 sky130_fd_pr__model__cap_mim
* device instance $1415 r0 *1 132.6,27.55 sky130_fd_pr__model__cap_mim
C$1415 \$419 TOP_N|VINN 8.647288e-15 sky130_fd_pr__model__cap_mim
* device instance $1416 r0 *1 136,27.55 sky130_fd_pr__model__cap_mim
C$1416 \$422 TOP_N|VINN 8.647288e-15 sky130_fd_pr__model__cap_mim
* device instance $1417 r0 *1 139.4,27.55 sky130_fd_pr__model__cap_mim
C$1417 \$419 TOP_N|VINN 8.647288e-15 sky130_fd_pr__model__cap_mim
* device instance $1418 r0 *1 142.8,27.55 sky130_fd_pr__model__cap_mim
C$1418 \$420 TOP_N|VINN 8.647288e-15 sky130_fd_pr__model__cap_mim
* device instance $1419 r0 *1 146.2,27.55 sky130_fd_pr__model__cap_mim
C$1419 \$419 TOP_N|VINN 8.647288e-15 sky130_fd_pr__model__cap_mim
* device instance $1420 r0 *1 149.6,27.55 sky130_fd_pr__model__cap_mim
C$1420 \$421 TOP_N|VINN 8.647288e-15 sky130_fd_pr__model__cap_mim
* device instance $1421 r0 *1 153,27.55 sky130_fd_pr__model__cap_mim
C$1421 \$419 TOP_N|VINN 8.647288e-15 sky130_fd_pr__model__cap_mim
* device instance $1422 r0 *1 156.4,27.55 sky130_fd_pr__model__cap_mim
C$1422 \$420 TOP_N|VINN 8.647288e-15 sky130_fd_pr__model__cap_mim
* device instance $1423 r0 *1 159.8,27.55 sky130_fd_pr__model__cap_mim
C$1423 \$419 TOP_N|VINN 8.647288e-15 sky130_fd_pr__model__cap_mim
* device instance $1424 r0 *1 163.2,27.55 sky130_fd_pr__model__cap_mim
C$1424 \$417 TOP_N|VINN 8.647288e-15 sky130_fd_pr__model__cap_mim
* device instance $1425 r0 *1 166.6,27.55 sky130_fd_pr__model__cap_mim
C$1425 \$419 TOP_N|VINN 8.647288e-15 sky130_fd_pr__model__cap_mim
* device instance $1426 r0 *1 170,27.55 sky130_fd_pr__model__cap_mim
C$1426 \$420 TOP_N|VINN 8.647288e-15 sky130_fd_pr__model__cap_mim
* device instance $1427 r0 *1 173.4,27.55 sky130_fd_pr__model__cap_mim
C$1427 \$419 TOP_N|VINN 8.647288e-15 sky130_fd_pr__model__cap_mim
* device instance $1428 r0 *1 176.8,27.55 sky130_fd_pr__model__cap_mim
C$1428 \$421 TOP_N|VINN 8.647288e-15 sky130_fd_pr__model__cap_mim
* device instance $1429 r0 *1 180.2,27.55 sky130_fd_pr__model__cap_mim
C$1429 \$419 TOP_N|VINN 8.647288e-15 sky130_fd_pr__model__cap_mim
* device instance $1430 r0 *1 183.6,27.55 sky130_fd_pr__model__cap_mim
C$1430 \$420 TOP_N|VINN 8.647288e-15 sky130_fd_pr__model__cap_mim
* device instance $1431 r0 *1 187,27.55 sky130_fd_pr__model__cap_mim
C$1431 \$419 TOP_N|VINN 8.647288e-15 sky130_fd_pr__model__cap_mim
* device instance $1432 r0 *1 190.4,27.55 sky130_fd_pr__model__cap_mim
C$1432 \$422 TOP_N|VINN 8.647288e-15 sky130_fd_pr__model__cap_mim
* device instance $1433 r0 *1 193.8,27.55 sky130_fd_pr__model__cap_mim
C$1433 \$419 TOP_N|VINN 8.647288e-15 sky130_fd_pr__model__cap_mim
* device instance $1434 r0 *1 197.2,27.55 sky130_fd_pr__model__cap_mim
C$1434 \$420 TOP_N|VINN 8.647288e-15 sky130_fd_pr__model__cap_mim
* device instance $1435 r0 *1 200.6,27.55 sky130_fd_pr__model__cap_mim
C$1435 \$419 TOP_N|VINN 8.647288e-15 sky130_fd_pr__model__cap_mim
* device instance $1436 r0 *1 204,27.55 sky130_fd_pr__model__cap_mim
C$1436 \$421 TOP_N|VINN 8.647288e-15 sky130_fd_pr__model__cap_mim
* device instance $1437 r0 *1 207.4,27.55 sky130_fd_pr__model__cap_mim
C$1437 \$419 TOP_N|VINN 8.647288e-15 sky130_fd_pr__model__cap_mim
* device instance $1438 r0 *1 210.8,27.55 sky130_fd_pr__model__cap_mim
C$1438 \$420 TOP_N|VINN 8.647288e-15 sky130_fd_pr__model__cap_mim
* device instance $1439 r0 *1 214.2,27.55 sky130_fd_pr__model__cap_mim
C$1439 \$419 TOP_N|VINN 8.647288e-15 sky130_fd_pr__model__cap_mim
* device instance $1440 r0 *1 0,30.95 sky130_fd_pr__model__cap_mim
C$1440 \$423 TOP_P|VINP 8.647288e-15 sky130_fd_pr__model__cap_mim
* device instance $1441 r0 *1 3.4,30.95 sky130_fd_pr__model__cap_mim
C$1441 \$424 TOP_P|VINP 8.647288e-15 sky130_fd_pr__model__cap_mim
* device instance $1442 r0 *1 6.8,30.95 sky130_fd_pr__model__cap_mim
C$1442 \$423 TOP_P|VINP 8.647288e-15 sky130_fd_pr__model__cap_mim
* device instance $1443 r0 *1 10.2,30.95 sky130_fd_pr__model__cap_mim
C$1443 \$425 TOP_P|VINP 8.647288e-15 sky130_fd_pr__model__cap_mim
* device instance $1444 r0 *1 13.6,30.95 sky130_fd_pr__model__cap_mim
C$1444 \$423 TOP_P|VINP 8.647288e-15 sky130_fd_pr__model__cap_mim
* device instance $1445 r0 *1 17,30.95 sky130_fd_pr__model__cap_mim
C$1445 \$424 TOP_P|VINP 8.647288e-15 sky130_fd_pr__model__cap_mim
* device instance $1446 r0 *1 20.4,30.95 sky130_fd_pr__model__cap_mim
C$1446 \$423 TOP_P|VINP 8.647288e-15 sky130_fd_pr__model__cap_mim
* device instance $1447 r0 *1 23.8,30.95 sky130_fd_pr__model__cap_mim
C$1447 \$412 TOP_P|VINP 8.647288e-15 sky130_fd_pr__model__cap_mim
* device instance $1448 r0 *1 27.2,30.95 sky130_fd_pr__model__cap_mim
C$1448 \$423 TOP_P|VINP 8.647288e-15 sky130_fd_pr__model__cap_mim
* device instance $1449 r0 *1 30.6,30.95 sky130_fd_pr__model__cap_mim
C$1449 \$424 TOP_P|VINP 8.647288e-15 sky130_fd_pr__model__cap_mim
* device instance $1450 r0 *1 34,30.95 sky130_fd_pr__model__cap_mim
C$1450 \$423 TOP_P|VINP 8.647288e-15 sky130_fd_pr__model__cap_mim
* device instance $1451 r0 *1 37.4,30.95 sky130_fd_pr__model__cap_mim
C$1451 \$425 TOP_P|VINP 8.647288e-15 sky130_fd_pr__model__cap_mim
* device instance $1452 r0 *1 40.8,30.95 sky130_fd_pr__model__cap_mim
C$1452 \$423 TOP_P|VINP 8.647288e-15 sky130_fd_pr__model__cap_mim
* device instance $1453 r0 *1 44.2,30.95 sky130_fd_pr__model__cap_mim
C$1453 \$424 TOP_P|VINP 8.647288e-15 sky130_fd_pr__model__cap_mim
* device instance $1454 r0 *1 47.6,30.95 sky130_fd_pr__model__cap_mim
C$1454 \$423 TOP_P|VINP 8.647288e-15 sky130_fd_pr__model__cap_mim
* device instance $1455 r0 *1 51,30.95 sky130_fd_pr__model__cap_mim
C$1455 \$411 TOP_P|VINP 8.647288e-15 sky130_fd_pr__model__cap_mim
* device instance $1456 r0 *1 54.4,30.95 sky130_fd_pr__model__cap_mim
C$1456 \$423 TOP_P|VINP 8.647288e-15 sky130_fd_pr__model__cap_mim
* device instance $1457 r0 *1 57.8,30.95 sky130_fd_pr__model__cap_mim
C$1457 \$424 TOP_P|VINP 8.647288e-15 sky130_fd_pr__model__cap_mim
* device instance $1458 r0 *1 61.2,30.95 sky130_fd_pr__model__cap_mim
C$1458 \$423 TOP_P|VINP 8.647288e-15 sky130_fd_pr__model__cap_mim
* device instance $1459 r0 *1 64.6,30.95 sky130_fd_pr__model__cap_mim
C$1459 \$425 TOP_P|VINP 8.647288e-15 sky130_fd_pr__model__cap_mim
* device instance $1460 r0 *1 68,30.95 sky130_fd_pr__model__cap_mim
C$1460 \$423 TOP_P|VINP 8.647288e-15 sky130_fd_pr__model__cap_mim
* device instance $1461 r0 *1 71.4,30.95 sky130_fd_pr__model__cap_mim
C$1461 \$424 TOP_P|VINP 8.647288e-15 sky130_fd_pr__model__cap_mim
* device instance $1462 r0 *1 74.8,30.95 sky130_fd_pr__model__cap_mim
C$1462 \$423 TOP_P|VINP 8.647288e-15 sky130_fd_pr__model__cap_mim
* device instance $1463 r0 *1 78.2,30.95 sky130_fd_pr__model__cap_mim
C$1463 \$412 TOP_P|VINP 8.647288e-15 sky130_fd_pr__model__cap_mim
* device instance $1464 r0 *1 81.6,30.95 sky130_fd_pr__model__cap_mim
C$1464 \$423 TOP_P|VINP 8.647288e-15 sky130_fd_pr__model__cap_mim
* device instance $1465 r0 *1 85,30.95 sky130_fd_pr__model__cap_mim
C$1465 \$424 TOP_P|VINP 8.647288e-15 sky130_fd_pr__model__cap_mim
* device instance $1466 r0 *1 88.4,30.95 sky130_fd_pr__model__cap_mim
C$1466 \$423 TOP_P|VINP 8.647288e-15 sky130_fd_pr__model__cap_mim
* device instance $1467 r0 *1 91.8,30.95 sky130_fd_pr__model__cap_mim
C$1467 \$425 TOP_P|VINP 8.647288e-15 sky130_fd_pr__model__cap_mim
* device instance $1468 r0 *1 95.2,30.95 sky130_fd_pr__model__cap_mim
C$1468 \$423 TOP_P|VINP 8.647288e-15 sky130_fd_pr__model__cap_mim
* device instance $1469 r0 *1 98.6,30.95 sky130_fd_pr__model__cap_mim
C$1469 \$424 TOP_P|VINP 8.647288e-15 sky130_fd_pr__model__cap_mim
* device instance $1470 r0 *1 102,30.95 sky130_fd_pr__model__cap_mim
C$1470 \$423 TOP_P|VINP 8.647288e-15 sky130_fd_pr__model__cap_mim
* device instance $1471 r0 *1 105.4,30.95 sky130_fd_pr__model__cap_mim
C$1471 \$410 TOP_P|VINP 8.647288e-15 sky130_fd_pr__model__cap_mim
* device instance $1472 r0 *1 108.8,30.95 sky130_fd_pr__model__cap_mim
C$1472 \$409 TOP_P|VINP 8.647288e-15 sky130_fd_pr__model__cap_mim
* device instance $1473 r0 *1 112.2,30.95 sky130_fd_pr__model__cap_mim
C$1473 \$423 TOP_P|VINP 8.647288e-15 sky130_fd_pr__model__cap_mim
* device instance $1474 r0 *1 115.6,30.95 sky130_fd_pr__model__cap_mim
C$1474 \$424 TOP_P|VINP 8.647288e-15 sky130_fd_pr__model__cap_mim
* device instance $1475 r0 *1 119,30.95 sky130_fd_pr__model__cap_mim
C$1475 \$423 TOP_P|VINP 8.647288e-15 sky130_fd_pr__model__cap_mim
* device instance $1476 r0 *1 122.4,30.95 sky130_fd_pr__model__cap_mim
C$1476 \$425 TOP_P|VINP 8.647288e-15 sky130_fd_pr__model__cap_mim
* device instance $1477 r0 *1 125.8,30.95 sky130_fd_pr__model__cap_mim
C$1477 \$423 TOP_P|VINP 8.647288e-15 sky130_fd_pr__model__cap_mim
* device instance $1478 r0 *1 129.2,30.95 sky130_fd_pr__model__cap_mim
C$1478 \$424 TOP_P|VINP 8.647288e-15 sky130_fd_pr__model__cap_mim
* device instance $1479 r0 *1 132.6,30.95 sky130_fd_pr__model__cap_mim
C$1479 \$423 TOP_P|VINP 8.647288e-15 sky130_fd_pr__model__cap_mim
* device instance $1480 r0 *1 136,30.95 sky130_fd_pr__model__cap_mim
C$1480 \$412 TOP_P|VINP 8.647288e-15 sky130_fd_pr__model__cap_mim
* device instance $1481 r0 *1 139.4,30.95 sky130_fd_pr__model__cap_mim
C$1481 \$423 TOP_P|VINP 8.647288e-15 sky130_fd_pr__model__cap_mim
* device instance $1482 r0 *1 142.8,30.95 sky130_fd_pr__model__cap_mim
C$1482 \$424 TOP_P|VINP 8.647288e-15 sky130_fd_pr__model__cap_mim
* device instance $1483 r0 *1 146.2,30.95 sky130_fd_pr__model__cap_mim
C$1483 \$423 TOP_P|VINP 8.647288e-15 sky130_fd_pr__model__cap_mim
* device instance $1484 r0 *1 149.6,30.95 sky130_fd_pr__model__cap_mim
C$1484 \$425 TOP_P|VINP 8.647288e-15 sky130_fd_pr__model__cap_mim
* device instance $1485 r0 *1 153,30.95 sky130_fd_pr__model__cap_mim
C$1485 \$423 TOP_P|VINP 8.647288e-15 sky130_fd_pr__model__cap_mim
* device instance $1486 r0 *1 156.4,30.95 sky130_fd_pr__model__cap_mim
C$1486 \$424 TOP_P|VINP 8.647288e-15 sky130_fd_pr__model__cap_mim
* device instance $1487 r0 *1 159.8,30.95 sky130_fd_pr__model__cap_mim
C$1487 \$423 TOP_P|VINP 8.647288e-15 sky130_fd_pr__model__cap_mim
* device instance $1488 r0 *1 163.2,30.95 sky130_fd_pr__model__cap_mim
C$1488 \$411 TOP_P|VINP 8.647288e-15 sky130_fd_pr__model__cap_mim
* device instance $1489 r0 *1 166.6,30.95 sky130_fd_pr__model__cap_mim
C$1489 \$423 TOP_P|VINP 8.647288e-15 sky130_fd_pr__model__cap_mim
* device instance $1490 r0 *1 170,30.95 sky130_fd_pr__model__cap_mim
C$1490 \$424 TOP_P|VINP 8.647288e-15 sky130_fd_pr__model__cap_mim
* device instance $1491 r0 *1 173.4,30.95 sky130_fd_pr__model__cap_mim
C$1491 \$423 TOP_P|VINP 8.647288e-15 sky130_fd_pr__model__cap_mim
* device instance $1492 r0 *1 176.8,30.95 sky130_fd_pr__model__cap_mim
C$1492 \$425 TOP_P|VINP 8.647288e-15 sky130_fd_pr__model__cap_mim
* device instance $1493 r0 *1 180.2,30.95 sky130_fd_pr__model__cap_mim
C$1493 \$423 TOP_P|VINP 8.647288e-15 sky130_fd_pr__model__cap_mim
* device instance $1494 r0 *1 183.6,30.95 sky130_fd_pr__model__cap_mim
C$1494 \$424 TOP_P|VINP 8.647288e-15 sky130_fd_pr__model__cap_mim
* device instance $1495 r0 *1 187,30.95 sky130_fd_pr__model__cap_mim
C$1495 \$423 TOP_P|VINP 8.647288e-15 sky130_fd_pr__model__cap_mim
* device instance $1496 r0 *1 190.4,30.95 sky130_fd_pr__model__cap_mim
C$1496 \$412 TOP_P|VINP 8.647288e-15 sky130_fd_pr__model__cap_mim
* device instance $1497 r0 *1 193.8,30.95 sky130_fd_pr__model__cap_mim
C$1497 \$423 TOP_P|VINP 8.647288e-15 sky130_fd_pr__model__cap_mim
* device instance $1498 r0 *1 197.2,30.95 sky130_fd_pr__model__cap_mim
C$1498 \$424 TOP_P|VINP 8.647288e-15 sky130_fd_pr__model__cap_mim
* device instance $1499 r0 *1 200.6,30.95 sky130_fd_pr__model__cap_mim
C$1499 \$423 TOP_P|VINP 8.647288e-15 sky130_fd_pr__model__cap_mim
* device instance $1500 r0 *1 204,30.95 sky130_fd_pr__model__cap_mim
C$1500 \$425 TOP_P|VINP 8.647288e-15 sky130_fd_pr__model__cap_mim
* device instance $1501 r0 *1 207.4,30.95 sky130_fd_pr__model__cap_mim
C$1501 \$423 TOP_P|VINP 8.647288e-15 sky130_fd_pr__model__cap_mim
* device instance $1502 r0 *1 210.8,30.95 sky130_fd_pr__model__cap_mim
C$1502 \$424 TOP_P|VINP 8.647288e-15 sky130_fd_pr__model__cap_mim
* device instance $1503 r0 *1 214.2,30.95 sky130_fd_pr__model__cap_mim
C$1503 \$423 TOP_P|VINP 8.647288e-15 sky130_fd_pr__model__cap_mim
* device instance $1504 r0 *1 0,34.35 sky130_fd_pr__model__cap_mim
C$1504 \$419 TOP_N|VINN 8.647288e-15 sky130_fd_pr__model__cap_mim
* device instance $1505 r0 *1 3.4,34.35 sky130_fd_pr__model__cap_mim
C$1505 \$420 TOP_N|VINN 8.647288e-15 sky130_fd_pr__model__cap_mim
* device instance $1506 r0 *1 6.8,34.35 sky130_fd_pr__model__cap_mim
C$1506 \$419 TOP_N|VINN 8.647288e-15 sky130_fd_pr__model__cap_mim
* device instance $1507 r0 *1 10.2,34.35 sky130_fd_pr__model__cap_mim
C$1507 \$421 TOP_N|VINN 8.647288e-15 sky130_fd_pr__model__cap_mim
* device instance $1508 r0 *1 13.6,34.35 sky130_fd_pr__model__cap_mim
C$1508 \$419 TOP_N|VINN 8.647288e-15 sky130_fd_pr__model__cap_mim
* device instance $1509 r0 *1 17,34.35 sky130_fd_pr__model__cap_mim
C$1509 \$420 TOP_N|VINN 8.647288e-15 sky130_fd_pr__model__cap_mim
* device instance $1510 r0 *1 20.4,34.35 sky130_fd_pr__model__cap_mim
C$1510 \$419 TOP_N|VINN 8.647288e-15 sky130_fd_pr__model__cap_mim
* device instance $1511 r0 *1 23.8,34.35 sky130_fd_pr__model__cap_mim
C$1511 \$422 TOP_N|VINN 8.647288e-15 sky130_fd_pr__model__cap_mim
* device instance $1512 r0 *1 27.2,34.35 sky130_fd_pr__model__cap_mim
C$1512 \$419 TOP_N|VINN 8.647288e-15 sky130_fd_pr__model__cap_mim
* device instance $1513 r0 *1 30.6,34.35 sky130_fd_pr__model__cap_mim
C$1513 \$420 TOP_N|VINN 8.647288e-15 sky130_fd_pr__model__cap_mim
* device instance $1514 r0 *1 34,34.35 sky130_fd_pr__model__cap_mim
C$1514 \$419 TOP_N|VINN 8.647288e-15 sky130_fd_pr__model__cap_mim
* device instance $1515 r0 *1 37.4,34.35 sky130_fd_pr__model__cap_mim
C$1515 \$421 TOP_N|VINN 8.647288e-15 sky130_fd_pr__model__cap_mim
* device instance $1516 r0 *1 40.8,34.35 sky130_fd_pr__model__cap_mim
C$1516 \$419 TOP_N|VINN 8.647288e-15 sky130_fd_pr__model__cap_mim
* device instance $1517 r0 *1 44.2,34.35 sky130_fd_pr__model__cap_mim
C$1517 \$420 TOP_N|VINN 8.647288e-15 sky130_fd_pr__model__cap_mim
* device instance $1518 r0 *1 47.6,34.35 sky130_fd_pr__model__cap_mim
C$1518 \$419 TOP_N|VINN 8.647288e-15 sky130_fd_pr__model__cap_mim
* device instance $1519 r0 *1 51,34.35 sky130_fd_pr__model__cap_mim
C$1519 \$417 TOP_N|VINN 8.647288e-15 sky130_fd_pr__model__cap_mim
* device instance $1520 r0 *1 54.4,34.35 sky130_fd_pr__model__cap_mim
C$1520 \$419 TOP_N|VINN 8.647288e-15 sky130_fd_pr__model__cap_mim
* device instance $1521 r0 *1 57.8,34.35 sky130_fd_pr__model__cap_mim
C$1521 \$420 TOP_N|VINN 8.647288e-15 sky130_fd_pr__model__cap_mim
* device instance $1522 r0 *1 61.2,34.35 sky130_fd_pr__model__cap_mim
C$1522 \$419 TOP_N|VINN 8.647288e-15 sky130_fd_pr__model__cap_mim
* device instance $1523 r0 *1 64.6,34.35 sky130_fd_pr__model__cap_mim
C$1523 \$421 TOP_N|VINN 8.647288e-15 sky130_fd_pr__model__cap_mim
* device instance $1524 r0 *1 68,34.35 sky130_fd_pr__model__cap_mim
C$1524 \$419 TOP_N|VINN 8.647288e-15 sky130_fd_pr__model__cap_mim
* device instance $1525 r0 *1 71.4,34.35 sky130_fd_pr__model__cap_mim
C$1525 \$420 TOP_N|VINN 8.647288e-15 sky130_fd_pr__model__cap_mim
* device instance $1526 r0 *1 74.8,34.35 sky130_fd_pr__model__cap_mim
C$1526 \$419 TOP_N|VINN 8.647288e-15 sky130_fd_pr__model__cap_mim
* device instance $1527 r0 *1 78.2,34.35 sky130_fd_pr__model__cap_mim
C$1527 \$422 TOP_N|VINN 8.647288e-15 sky130_fd_pr__model__cap_mim
* device instance $1528 r0 *1 81.6,34.35 sky130_fd_pr__model__cap_mim
C$1528 \$419 TOP_N|VINN 8.647288e-15 sky130_fd_pr__model__cap_mim
* device instance $1529 r0 *1 85,34.35 sky130_fd_pr__model__cap_mim
C$1529 \$420 TOP_N|VINN 8.647288e-15 sky130_fd_pr__model__cap_mim
* device instance $1530 r0 *1 88.4,34.35 sky130_fd_pr__model__cap_mim
C$1530 \$419 TOP_N|VINN 8.647288e-15 sky130_fd_pr__model__cap_mim
* device instance $1531 r0 *1 91.8,34.35 sky130_fd_pr__model__cap_mim
C$1531 \$421 TOP_N|VINN 8.647288e-15 sky130_fd_pr__model__cap_mim
* device instance $1532 r0 *1 95.2,34.35 sky130_fd_pr__model__cap_mim
C$1532 \$419 TOP_N|VINN 8.647288e-15 sky130_fd_pr__model__cap_mim
* device instance $1533 r0 *1 98.6,34.35 sky130_fd_pr__model__cap_mim
C$1533 \$420 TOP_N|VINN 8.647288e-15 sky130_fd_pr__model__cap_mim
* device instance $1534 r0 *1 102,34.35 sky130_fd_pr__model__cap_mim
C$1534 \$419 TOP_N|VINN 8.647288e-15 sky130_fd_pr__model__cap_mim
* device instance $1535 r0 *1 105.4,34.35 sky130_fd_pr__model__cap_mim
C$1535 \$416 TOP_N|VINN 8.647288e-15 sky130_fd_pr__model__cap_mim
* device instance $1536 r0 *1 108.8,34.35 sky130_fd_pr__model__cap_mim
C$1536 \$414 TOP_N|VINN 8.647288e-15 sky130_fd_pr__model__cap_mim
* device instance $1537 r0 *1 112.2,34.35 sky130_fd_pr__model__cap_mim
C$1537 \$419 TOP_N|VINN 8.647288e-15 sky130_fd_pr__model__cap_mim
* device instance $1538 r0 *1 115.6,34.35 sky130_fd_pr__model__cap_mim
C$1538 \$420 TOP_N|VINN 8.647288e-15 sky130_fd_pr__model__cap_mim
* device instance $1539 r0 *1 119,34.35 sky130_fd_pr__model__cap_mim
C$1539 \$419 TOP_N|VINN 8.647288e-15 sky130_fd_pr__model__cap_mim
* device instance $1540 r0 *1 122.4,34.35 sky130_fd_pr__model__cap_mim
C$1540 \$421 TOP_N|VINN 8.647288e-15 sky130_fd_pr__model__cap_mim
* device instance $1541 r0 *1 125.8,34.35 sky130_fd_pr__model__cap_mim
C$1541 \$419 TOP_N|VINN 8.647288e-15 sky130_fd_pr__model__cap_mim
* device instance $1542 r0 *1 129.2,34.35 sky130_fd_pr__model__cap_mim
C$1542 \$420 TOP_N|VINN 8.647288e-15 sky130_fd_pr__model__cap_mim
* device instance $1543 r0 *1 132.6,34.35 sky130_fd_pr__model__cap_mim
C$1543 \$419 TOP_N|VINN 8.647288e-15 sky130_fd_pr__model__cap_mim
* device instance $1544 r0 *1 136,34.35 sky130_fd_pr__model__cap_mim
C$1544 \$422 TOP_N|VINN 8.647288e-15 sky130_fd_pr__model__cap_mim
* device instance $1545 r0 *1 139.4,34.35 sky130_fd_pr__model__cap_mim
C$1545 \$419 TOP_N|VINN 8.647288e-15 sky130_fd_pr__model__cap_mim
* device instance $1546 r0 *1 142.8,34.35 sky130_fd_pr__model__cap_mim
C$1546 \$420 TOP_N|VINN 8.647288e-15 sky130_fd_pr__model__cap_mim
* device instance $1547 r0 *1 146.2,34.35 sky130_fd_pr__model__cap_mim
C$1547 \$419 TOP_N|VINN 8.647288e-15 sky130_fd_pr__model__cap_mim
* device instance $1548 r0 *1 149.6,34.35 sky130_fd_pr__model__cap_mim
C$1548 \$421 TOP_N|VINN 8.647288e-15 sky130_fd_pr__model__cap_mim
* device instance $1549 r0 *1 153,34.35 sky130_fd_pr__model__cap_mim
C$1549 \$419 TOP_N|VINN 8.647288e-15 sky130_fd_pr__model__cap_mim
* device instance $1550 r0 *1 156.4,34.35 sky130_fd_pr__model__cap_mim
C$1550 \$420 TOP_N|VINN 8.647288e-15 sky130_fd_pr__model__cap_mim
* device instance $1551 r0 *1 159.8,34.35 sky130_fd_pr__model__cap_mim
C$1551 \$419 TOP_N|VINN 8.647288e-15 sky130_fd_pr__model__cap_mim
* device instance $1552 r0 *1 163.2,34.35 sky130_fd_pr__model__cap_mim
C$1552 \$417 TOP_N|VINN 8.647288e-15 sky130_fd_pr__model__cap_mim
* device instance $1553 r0 *1 166.6,34.35 sky130_fd_pr__model__cap_mim
C$1553 \$419 TOP_N|VINN 8.647288e-15 sky130_fd_pr__model__cap_mim
* device instance $1554 r0 *1 170,34.35 sky130_fd_pr__model__cap_mim
C$1554 \$420 TOP_N|VINN 8.647288e-15 sky130_fd_pr__model__cap_mim
* device instance $1555 r0 *1 173.4,34.35 sky130_fd_pr__model__cap_mim
C$1555 \$419 TOP_N|VINN 8.647288e-15 sky130_fd_pr__model__cap_mim
* device instance $1556 r0 *1 176.8,34.35 sky130_fd_pr__model__cap_mim
C$1556 \$421 TOP_N|VINN 8.647288e-15 sky130_fd_pr__model__cap_mim
* device instance $1557 r0 *1 180.2,34.35 sky130_fd_pr__model__cap_mim
C$1557 \$419 TOP_N|VINN 8.647288e-15 sky130_fd_pr__model__cap_mim
* device instance $1558 r0 *1 183.6,34.35 sky130_fd_pr__model__cap_mim
C$1558 \$420 TOP_N|VINN 8.647288e-15 sky130_fd_pr__model__cap_mim
* device instance $1559 r0 *1 187,34.35 sky130_fd_pr__model__cap_mim
C$1559 \$419 TOP_N|VINN 8.647288e-15 sky130_fd_pr__model__cap_mim
* device instance $1560 r0 *1 190.4,34.35 sky130_fd_pr__model__cap_mim
C$1560 \$422 TOP_N|VINN 8.647288e-15 sky130_fd_pr__model__cap_mim
* device instance $1561 r0 *1 193.8,34.35 sky130_fd_pr__model__cap_mim
C$1561 \$419 TOP_N|VINN 8.647288e-15 sky130_fd_pr__model__cap_mim
* device instance $1562 r0 *1 197.2,34.35 sky130_fd_pr__model__cap_mim
C$1562 \$420 TOP_N|VINN 8.647288e-15 sky130_fd_pr__model__cap_mim
* device instance $1563 r0 *1 200.6,34.35 sky130_fd_pr__model__cap_mim
C$1563 \$419 TOP_N|VINN 8.647288e-15 sky130_fd_pr__model__cap_mim
* device instance $1564 r0 *1 204,34.35 sky130_fd_pr__model__cap_mim
C$1564 \$421 TOP_N|VINN 8.647288e-15 sky130_fd_pr__model__cap_mim
* device instance $1565 r0 *1 207.4,34.35 sky130_fd_pr__model__cap_mim
C$1565 \$419 TOP_N|VINN 8.647288e-15 sky130_fd_pr__model__cap_mim
* device instance $1566 r0 *1 210.8,34.35 sky130_fd_pr__model__cap_mim
C$1566 \$420 TOP_N|VINN 8.647288e-15 sky130_fd_pr__model__cap_mim
* device instance $1567 r0 *1 214.2,34.35 sky130_fd_pr__model__cap_mim
C$1567 \$419 TOP_N|VINN 8.647288e-15 sky130_fd_pr__model__cap_mim
* device instance $1568 r0 *1 0,37.75 sky130_fd_pr__model__cap_mim
C$1568 \$423 TOP_P|VINP 8.647288e-15 sky130_fd_pr__model__cap_mim
* device instance $1569 r0 *1 3.4,37.75 sky130_fd_pr__model__cap_mim
C$1569 \$424 TOP_P|VINP 8.647288e-15 sky130_fd_pr__model__cap_mim
* device instance $1570 r0 *1 6.8,37.75 sky130_fd_pr__model__cap_mim
C$1570 \$423 TOP_P|VINP 8.647288e-15 sky130_fd_pr__model__cap_mim
* device instance $1571 r0 *1 10.2,37.75 sky130_fd_pr__model__cap_mim
C$1571 \$425 TOP_P|VINP 8.647288e-15 sky130_fd_pr__model__cap_mim
* device instance $1572 r0 *1 13.6,37.75 sky130_fd_pr__model__cap_mim
C$1572 \$423 TOP_P|VINP 8.647288e-15 sky130_fd_pr__model__cap_mim
* device instance $1573 r0 *1 17,37.75 sky130_fd_pr__model__cap_mim
C$1573 \$424 TOP_P|VINP 8.647288e-15 sky130_fd_pr__model__cap_mim
* device instance $1574 r0 *1 20.4,37.75 sky130_fd_pr__model__cap_mim
C$1574 \$423 TOP_P|VINP 8.647288e-15 sky130_fd_pr__model__cap_mim
* device instance $1575 r0 *1 23.8,37.75 sky130_fd_pr__model__cap_mim
C$1575 \$412 TOP_P|VINP 8.647288e-15 sky130_fd_pr__model__cap_mim
* device instance $1576 r0 *1 27.2,37.75 sky130_fd_pr__model__cap_mim
C$1576 \$423 TOP_P|VINP 8.647288e-15 sky130_fd_pr__model__cap_mim
* device instance $1577 r0 *1 30.6,37.75 sky130_fd_pr__model__cap_mim
C$1577 \$424 TOP_P|VINP 8.647288e-15 sky130_fd_pr__model__cap_mim
* device instance $1578 r0 *1 34,37.75 sky130_fd_pr__model__cap_mim
C$1578 \$423 TOP_P|VINP 8.647288e-15 sky130_fd_pr__model__cap_mim
* device instance $1579 r0 *1 37.4,37.75 sky130_fd_pr__model__cap_mim
C$1579 \$425 TOP_P|VINP 8.647288e-15 sky130_fd_pr__model__cap_mim
* device instance $1580 r0 *1 40.8,37.75 sky130_fd_pr__model__cap_mim
C$1580 \$423 TOP_P|VINP 8.647288e-15 sky130_fd_pr__model__cap_mim
* device instance $1581 r0 *1 44.2,37.75 sky130_fd_pr__model__cap_mim
C$1581 \$424 TOP_P|VINP 8.647288e-15 sky130_fd_pr__model__cap_mim
* device instance $1582 r0 *1 47.6,37.75 sky130_fd_pr__model__cap_mim
C$1582 \$423 TOP_P|VINP 8.647288e-15 sky130_fd_pr__model__cap_mim
* device instance $1583 r0 *1 51,37.75 sky130_fd_pr__model__cap_mim
C$1583 \$411 TOP_P|VINP 8.647288e-15 sky130_fd_pr__model__cap_mim
* device instance $1584 r0 *1 54.4,37.75 sky130_fd_pr__model__cap_mim
C$1584 \$423 TOP_P|VINP 8.647288e-15 sky130_fd_pr__model__cap_mim
* device instance $1585 r0 *1 57.8,37.75 sky130_fd_pr__model__cap_mim
C$1585 \$424 TOP_P|VINP 8.647288e-15 sky130_fd_pr__model__cap_mim
* device instance $1586 r0 *1 61.2,37.75 sky130_fd_pr__model__cap_mim
C$1586 \$423 TOP_P|VINP 8.647288e-15 sky130_fd_pr__model__cap_mim
* device instance $1587 r0 *1 64.6,37.75 sky130_fd_pr__model__cap_mim
C$1587 \$425 TOP_P|VINP 8.647288e-15 sky130_fd_pr__model__cap_mim
* device instance $1588 r0 *1 68,37.75 sky130_fd_pr__model__cap_mim
C$1588 \$423 TOP_P|VINP 8.647288e-15 sky130_fd_pr__model__cap_mim
* device instance $1589 r0 *1 71.4,37.75 sky130_fd_pr__model__cap_mim
C$1589 \$424 TOP_P|VINP 8.647288e-15 sky130_fd_pr__model__cap_mim
* device instance $1590 r0 *1 74.8,37.75 sky130_fd_pr__model__cap_mim
C$1590 \$423 TOP_P|VINP 8.647288e-15 sky130_fd_pr__model__cap_mim
* device instance $1591 r0 *1 78.2,37.75 sky130_fd_pr__model__cap_mim
C$1591 \$412 TOP_P|VINP 8.647288e-15 sky130_fd_pr__model__cap_mim
* device instance $1592 r0 *1 81.6,37.75 sky130_fd_pr__model__cap_mim
C$1592 \$423 TOP_P|VINP 8.647288e-15 sky130_fd_pr__model__cap_mim
* device instance $1593 r0 *1 85,37.75 sky130_fd_pr__model__cap_mim
C$1593 \$424 TOP_P|VINP 8.647288e-15 sky130_fd_pr__model__cap_mim
* device instance $1594 r0 *1 88.4,37.75 sky130_fd_pr__model__cap_mim
C$1594 \$423 TOP_P|VINP 8.647288e-15 sky130_fd_pr__model__cap_mim
* device instance $1595 r0 *1 91.8,37.75 sky130_fd_pr__model__cap_mim
C$1595 \$425 TOP_P|VINP 8.647288e-15 sky130_fd_pr__model__cap_mim
* device instance $1596 r0 *1 95.2,37.75 sky130_fd_pr__model__cap_mim
C$1596 \$423 TOP_P|VINP 8.647288e-15 sky130_fd_pr__model__cap_mim
* device instance $1597 r0 *1 98.6,37.75 sky130_fd_pr__model__cap_mim
C$1597 \$424 TOP_P|VINP 8.647288e-15 sky130_fd_pr__model__cap_mim
* device instance $1598 r0 *1 102,37.75 sky130_fd_pr__model__cap_mim
C$1598 \$423 TOP_P|VINP 8.647288e-15 sky130_fd_pr__model__cap_mim
* device instance $1599 r0 *1 105.4,37.75 sky130_fd_pr__model__cap_mim
C$1599 \$410 TOP_P|VINP 8.647288e-15 sky130_fd_pr__model__cap_mim
* device instance $1600 r0 *1 108.8,37.75 sky130_fd_pr__model__cap_mim
C$1600 \$408 TOP_P|VINP 8.647288e-15 sky130_fd_pr__model__cap_mim
* device instance $1601 r0 *1 112.2,37.75 sky130_fd_pr__model__cap_mim
C$1601 \$423 TOP_P|VINP 8.647288e-15 sky130_fd_pr__model__cap_mim
* device instance $1602 r0 *1 115.6,37.75 sky130_fd_pr__model__cap_mim
C$1602 \$424 TOP_P|VINP 8.647288e-15 sky130_fd_pr__model__cap_mim
* device instance $1603 r0 *1 119,37.75 sky130_fd_pr__model__cap_mim
C$1603 \$423 TOP_P|VINP 8.647288e-15 sky130_fd_pr__model__cap_mim
* device instance $1604 r0 *1 122.4,37.75 sky130_fd_pr__model__cap_mim
C$1604 \$425 TOP_P|VINP 8.647288e-15 sky130_fd_pr__model__cap_mim
* device instance $1605 r0 *1 125.8,37.75 sky130_fd_pr__model__cap_mim
C$1605 \$423 TOP_P|VINP 8.647288e-15 sky130_fd_pr__model__cap_mim
* device instance $1606 r0 *1 129.2,37.75 sky130_fd_pr__model__cap_mim
C$1606 \$424 TOP_P|VINP 8.647288e-15 sky130_fd_pr__model__cap_mim
* device instance $1607 r0 *1 132.6,37.75 sky130_fd_pr__model__cap_mim
C$1607 \$423 TOP_P|VINP 8.647288e-15 sky130_fd_pr__model__cap_mim
* device instance $1608 r0 *1 136,37.75 sky130_fd_pr__model__cap_mim
C$1608 \$412 TOP_P|VINP 8.647288e-15 sky130_fd_pr__model__cap_mim
* device instance $1609 r0 *1 139.4,37.75 sky130_fd_pr__model__cap_mim
C$1609 \$423 TOP_P|VINP 8.647288e-15 sky130_fd_pr__model__cap_mim
* device instance $1610 r0 *1 142.8,37.75 sky130_fd_pr__model__cap_mim
C$1610 \$424 TOP_P|VINP 8.647288e-15 sky130_fd_pr__model__cap_mim
* device instance $1611 r0 *1 146.2,37.75 sky130_fd_pr__model__cap_mim
C$1611 \$423 TOP_P|VINP 8.647288e-15 sky130_fd_pr__model__cap_mim
* device instance $1612 r0 *1 149.6,37.75 sky130_fd_pr__model__cap_mim
C$1612 \$425 TOP_P|VINP 8.647288e-15 sky130_fd_pr__model__cap_mim
* device instance $1613 r0 *1 153,37.75 sky130_fd_pr__model__cap_mim
C$1613 \$423 TOP_P|VINP 8.647288e-15 sky130_fd_pr__model__cap_mim
* device instance $1614 r0 *1 156.4,37.75 sky130_fd_pr__model__cap_mim
C$1614 \$424 TOP_P|VINP 8.647288e-15 sky130_fd_pr__model__cap_mim
* device instance $1615 r0 *1 159.8,37.75 sky130_fd_pr__model__cap_mim
C$1615 \$423 TOP_P|VINP 8.647288e-15 sky130_fd_pr__model__cap_mim
* device instance $1616 r0 *1 163.2,37.75 sky130_fd_pr__model__cap_mim
C$1616 \$411 TOP_P|VINP 8.647288e-15 sky130_fd_pr__model__cap_mim
* device instance $1617 r0 *1 166.6,37.75 sky130_fd_pr__model__cap_mim
C$1617 \$423 TOP_P|VINP 8.647288e-15 sky130_fd_pr__model__cap_mim
* device instance $1618 r0 *1 170,37.75 sky130_fd_pr__model__cap_mim
C$1618 \$424 TOP_P|VINP 8.647288e-15 sky130_fd_pr__model__cap_mim
* device instance $1619 r0 *1 173.4,37.75 sky130_fd_pr__model__cap_mim
C$1619 \$423 TOP_P|VINP 8.647288e-15 sky130_fd_pr__model__cap_mim
* device instance $1620 r0 *1 176.8,37.75 sky130_fd_pr__model__cap_mim
C$1620 \$425 TOP_P|VINP 8.647288e-15 sky130_fd_pr__model__cap_mim
* device instance $1621 r0 *1 180.2,37.75 sky130_fd_pr__model__cap_mim
C$1621 \$423 TOP_P|VINP 8.647288e-15 sky130_fd_pr__model__cap_mim
* device instance $1622 r0 *1 183.6,37.75 sky130_fd_pr__model__cap_mim
C$1622 \$424 TOP_P|VINP 8.647288e-15 sky130_fd_pr__model__cap_mim
* device instance $1623 r0 *1 187,37.75 sky130_fd_pr__model__cap_mim
C$1623 \$423 TOP_P|VINP 8.647288e-15 sky130_fd_pr__model__cap_mim
* device instance $1624 r0 *1 190.4,37.75 sky130_fd_pr__model__cap_mim
C$1624 \$412 TOP_P|VINP 8.647288e-15 sky130_fd_pr__model__cap_mim
* device instance $1625 r0 *1 193.8,37.75 sky130_fd_pr__model__cap_mim
C$1625 \$423 TOP_P|VINP 8.647288e-15 sky130_fd_pr__model__cap_mim
* device instance $1626 r0 *1 197.2,37.75 sky130_fd_pr__model__cap_mim
C$1626 \$424 TOP_P|VINP 8.647288e-15 sky130_fd_pr__model__cap_mim
* device instance $1627 r0 *1 200.6,37.75 sky130_fd_pr__model__cap_mim
C$1627 \$423 TOP_P|VINP 8.647288e-15 sky130_fd_pr__model__cap_mim
* device instance $1628 r0 *1 204,37.75 sky130_fd_pr__model__cap_mim
C$1628 \$425 TOP_P|VINP 8.647288e-15 sky130_fd_pr__model__cap_mim
* device instance $1629 r0 *1 207.4,37.75 sky130_fd_pr__model__cap_mim
C$1629 \$423 TOP_P|VINP 8.647288e-15 sky130_fd_pr__model__cap_mim
* device instance $1630 r0 *1 210.8,37.75 sky130_fd_pr__model__cap_mim
C$1630 \$424 TOP_P|VINP 8.647288e-15 sky130_fd_pr__model__cap_mim
* device instance $1631 r0 *1 214.2,37.75 sky130_fd_pr__model__cap_mim
C$1631 \$423 TOP_P|VINP 8.647288e-15 sky130_fd_pr__model__cap_mim
* device instance $1632 r0 *1 0,41.15 sky130_fd_pr__model__cap_mim
C$1632 \$419 TOP_N|VINN 8.647288e-15 sky130_fd_pr__model__cap_mim
* device instance $1633 r0 *1 3.4,41.15 sky130_fd_pr__model__cap_mim
C$1633 \$420 TOP_N|VINN 8.647288e-15 sky130_fd_pr__model__cap_mim
* device instance $1634 r0 *1 6.8,41.15 sky130_fd_pr__model__cap_mim
C$1634 \$419 TOP_N|VINN 8.647288e-15 sky130_fd_pr__model__cap_mim
* device instance $1635 r0 *1 10.2,41.15 sky130_fd_pr__model__cap_mim
C$1635 \$421 TOP_N|VINN 8.647288e-15 sky130_fd_pr__model__cap_mim
* device instance $1636 r0 *1 13.6,41.15 sky130_fd_pr__model__cap_mim
C$1636 \$419 TOP_N|VINN 8.647288e-15 sky130_fd_pr__model__cap_mim
* device instance $1637 r0 *1 17,41.15 sky130_fd_pr__model__cap_mim
C$1637 \$420 TOP_N|VINN 8.647288e-15 sky130_fd_pr__model__cap_mim
* device instance $1638 r0 *1 20.4,41.15 sky130_fd_pr__model__cap_mim
C$1638 \$419 TOP_N|VINN 8.647288e-15 sky130_fd_pr__model__cap_mim
* device instance $1639 r0 *1 23.8,41.15 sky130_fd_pr__model__cap_mim
C$1639 \$422 TOP_N|VINN 8.647288e-15 sky130_fd_pr__model__cap_mim
* device instance $1640 r0 *1 27.2,41.15 sky130_fd_pr__model__cap_mim
C$1640 \$419 TOP_N|VINN 8.647288e-15 sky130_fd_pr__model__cap_mim
* device instance $1641 r0 *1 30.6,41.15 sky130_fd_pr__model__cap_mim
C$1641 \$420 TOP_N|VINN 8.647288e-15 sky130_fd_pr__model__cap_mim
* device instance $1642 r0 *1 34,41.15 sky130_fd_pr__model__cap_mim
C$1642 \$419 TOP_N|VINN 8.647288e-15 sky130_fd_pr__model__cap_mim
* device instance $1643 r0 *1 37.4,41.15 sky130_fd_pr__model__cap_mim
C$1643 \$421 TOP_N|VINN 8.647288e-15 sky130_fd_pr__model__cap_mim
* device instance $1644 r0 *1 40.8,41.15 sky130_fd_pr__model__cap_mim
C$1644 \$419 TOP_N|VINN 8.647288e-15 sky130_fd_pr__model__cap_mim
* device instance $1645 r0 *1 44.2,41.15 sky130_fd_pr__model__cap_mim
C$1645 \$420 TOP_N|VINN 8.647288e-15 sky130_fd_pr__model__cap_mim
* device instance $1646 r0 *1 47.6,41.15 sky130_fd_pr__model__cap_mim
C$1646 \$419 TOP_N|VINN 8.647288e-15 sky130_fd_pr__model__cap_mim
* device instance $1647 r0 *1 51,41.15 sky130_fd_pr__model__cap_mim
C$1647 \$417 TOP_N|VINN 8.647288e-15 sky130_fd_pr__model__cap_mim
* device instance $1648 r0 *1 54.4,41.15 sky130_fd_pr__model__cap_mim
C$1648 \$419 TOP_N|VINN 8.647288e-15 sky130_fd_pr__model__cap_mim
* device instance $1649 r0 *1 57.8,41.15 sky130_fd_pr__model__cap_mim
C$1649 \$420 TOP_N|VINN 8.647288e-15 sky130_fd_pr__model__cap_mim
* device instance $1650 r0 *1 61.2,41.15 sky130_fd_pr__model__cap_mim
C$1650 \$419 TOP_N|VINN 8.647288e-15 sky130_fd_pr__model__cap_mim
* device instance $1651 r0 *1 64.6,41.15 sky130_fd_pr__model__cap_mim
C$1651 \$421 TOP_N|VINN 8.647288e-15 sky130_fd_pr__model__cap_mim
* device instance $1652 r0 *1 68,41.15 sky130_fd_pr__model__cap_mim
C$1652 \$419 TOP_N|VINN 8.647288e-15 sky130_fd_pr__model__cap_mim
* device instance $1653 r0 *1 71.4,41.15 sky130_fd_pr__model__cap_mim
C$1653 \$420 TOP_N|VINN 8.647288e-15 sky130_fd_pr__model__cap_mim
* device instance $1654 r0 *1 74.8,41.15 sky130_fd_pr__model__cap_mim
C$1654 \$419 TOP_N|VINN 8.647288e-15 sky130_fd_pr__model__cap_mim
* device instance $1655 r0 *1 78.2,41.15 sky130_fd_pr__model__cap_mim
C$1655 \$422 TOP_N|VINN 8.647288e-15 sky130_fd_pr__model__cap_mim
* device instance $1656 r0 *1 81.6,41.15 sky130_fd_pr__model__cap_mim
C$1656 \$419 TOP_N|VINN 8.647288e-15 sky130_fd_pr__model__cap_mim
* device instance $1657 r0 *1 85,41.15 sky130_fd_pr__model__cap_mim
C$1657 \$420 TOP_N|VINN 8.647288e-15 sky130_fd_pr__model__cap_mim
* device instance $1658 r0 *1 88.4,41.15 sky130_fd_pr__model__cap_mim
C$1658 \$419 TOP_N|VINN 8.647288e-15 sky130_fd_pr__model__cap_mim
* device instance $1659 r0 *1 91.8,41.15 sky130_fd_pr__model__cap_mim
C$1659 \$421 TOP_N|VINN 8.647288e-15 sky130_fd_pr__model__cap_mim
* device instance $1660 r0 *1 95.2,41.15 sky130_fd_pr__model__cap_mim
C$1660 \$419 TOP_N|VINN 8.647288e-15 sky130_fd_pr__model__cap_mim
* device instance $1661 r0 *1 98.6,41.15 sky130_fd_pr__model__cap_mim
C$1661 \$420 TOP_N|VINN 8.647288e-15 sky130_fd_pr__model__cap_mim
* device instance $1662 r0 *1 102,41.15 sky130_fd_pr__model__cap_mim
C$1662 \$419 TOP_N|VINN 8.647288e-15 sky130_fd_pr__model__cap_mim
* device instance $1663 r0 *1 105.4,41.15 sky130_fd_pr__model__cap_mim
C$1663 \$416 TOP_N|VINN 8.647288e-15 sky130_fd_pr__model__cap_mim
* device instance $1664 r0 *1 108.8,41.15 sky130_fd_pr__model__cap_mim
C$1664 \$415 TOP_N|VINN 8.647288e-15 sky130_fd_pr__model__cap_mim
* device instance $1665 r0 *1 112.2,41.15 sky130_fd_pr__model__cap_mim
C$1665 \$419 TOP_N|VINN 8.647288e-15 sky130_fd_pr__model__cap_mim
* device instance $1666 r0 *1 115.6,41.15 sky130_fd_pr__model__cap_mim
C$1666 \$420 TOP_N|VINN 8.647288e-15 sky130_fd_pr__model__cap_mim
* device instance $1667 r0 *1 119,41.15 sky130_fd_pr__model__cap_mim
C$1667 \$419 TOP_N|VINN 8.647288e-15 sky130_fd_pr__model__cap_mim
* device instance $1668 r0 *1 122.4,41.15 sky130_fd_pr__model__cap_mim
C$1668 \$421 TOP_N|VINN 8.647288e-15 sky130_fd_pr__model__cap_mim
* device instance $1669 r0 *1 125.8,41.15 sky130_fd_pr__model__cap_mim
C$1669 \$419 TOP_N|VINN 8.647288e-15 sky130_fd_pr__model__cap_mim
* device instance $1670 r0 *1 129.2,41.15 sky130_fd_pr__model__cap_mim
C$1670 \$420 TOP_N|VINN 8.647288e-15 sky130_fd_pr__model__cap_mim
* device instance $1671 r0 *1 132.6,41.15 sky130_fd_pr__model__cap_mim
C$1671 \$419 TOP_N|VINN 8.647288e-15 sky130_fd_pr__model__cap_mim
* device instance $1672 r0 *1 136,41.15 sky130_fd_pr__model__cap_mim
C$1672 \$422 TOP_N|VINN 8.647288e-15 sky130_fd_pr__model__cap_mim
* device instance $1673 r0 *1 139.4,41.15 sky130_fd_pr__model__cap_mim
C$1673 \$419 TOP_N|VINN 8.647288e-15 sky130_fd_pr__model__cap_mim
* device instance $1674 r0 *1 142.8,41.15 sky130_fd_pr__model__cap_mim
C$1674 \$420 TOP_N|VINN 8.647288e-15 sky130_fd_pr__model__cap_mim
* device instance $1675 r0 *1 146.2,41.15 sky130_fd_pr__model__cap_mim
C$1675 \$419 TOP_N|VINN 8.647288e-15 sky130_fd_pr__model__cap_mim
* device instance $1676 r0 *1 149.6,41.15 sky130_fd_pr__model__cap_mim
C$1676 \$421 TOP_N|VINN 8.647288e-15 sky130_fd_pr__model__cap_mim
* device instance $1677 r0 *1 153,41.15 sky130_fd_pr__model__cap_mim
C$1677 \$419 TOP_N|VINN 8.647288e-15 sky130_fd_pr__model__cap_mim
* device instance $1678 r0 *1 156.4,41.15 sky130_fd_pr__model__cap_mim
C$1678 \$420 TOP_N|VINN 8.647288e-15 sky130_fd_pr__model__cap_mim
* device instance $1679 r0 *1 159.8,41.15 sky130_fd_pr__model__cap_mim
C$1679 \$419 TOP_N|VINN 8.647288e-15 sky130_fd_pr__model__cap_mim
* device instance $1680 r0 *1 163.2,41.15 sky130_fd_pr__model__cap_mim
C$1680 \$417 TOP_N|VINN 8.647288e-15 sky130_fd_pr__model__cap_mim
* device instance $1681 r0 *1 166.6,41.15 sky130_fd_pr__model__cap_mim
C$1681 \$419 TOP_N|VINN 8.647288e-15 sky130_fd_pr__model__cap_mim
* device instance $1682 r0 *1 170,41.15 sky130_fd_pr__model__cap_mim
C$1682 \$420 TOP_N|VINN 8.647288e-15 sky130_fd_pr__model__cap_mim
* device instance $1683 r0 *1 173.4,41.15 sky130_fd_pr__model__cap_mim
C$1683 \$419 TOP_N|VINN 8.647288e-15 sky130_fd_pr__model__cap_mim
* device instance $1684 r0 *1 176.8,41.15 sky130_fd_pr__model__cap_mim
C$1684 \$421 TOP_N|VINN 8.647288e-15 sky130_fd_pr__model__cap_mim
* device instance $1685 r0 *1 180.2,41.15 sky130_fd_pr__model__cap_mim
C$1685 \$419 TOP_N|VINN 8.647288e-15 sky130_fd_pr__model__cap_mim
* device instance $1686 r0 *1 183.6,41.15 sky130_fd_pr__model__cap_mim
C$1686 \$420 TOP_N|VINN 8.647288e-15 sky130_fd_pr__model__cap_mim
* device instance $1687 r0 *1 187,41.15 sky130_fd_pr__model__cap_mim
C$1687 \$419 TOP_N|VINN 8.647288e-15 sky130_fd_pr__model__cap_mim
* device instance $1688 r0 *1 190.4,41.15 sky130_fd_pr__model__cap_mim
C$1688 \$422 TOP_N|VINN 8.647288e-15 sky130_fd_pr__model__cap_mim
* device instance $1689 r0 *1 193.8,41.15 sky130_fd_pr__model__cap_mim
C$1689 \$419 TOP_N|VINN 8.647288e-15 sky130_fd_pr__model__cap_mim
* device instance $1690 r0 *1 197.2,41.15 sky130_fd_pr__model__cap_mim
C$1690 \$420 TOP_N|VINN 8.647288e-15 sky130_fd_pr__model__cap_mim
* device instance $1691 r0 *1 200.6,41.15 sky130_fd_pr__model__cap_mim
C$1691 \$419 TOP_N|VINN 8.647288e-15 sky130_fd_pr__model__cap_mim
* device instance $1692 r0 *1 204,41.15 sky130_fd_pr__model__cap_mim
C$1692 \$421 TOP_N|VINN 8.647288e-15 sky130_fd_pr__model__cap_mim
* device instance $1693 r0 *1 207.4,41.15 sky130_fd_pr__model__cap_mim
C$1693 \$419 TOP_N|VINN 8.647288e-15 sky130_fd_pr__model__cap_mim
* device instance $1694 r0 *1 210.8,41.15 sky130_fd_pr__model__cap_mim
C$1694 \$420 TOP_N|VINN 8.647288e-15 sky130_fd_pr__model__cap_mim
* device instance $1695 r0 *1 214.2,41.15 sky130_fd_pr__model__cap_mim
C$1695 \$419 TOP_N|VINN 8.647288e-15 sky130_fd_pr__model__cap_mim
* device instance $1696 r0 *1 0,44.55 sky130_fd_pr__model__cap_mim
C$1696 \$423 TOP_P|VINP 8.647288e-15 sky130_fd_pr__model__cap_mim
* device instance $1697 r0 *1 3.4,44.55 sky130_fd_pr__model__cap_mim
C$1697 \$424 TOP_P|VINP 8.647288e-15 sky130_fd_pr__model__cap_mim
* device instance $1698 r0 *1 6.8,44.55 sky130_fd_pr__model__cap_mim
C$1698 \$423 TOP_P|VINP 8.647288e-15 sky130_fd_pr__model__cap_mim
* device instance $1699 r0 *1 10.2,44.55 sky130_fd_pr__model__cap_mim
C$1699 \$425 TOP_P|VINP 8.647288e-15 sky130_fd_pr__model__cap_mim
* device instance $1700 r0 *1 13.6,44.55 sky130_fd_pr__model__cap_mim
C$1700 \$423 TOP_P|VINP 8.647288e-15 sky130_fd_pr__model__cap_mim
* device instance $1701 r0 *1 17,44.55 sky130_fd_pr__model__cap_mim
C$1701 \$424 TOP_P|VINP 8.647288e-15 sky130_fd_pr__model__cap_mim
* device instance $1702 r0 *1 20.4,44.55 sky130_fd_pr__model__cap_mim
C$1702 \$423 TOP_P|VINP 8.647288e-15 sky130_fd_pr__model__cap_mim
* device instance $1703 r0 *1 23.8,44.55 sky130_fd_pr__model__cap_mim
C$1703 \$412 TOP_P|VINP 8.647288e-15 sky130_fd_pr__model__cap_mim
* device instance $1704 r0 *1 27.2,44.55 sky130_fd_pr__model__cap_mim
C$1704 \$423 TOP_P|VINP 8.647288e-15 sky130_fd_pr__model__cap_mim
* device instance $1705 r0 *1 30.6,44.55 sky130_fd_pr__model__cap_mim
C$1705 \$424 TOP_P|VINP 8.647288e-15 sky130_fd_pr__model__cap_mim
* device instance $1706 r0 *1 34,44.55 sky130_fd_pr__model__cap_mim
C$1706 \$423 TOP_P|VINP 8.647288e-15 sky130_fd_pr__model__cap_mim
* device instance $1707 r0 *1 37.4,44.55 sky130_fd_pr__model__cap_mim
C$1707 \$425 TOP_P|VINP 8.647288e-15 sky130_fd_pr__model__cap_mim
* device instance $1708 r0 *1 40.8,44.55 sky130_fd_pr__model__cap_mim
C$1708 \$423 TOP_P|VINP 8.647288e-15 sky130_fd_pr__model__cap_mim
* device instance $1709 r0 *1 44.2,44.55 sky130_fd_pr__model__cap_mim
C$1709 \$424 TOP_P|VINP 8.647288e-15 sky130_fd_pr__model__cap_mim
* device instance $1710 r0 *1 47.6,44.55 sky130_fd_pr__model__cap_mim
C$1710 \$423 TOP_P|VINP 8.647288e-15 sky130_fd_pr__model__cap_mim
* device instance $1711 r0 *1 51,44.55 sky130_fd_pr__model__cap_mim
C$1711 \$411 TOP_P|VINP 8.647288e-15 sky130_fd_pr__model__cap_mim
* device instance $1712 r0 *1 54.4,44.55 sky130_fd_pr__model__cap_mim
C$1712 \$423 TOP_P|VINP 8.647288e-15 sky130_fd_pr__model__cap_mim
* device instance $1713 r0 *1 57.8,44.55 sky130_fd_pr__model__cap_mim
C$1713 \$424 TOP_P|VINP 8.647288e-15 sky130_fd_pr__model__cap_mim
* device instance $1714 r0 *1 61.2,44.55 sky130_fd_pr__model__cap_mim
C$1714 \$423 TOP_P|VINP 8.647288e-15 sky130_fd_pr__model__cap_mim
* device instance $1715 r0 *1 64.6,44.55 sky130_fd_pr__model__cap_mim
C$1715 \$425 TOP_P|VINP 8.647288e-15 sky130_fd_pr__model__cap_mim
* device instance $1716 r0 *1 68,44.55 sky130_fd_pr__model__cap_mim
C$1716 \$423 TOP_P|VINP 8.647288e-15 sky130_fd_pr__model__cap_mim
* device instance $1717 r0 *1 71.4,44.55 sky130_fd_pr__model__cap_mim
C$1717 \$424 TOP_P|VINP 8.647288e-15 sky130_fd_pr__model__cap_mim
* device instance $1718 r0 *1 74.8,44.55 sky130_fd_pr__model__cap_mim
C$1718 \$423 TOP_P|VINP 8.647288e-15 sky130_fd_pr__model__cap_mim
* device instance $1719 r0 *1 78.2,44.55 sky130_fd_pr__model__cap_mim
C$1719 \$412 TOP_P|VINP 8.647288e-15 sky130_fd_pr__model__cap_mim
* device instance $1720 r0 *1 81.6,44.55 sky130_fd_pr__model__cap_mim
C$1720 \$423 TOP_P|VINP 8.647288e-15 sky130_fd_pr__model__cap_mim
* device instance $1721 r0 *1 85,44.55 sky130_fd_pr__model__cap_mim
C$1721 \$424 TOP_P|VINP 8.647288e-15 sky130_fd_pr__model__cap_mim
* device instance $1722 r0 *1 88.4,44.55 sky130_fd_pr__model__cap_mim
C$1722 \$423 TOP_P|VINP 8.647288e-15 sky130_fd_pr__model__cap_mim
* device instance $1723 r0 *1 91.8,44.55 sky130_fd_pr__model__cap_mim
C$1723 \$425 TOP_P|VINP 8.647288e-15 sky130_fd_pr__model__cap_mim
* device instance $1724 r0 *1 95.2,44.55 sky130_fd_pr__model__cap_mim
C$1724 \$423 TOP_P|VINP 8.647288e-15 sky130_fd_pr__model__cap_mim
* device instance $1725 r0 *1 98.6,44.55 sky130_fd_pr__model__cap_mim
C$1725 \$424 TOP_P|VINP 8.647288e-15 sky130_fd_pr__model__cap_mim
* device instance $1726 r0 *1 102,44.55 sky130_fd_pr__model__cap_mim
C$1726 \$423 TOP_P|VINP 8.647288e-15 sky130_fd_pr__model__cap_mim
* device instance $1727 r0 *1 105.4,44.55 sky130_fd_pr__model__cap_mim
C$1727 \$410 TOP_P|VINP 8.647288e-15 sky130_fd_pr__model__cap_mim
* device instance $1728 r0 *1 108.8,44.55 sky130_fd_pr__model__cap_mim
C$1728 \$409 TOP_P|VINP 8.647288e-15 sky130_fd_pr__model__cap_mim
* device instance $1729 r0 *1 112.2,44.55 sky130_fd_pr__model__cap_mim
C$1729 \$423 TOP_P|VINP 8.647288e-15 sky130_fd_pr__model__cap_mim
* device instance $1730 r0 *1 115.6,44.55 sky130_fd_pr__model__cap_mim
C$1730 \$424 TOP_P|VINP 8.647288e-15 sky130_fd_pr__model__cap_mim
* device instance $1731 r0 *1 119,44.55 sky130_fd_pr__model__cap_mim
C$1731 \$423 TOP_P|VINP 8.647288e-15 sky130_fd_pr__model__cap_mim
* device instance $1732 r0 *1 122.4,44.55 sky130_fd_pr__model__cap_mim
C$1732 \$425 TOP_P|VINP 8.647288e-15 sky130_fd_pr__model__cap_mim
* device instance $1733 r0 *1 125.8,44.55 sky130_fd_pr__model__cap_mim
C$1733 \$423 TOP_P|VINP 8.647288e-15 sky130_fd_pr__model__cap_mim
* device instance $1734 r0 *1 129.2,44.55 sky130_fd_pr__model__cap_mim
C$1734 \$424 TOP_P|VINP 8.647288e-15 sky130_fd_pr__model__cap_mim
* device instance $1735 r0 *1 132.6,44.55 sky130_fd_pr__model__cap_mim
C$1735 \$423 TOP_P|VINP 8.647288e-15 sky130_fd_pr__model__cap_mim
* device instance $1736 r0 *1 136,44.55 sky130_fd_pr__model__cap_mim
C$1736 \$412 TOP_P|VINP 8.647288e-15 sky130_fd_pr__model__cap_mim
* device instance $1737 r0 *1 139.4,44.55 sky130_fd_pr__model__cap_mim
C$1737 \$423 TOP_P|VINP 8.647288e-15 sky130_fd_pr__model__cap_mim
* device instance $1738 r0 *1 142.8,44.55 sky130_fd_pr__model__cap_mim
C$1738 \$424 TOP_P|VINP 8.647288e-15 sky130_fd_pr__model__cap_mim
* device instance $1739 r0 *1 146.2,44.55 sky130_fd_pr__model__cap_mim
C$1739 \$423 TOP_P|VINP 8.647288e-15 sky130_fd_pr__model__cap_mim
* device instance $1740 r0 *1 149.6,44.55 sky130_fd_pr__model__cap_mim
C$1740 \$425 TOP_P|VINP 8.647288e-15 sky130_fd_pr__model__cap_mim
* device instance $1741 r0 *1 153,44.55 sky130_fd_pr__model__cap_mim
C$1741 \$423 TOP_P|VINP 8.647288e-15 sky130_fd_pr__model__cap_mim
* device instance $1742 r0 *1 156.4,44.55 sky130_fd_pr__model__cap_mim
C$1742 \$424 TOP_P|VINP 8.647288e-15 sky130_fd_pr__model__cap_mim
* device instance $1743 r0 *1 159.8,44.55 sky130_fd_pr__model__cap_mim
C$1743 \$423 TOP_P|VINP 8.647288e-15 sky130_fd_pr__model__cap_mim
* device instance $1744 r0 *1 163.2,44.55 sky130_fd_pr__model__cap_mim
C$1744 \$411 TOP_P|VINP 8.647288e-15 sky130_fd_pr__model__cap_mim
* device instance $1745 r0 *1 166.6,44.55 sky130_fd_pr__model__cap_mim
C$1745 \$423 TOP_P|VINP 8.647288e-15 sky130_fd_pr__model__cap_mim
* device instance $1746 r0 *1 170,44.55 sky130_fd_pr__model__cap_mim
C$1746 \$424 TOP_P|VINP 8.647288e-15 sky130_fd_pr__model__cap_mim
* device instance $1747 r0 *1 173.4,44.55 sky130_fd_pr__model__cap_mim
C$1747 \$423 TOP_P|VINP 8.647288e-15 sky130_fd_pr__model__cap_mim
* device instance $1748 r0 *1 176.8,44.55 sky130_fd_pr__model__cap_mim
C$1748 \$425 TOP_P|VINP 8.647288e-15 sky130_fd_pr__model__cap_mim
* device instance $1749 r0 *1 180.2,44.55 sky130_fd_pr__model__cap_mim
C$1749 \$423 TOP_P|VINP 8.647288e-15 sky130_fd_pr__model__cap_mim
* device instance $1750 r0 *1 183.6,44.55 sky130_fd_pr__model__cap_mim
C$1750 \$424 TOP_P|VINP 8.647288e-15 sky130_fd_pr__model__cap_mim
* device instance $1751 r0 *1 187,44.55 sky130_fd_pr__model__cap_mim
C$1751 \$423 TOP_P|VINP 8.647288e-15 sky130_fd_pr__model__cap_mim
* device instance $1752 r0 *1 190.4,44.55 sky130_fd_pr__model__cap_mim
C$1752 \$412 TOP_P|VINP 8.647288e-15 sky130_fd_pr__model__cap_mim
* device instance $1753 r0 *1 193.8,44.55 sky130_fd_pr__model__cap_mim
C$1753 \$423 TOP_P|VINP 8.647288e-15 sky130_fd_pr__model__cap_mim
* device instance $1754 r0 *1 197.2,44.55 sky130_fd_pr__model__cap_mim
C$1754 \$424 TOP_P|VINP 8.647288e-15 sky130_fd_pr__model__cap_mim
* device instance $1755 r0 *1 200.6,44.55 sky130_fd_pr__model__cap_mim
C$1755 \$423 TOP_P|VINP 8.647288e-15 sky130_fd_pr__model__cap_mim
* device instance $1756 r0 *1 204,44.55 sky130_fd_pr__model__cap_mim
C$1756 \$425 TOP_P|VINP 8.647288e-15 sky130_fd_pr__model__cap_mim
* device instance $1757 r0 *1 207.4,44.55 sky130_fd_pr__model__cap_mim
C$1757 \$423 TOP_P|VINP 8.647288e-15 sky130_fd_pr__model__cap_mim
* device instance $1758 r0 *1 210.8,44.55 sky130_fd_pr__model__cap_mim
C$1758 \$424 TOP_P|VINP 8.647288e-15 sky130_fd_pr__model__cap_mim
* device instance $1759 r0 *1 214.2,44.55 sky130_fd_pr__model__cap_mim
C$1759 \$423 TOP_P|VINP 8.647288e-15 sky130_fd_pr__model__cap_mim
* device instance $1760 r0 *1 0,47.95 sky130_fd_pr__model__cap_mim
C$1760 \$419 TOP_N|VINN 8.647288e-15 sky130_fd_pr__model__cap_mim
* device instance $1761 r0 *1 3.4,47.95 sky130_fd_pr__model__cap_mim
C$1761 \$420 TOP_N|VINN 8.647288e-15 sky130_fd_pr__model__cap_mim
* device instance $1762 r0 *1 6.8,47.95 sky130_fd_pr__model__cap_mim
C$1762 \$419 TOP_N|VINN 8.647288e-15 sky130_fd_pr__model__cap_mim
* device instance $1763 r0 *1 10.2,47.95 sky130_fd_pr__model__cap_mim
C$1763 \$421 TOP_N|VINN 8.647288e-15 sky130_fd_pr__model__cap_mim
* device instance $1764 r0 *1 13.6,47.95 sky130_fd_pr__model__cap_mim
C$1764 \$419 TOP_N|VINN 8.647288e-15 sky130_fd_pr__model__cap_mim
* device instance $1765 r0 *1 17,47.95 sky130_fd_pr__model__cap_mim
C$1765 \$420 TOP_N|VINN 8.647288e-15 sky130_fd_pr__model__cap_mim
* device instance $1766 r0 *1 20.4,47.95 sky130_fd_pr__model__cap_mim
C$1766 \$419 TOP_N|VINN 8.647288e-15 sky130_fd_pr__model__cap_mim
* device instance $1767 r0 *1 23.8,47.95 sky130_fd_pr__model__cap_mim
C$1767 \$422 TOP_N|VINN 8.647288e-15 sky130_fd_pr__model__cap_mim
* device instance $1768 r0 *1 27.2,47.95 sky130_fd_pr__model__cap_mim
C$1768 \$419 TOP_N|VINN 8.647288e-15 sky130_fd_pr__model__cap_mim
* device instance $1769 r0 *1 30.6,47.95 sky130_fd_pr__model__cap_mim
C$1769 \$420 TOP_N|VINN 8.647288e-15 sky130_fd_pr__model__cap_mim
* device instance $1770 r0 *1 34,47.95 sky130_fd_pr__model__cap_mim
C$1770 \$419 TOP_N|VINN 8.647288e-15 sky130_fd_pr__model__cap_mim
* device instance $1771 r0 *1 37.4,47.95 sky130_fd_pr__model__cap_mim
C$1771 \$421 TOP_N|VINN 8.647288e-15 sky130_fd_pr__model__cap_mim
* device instance $1772 r0 *1 40.8,47.95 sky130_fd_pr__model__cap_mim
C$1772 \$419 TOP_N|VINN 8.647288e-15 sky130_fd_pr__model__cap_mim
* device instance $1773 r0 *1 44.2,47.95 sky130_fd_pr__model__cap_mim
C$1773 \$420 TOP_N|VINN 8.647288e-15 sky130_fd_pr__model__cap_mim
* device instance $1774 r0 *1 47.6,47.95 sky130_fd_pr__model__cap_mim
C$1774 \$419 TOP_N|VINN 8.647288e-15 sky130_fd_pr__model__cap_mim
* device instance $1775 r0 *1 51,47.95 sky130_fd_pr__model__cap_mim
C$1775 \$417 TOP_N|VINN 8.647288e-15 sky130_fd_pr__model__cap_mim
* device instance $1776 r0 *1 54.4,47.95 sky130_fd_pr__model__cap_mim
C$1776 \$419 TOP_N|VINN 8.647288e-15 sky130_fd_pr__model__cap_mim
* device instance $1777 r0 *1 57.8,47.95 sky130_fd_pr__model__cap_mim
C$1777 \$420 TOP_N|VINN 8.647288e-15 sky130_fd_pr__model__cap_mim
* device instance $1778 r0 *1 61.2,47.95 sky130_fd_pr__model__cap_mim
C$1778 \$419 TOP_N|VINN 8.647288e-15 sky130_fd_pr__model__cap_mim
* device instance $1779 r0 *1 64.6,47.95 sky130_fd_pr__model__cap_mim
C$1779 \$421 TOP_N|VINN 8.647288e-15 sky130_fd_pr__model__cap_mim
* device instance $1780 r0 *1 68,47.95 sky130_fd_pr__model__cap_mim
C$1780 \$419 TOP_N|VINN 8.647288e-15 sky130_fd_pr__model__cap_mim
* device instance $1781 r0 *1 71.4,47.95 sky130_fd_pr__model__cap_mim
C$1781 \$420 TOP_N|VINN 8.647288e-15 sky130_fd_pr__model__cap_mim
* device instance $1782 r0 *1 74.8,47.95 sky130_fd_pr__model__cap_mim
C$1782 \$419 TOP_N|VINN 8.647288e-15 sky130_fd_pr__model__cap_mim
* device instance $1783 r0 *1 78.2,47.95 sky130_fd_pr__model__cap_mim
C$1783 \$422 TOP_N|VINN 8.647288e-15 sky130_fd_pr__model__cap_mim
* device instance $1784 r0 *1 81.6,47.95 sky130_fd_pr__model__cap_mim
C$1784 \$419 TOP_N|VINN 8.647288e-15 sky130_fd_pr__model__cap_mim
* device instance $1785 r0 *1 85,47.95 sky130_fd_pr__model__cap_mim
C$1785 \$420 TOP_N|VINN 8.647288e-15 sky130_fd_pr__model__cap_mim
* device instance $1786 r0 *1 88.4,47.95 sky130_fd_pr__model__cap_mim
C$1786 \$419 TOP_N|VINN 8.647288e-15 sky130_fd_pr__model__cap_mim
* device instance $1787 r0 *1 91.8,47.95 sky130_fd_pr__model__cap_mim
C$1787 \$421 TOP_N|VINN 8.647288e-15 sky130_fd_pr__model__cap_mim
* device instance $1788 r0 *1 95.2,47.95 sky130_fd_pr__model__cap_mim
C$1788 \$419 TOP_N|VINN 8.647288e-15 sky130_fd_pr__model__cap_mim
* device instance $1789 r0 *1 98.6,47.95 sky130_fd_pr__model__cap_mim
C$1789 \$420 TOP_N|VINN 8.647288e-15 sky130_fd_pr__model__cap_mim
* device instance $1790 r0 *1 102,47.95 sky130_fd_pr__model__cap_mim
C$1790 \$419 TOP_N|VINN 8.647288e-15 sky130_fd_pr__model__cap_mim
* device instance $1791 r0 *1 105.4,47.95 sky130_fd_pr__model__cap_mim
C$1791 \$416 TOP_N|VINN 8.647288e-15 sky130_fd_pr__model__cap_mim
* device instance $1792 r0 *1 108.8,47.95 sky130_fd_pr__model__cap_mim
C$1792 VREFN TOP_N|VINN 8.647288e-15 sky130_fd_pr__model__cap_mim
* device instance $1793 r0 *1 112.2,47.95 sky130_fd_pr__model__cap_mim
C$1793 \$419 TOP_N|VINN 8.647288e-15 sky130_fd_pr__model__cap_mim
* device instance $1794 r0 *1 115.6,47.95 sky130_fd_pr__model__cap_mim
C$1794 \$420 TOP_N|VINN 8.647288e-15 sky130_fd_pr__model__cap_mim
* device instance $1795 r0 *1 119,47.95 sky130_fd_pr__model__cap_mim
C$1795 \$419 TOP_N|VINN 8.647288e-15 sky130_fd_pr__model__cap_mim
* device instance $1796 r0 *1 122.4,47.95 sky130_fd_pr__model__cap_mim
C$1796 \$421 TOP_N|VINN 8.647288e-15 sky130_fd_pr__model__cap_mim
* device instance $1797 r0 *1 125.8,47.95 sky130_fd_pr__model__cap_mim
C$1797 \$419 TOP_N|VINN 8.647288e-15 sky130_fd_pr__model__cap_mim
* device instance $1798 r0 *1 129.2,47.95 sky130_fd_pr__model__cap_mim
C$1798 \$420 TOP_N|VINN 8.647288e-15 sky130_fd_pr__model__cap_mim
* device instance $1799 r0 *1 132.6,47.95 sky130_fd_pr__model__cap_mim
C$1799 \$419 TOP_N|VINN 8.647288e-15 sky130_fd_pr__model__cap_mim
* device instance $1800 r0 *1 136,47.95 sky130_fd_pr__model__cap_mim
C$1800 \$422 TOP_N|VINN 8.647288e-15 sky130_fd_pr__model__cap_mim
* device instance $1801 r0 *1 139.4,47.95 sky130_fd_pr__model__cap_mim
C$1801 \$419 TOP_N|VINN 8.647288e-15 sky130_fd_pr__model__cap_mim
* device instance $1802 r0 *1 142.8,47.95 sky130_fd_pr__model__cap_mim
C$1802 \$420 TOP_N|VINN 8.647288e-15 sky130_fd_pr__model__cap_mim
* device instance $1803 r0 *1 146.2,47.95 sky130_fd_pr__model__cap_mim
C$1803 \$419 TOP_N|VINN 8.647288e-15 sky130_fd_pr__model__cap_mim
* device instance $1804 r0 *1 149.6,47.95 sky130_fd_pr__model__cap_mim
C$1804 \$421 TOP_N|VINN 8.647288e-15 sky130_fd_pr__model__cap_mim
* device instance $1805 r0 *1 153,47.95 sky130_fd_pr__model__cap_mim
C$1805 \$419 TOP_N|VINN 8.647288e-15 sky130_fd_pr__model__cap_mim
* device instance $1806 r0 *1 156.4,47.95 sky130_fd_pr__model__cap_mim
C$1806 \$420 TOP_N|VINN 8.647288e-15 sky130_fd_pr__model__cap_mim
* device instance $1807 r0 *1 159.8,47.95 sky130_fd_pr__model__cap_mim
C$1807 \$419 TOP_N|VINN 8.647288e-15 sky130_fd_pr__model__cap_mim
* device instance $1808 r0 *1 163.2,47.95 sky130_fd_pr__model__cap_mim
C$1808 \$417 TOP_N|VINN 8.647288e-15 sky130_fd_pr__model__cap_mim
* device instance $1809 r0 *1 166.6,47.95 sky130_fd_pr__model__cap_mim
C$1809 \$419 TOP_N|VINN 8.647288e-15 sky130_fd_pr__model__cap_mim
* device instance $1810 r0 *1 170,47.95 sky130_fd_pr__model__cap_mim
C$1810 \$420 TOP_N|VINN 8.647288e-15 sky130_fd_pr__model__cap_mim
* device instance $1811 r0 *1 173.4,47.95 sky130_fd_pr__model__cap_mim
C$1811 \$419 TOP_N|VINN 8.647288e-15 sky130_fd_pr__model__cap_mim
* device instance $1812 r0 *1 176.8,47.95 sky130_fd_pr__model__cap_mim
C$1812 \$421 TOP_N|VINN 8.647288e-15 sky130_fd_pr__model__cap_mim
* device instance $1813 r0 *1 180.2,47.95 sky130_fd_pr__model__cap_mim
C$1813 \$419 TOP_N|VINN 8.647288e-15 sky130_fd_pr__model__cap_mim
* device instance $1814 r0 *1 183.6,47.95 sky130_fd_pr__model__cap_mim
C$1814 \$420 TOP_N|VINN 8.647288e-15 sky130_fd_pr__model__cap_mim
* device instance $1815 r0 *1 187,47.95 sky130_fd_pr__model__cap_mim
C$1815 \$419 TOP_N|VINN 8.647288e-15 sky130_fd_pr__model__cap_mim
* device instance $1816 r0 *1 190.4,47.95 sky130_fd_pr__model__cap_mim
C$1816 \$422 TOP_N|VINN 8.647288e-15 sky130_fd_pr__model__cap_mim
* device instance $1817 r0 *1 193.8,47.95 sky130_fd_pr__model__cap_mim
C$1817 \$419 TOP_N|VINN 8.647288e-15 sky130_fd_pr__model__cap_mim
* device instance $1818 r0 *1 197.2,47.95 sky130_fd_pr__model__cap_mim
C$1818 \$420 TOP_N|VINN 8.647288e-15 sky130_fd_pr__model__cap_mim
* device instance $1819 r0 *1 200.6,47.95 sky130_fd_pr__model__cap_mim
C$1819 \$419 TOP_N|VINN 8.647288e-15 sky130_fd_pr__model__cap_mim
* device instance $1820 r0 *1 204,47.95 sky130_fd_pr__model__cap_mim
C$1820 \$421 TOP_N|VINN 8.647288e-15 sky130_fd_pr__model__cap_mim
* device instance $1821 r0 *1 207.4,47.95 sky130_fd_pr__model__cap_mim
C$1821 \$419 TOP_N|VINN 8.647288e-15 sky130_fd_pr__model__cap_mim
* device instance $1822 r0 *1 210.8,47.95 sky130_fd_pr__model__cap_mim
C$1822 \$420 TOP_N|VINN 8.647288e-15 sky130_fd_pr__model__cap_mim
* device instance $1823 r0 *1 214.2,47.95 sky130_fd_pr__model__cap_mim
C$1823 \$419 TOP_N|VINN 8.647288e-15 sky130_fd_pr__model__cap_mim
* device instance $1824 r0 *1 0,51.35 sky130_fd_pr__model__cap_mim
C$1824 \$423 TOP_P|VINP 8.647288e-15 sky130_fd_pr__model__cap_mim
* device instance $1825 r0 *1 3.4,51.35 sky130_fd_pr__model__cap_mim
C$1825 \$424 TOP_P|VINP 8.647288e-15 sky130_fd_pr__model__cap_mim
* device instance $1826 r0 *1 6.8,51.35 sky130_fd_pr__model__cap_mim
C$1826 \$423 TOP_P|VINP 8.647288e-15 sky130_fd_pr__model__cap_mim
* device instance $1827 r0 *1 10.2,51.35 sky130_fd_pr__model__cap_mim
C$1827 \$425 TOP_P|VINP 8.647288e-15 sky130_fd_pr__model__cap_mim
* device instance $1828 r0 *1 13.6,51.35 sky130_fd_pr__model__cap_mim
C$1828 \$423 TOP_P|VINP 8.647288e-15 sky130_fd_pr__model__cap_mim
* device instance $1829 r0 *1 17,51.35 sky130_fd_pr__model__cap_mim
C$1829 \$424 TOP_P|VINP 8.647288e-15 sky130_fd_pr__model__cap_mim
* device instance $1830 r0 *1 20.4,51.35 sky130_fd_pr__model__cap_mim
C$1830 \$423 TOP_P|VINP 8.647288e-15 sky130_fd_pr__model__cap_mim
* device instance $1831 r0 *1 23.8,51.35 sky130_fd_pr__model__cap_mim
C$1831 \$412 TOP_P|VINP 8.647288e-15 sky130_fd_pr__model__cap_mim
* device instance $1832 r0 *1 27.2,51.35 sky130_fd_pr__model__cap_mim
C$1832 \$423 TOP_P|VINP 8.647288e-15 sky130_fd_pr__model__cap_mim
* device instance $1833 r0 *1 30.6,51.35 sky130_fd_pr__model__cap_mim
C$1833 \$424 TOP_P|VINP 8.647288e-15 sky130_fd_pr__model__cap_mim
* device instance $1834 r0 *1 34,51.35 sky130_fd_pr__model__cap_mim
C$1834 \$423 TOP_P|VINP 8.647288e-15 sky130_fd_pr__model__cap_mim
* device instance $1835 r0 *1 37.4,51.35 sky130_fd_pr__model__cap_mim
C$1835 \$425 TOP_P|VINP 8.647288e-15 sky130_fd_pr__model__cap_mim
* device instance $1836 r0 *1 40.8,51.35 sky130_fd_pr__model__cap_mim
C$1836 \$423 TOP_P|VINP 8.647288e-15 sky130_fd_pr__model__cap_mim
* device instance $1837 r0 *1 44.2,51.35 sky130_fd_pr__model__cap_mim
C$1837 \$424 TOP_P|VINP 8.647288e-15 sky130_fd_pr__model__cap_mim
* device instance $1838 r0 *1 47.6,51.35 sky130_fd_pr__model__cap_mim
C$1838 \$423 TOP_P|VINP 8.647288e-15 sky130_fd_pr__model__cap_mim
* device instance $1839 r0 *1 51,51.35 sky130_fd_pr__model__cap_mim
C$1839 \$411 TOP_P|VINP 8.647288e-15 sky130_fd_pr__model__cap_mim
* device instance $1840 r0 *1 54.4,51.35 sky130_fd_pr__model__cap_mim
C$1840 \$423 TOP_P|VINP 8.647288e-15 sky130_fd_pr__model__cap_mim
* device instance $1841 r0 *1 57.8,51.35 sky130_fd_pr__model__cap_mim
C$1841 \$424 TOP_P|VINP 8.647288e-15 sky130_fd_pr__model__cap_mim
* device instance $1842 r0 *1 61.2,51.35 sky130_fd_pr__model__cap_mim
C$1842 \$423 TOP_P|VINP 8.647288e-15 sky130_fd_pr__model__cap_mim
* device instance $1843 r0 *1 64.6,51.35 sky130_fd_pr__model__cap_mim
C$1843 \$425 TOP_P|VINP 8.647288e-15 sky130_fd_pr__model__cap_mim
* device instance $1844 r0 *1 68,51.35 sky130_fd_pr__model__cap_mim
C$1844 \$423 TOP_P|VINP 8.647288e-15 sky130_fd_pr__model__cap_mim
* device instance $1845 r0 *1 71.4,51.35 sky130_fd_pr__model__cap_mim
C$1845 \$424 TOP_P|VINP 8.647288e-15 sky130_fd_pr__model__cap_mim
* device instance $1846 r0 *1 74.8,51.35 sky130_fd_pr__model__cap_mim
C$1846 \$423 TOP_P|VINP 8.647288e-15 sky130_fd_pr__model__cap_mim
* device instance $1847 r0 *1 78.2,51.35 sky130_fd_pr__model__cap_mim
C$1847 \$412 TOP_P|VINP 8.647288e-15 sky130_fd_pr__model__cap_mim
* device instance $1848 r0 *1 81.6,51.35 sky130_fd_pr__model__cap_mim
C$1848 \$423 TOP_P|VINP 8.647288e-15 sky130_fd_pr__model__cap_mim
* device instance $1849 r0 *1 85,51.35 sky130_fd_pr__model__cap_mim
C$1849 \$424 TOP_P|VINP 8.647288e-15 sky130_fd_pr__model__cap_mim
* device instance $1850 r0 *1 88.4,51.35 sky130_fd_pr__model__cap_mim
C$1850 \$423 TOP_P|VINP 8.647288e-15 sky130_fd_pr__model__cap_mim
* device instance $1851 r0 *1 91.8,51.35 sky130_fd_pr__model__cap_mim
C$1851 \$425 TOP_P|VINP 8.647288e-15 sky130_fd_pr__model__cap_mim
* device instance $1852 r0 *1 95.2,51.35 sky130_fd_pr__model__cap_mim
C$1852 \$423 TOP_P|VINP 8.647288e-15 sky130_fd_pr__model__cap_mim
* device instance $1853 r0 *1 98.6,51.35 sky130_fd_pr__model__cap_mim
C$1853 \$424 TOP_P|VINP 8.647288e-15 sky130_fd_pr__model__cap_mim
* device instance $1854 r0 *1 102,51.35 sky130_fd_pr__model__cap_mim
C$1854 \$423 TOP_P|VINP 8.647288e-15 sky130_fd_pr__model__cap_mim
* device instance $1855 r0 *1 105.4,51.35 sky130_fd_pr__model__cap_mim
C$1855 \$410 TOP_P|VINP 8.647288e-15 sky130_fd_pr__model__cap_mim
* device instance $1856 r0 *1 108.8,51.35 sky130_fd_pr__model__cap_mim
C$1856 VREFN TOP_P|VINP 8.647288e-15 sky130_fd_pr__model__cap_mim
* device instance $1857 r0 *1 112.2,51.35 sky130_fd_pr__model__cap_mim
C$1857 \$423 TOP_P|VINP 8.647288e-15 sky130_fd_pr__model__cap_mim
* device instance $1858 r0 *1 115.6,51.35 sky130_fd_pr__model__cap_mim
C$1858 \$424 TOP_P|VINP 8.647288e-15 sky130_fd_pr__model__cap_mim
* device instance $1859 r0 *1 119,51.35 sky130_fd_pr__model__cap_mim
C$1859 \$423 TOP_P|VINP 8.647288e-15 sky130_fd_pr__model__cap_mim
* device instance $1860 r0 *1 122.4,51.35 sky130_fd_pr__model__cap_mim
C$1860 \$425 TOP_P|VINP 8.647288e-15 sky130_fd_pr__model__cap_mim
* device instance $1861 r0 *1 125.8,51.35 sky130_fd_pr__model__cap_mim
C$1861 \$423 TOP_P|VINP 8.647288e-15 sky130_fd_pr__model__cap_mim
* device instance $1862 r0 *1 129.2,51.35 sky130_fd_pr__model__cap_mim
C$1862 \$424 TOP_P|VINP 8.647288e-15 sky130_fd_pr__model__cap_mim
* device instance $1863 r0 *1 132.6,51.35 sky130_fd_pr__model__cap_mim
C$1863 \$423 TOP_P|VINP 8.647288e-15 sky130_fd_pr__model__cap_mim
* device instance $1864 r0 *1 136,51.35 sky130_fd_pr__model__cap_mim
C$1864 \$412 TOP_P|VINP 8.647288e-15 sky130_fd_pr__model__cap_mim
* device instance $1865 r0 *1 139.4,51.35 sky130_fd_pr__model__cap_mim
C$1865 \$423 TOP_P|VINP 8.647288e-15 sky130_fd_pr__model__cap_mim
* device instance $1866 r0 *1 142.8,51.35 sky130_fd_pr__model__cap_mim
C$1866 \$424 TOP_P|VINP 8.647288e-15 sky130_fd_pr__model__cap_mim
* device instance $1867 r0 *1 146.2,51.35 sky130_fd_pr__model__cap_mim
C$1867 \$423 TOP_P|VINP 8.647288e-15 sky130_fd_pr__model__cap_mim
* device instance $1868 r0 *1 149.6,51.35 sky130_fd_pr__model__cap_mim
C$1868 \$425 TOP_P|VINP 8.647288e-15 sky130_fd_pr__model__cap_mim
* device instance $1869 r0 *1 153,51.35 sky130_fd_pr__model__cap_mim
C$1869 \$423 TOP_P|VINP 8.647288e-15 sky130_fd_pr__model__cap_mim
* device instance $1870 r0 *1 156.4,51.35 sky130_fd_pr__model__cap_mim
C$1870 \$424 TOP_P|VINP 8.647288e-15 sky130_fd_pr__model__cap_mim
* device instance $1871 r0 *1 159.8,51.35 sky130_fd_pr__model__cap_mim
C$1871 \$423 TOP_P|VINP 8.647288e-15 sky130_fd_pr__model__cap_mim
* device instance $1872 r0 *1 163.2,51.35 sky130_fd_pr__model__cap_mim
C$1872 \$411 TOP_P|VINP 8.647288e-15 sky130_fd_pr__model__cap_mim
* device instance $1873 r0 *1 166.6,51.35 sky130_fd_pr__model__cap_mim
C$1873 \$423 TOP_P|VINP 8.647288e-15 sky130_fd_pr__model__cap_mim
* device instance $1874 r0 *1 170,51.35 sky130_fd_pr__model__cap_mim
C$1874 \$424 TOP_P|VINP 8.647288e-15 sky130_fd_pr__model__cap_mim
* device instance $1875 r0 *1 173.4,51.35 sky130_fd_pr__model__cap_mim
C$1875 \$423 TOP_P|VINP 8.647288e-15 sky130_fd_pr__model__cap_mim
* device instance $1876 r0 *1 176.8,51.35 sky130_fd_pr__model__cap_mim
C$1876 \$425 TOP_P|VINP 8.647288e-15 sky130_fd_pr__model__cap_mim
* device instance $1877 r0 *1 180.2,51.35 sky130_fd_pr__model__cap_mim
C$1877 \$423 TOP_P|VINP 8.647288e-15 sky130_fd_pr__model__cap_mim
* device instance $1878 r0 *1 183.6,51.35 sky130_fd_pr__model__cap_mim
C$1878 \$424 TOP_P|VINP 8.647288e-15 sky130_fd_pr__model__cap_mim
* device instance $1879 r0 *1 187,51.35 sky130_fd_pr__model__cap_mim
C$1879 \$423 TOP_P|VINP 8.647288e-15 sky130_fd_pr__model__cap_mim
* device instance $1880 r0 *1 190.4,51.35 sky130_fd_pr__model__cap_mim
C$1880 \$412 TOP_P|VINP 8.647288e-15 sky130_fd_pr__model__cap_mim
* device instance $1881 r0 *1 193.8,51.35 sky130_fd_pr__model__cap_mim
C$1881 \$423 TOP_P|VINP 8.647288e-15 sky130_fd_pr__model__cap_mim
* device instance $1882 r0 *1 197.2,51.35 sky130_fd_pr__model__cap_mim
C$1882 \$424 TOP_P|VINP 8.647288e-15 sky130_fd_pr__model__cap_mim
* device instance $1883 r0 *1 200.6,51.35 sky130_fd_pr__model__cap_mim
C$1883 \$423 TOP_P|VINP 8.647288e-15 sky130_fd_pr__model__cap_mim
* device instance $1884 r0 *1 204,51.35 sky130_fd_pr__model__cap_mim
C$1884 \$425 TOP_P|VINP 8.647288e-15 sky130_fd_pr__model__cap_mim
* device instance $1885 r0 *1 207.4,51.35 sky130_fd_pr__model__cap_mim
C$1885 \$423 TOP_P|VINP 8.647288e-15 sky130_fd_pr__model__cap_mim
* device instance $1886 r0 *1 210.8,51.35 sky130_fd_pr__model__cap_mim
C$1886 \$424 TOP_P|VINP 8.647288e-15 sky130_fd_pr__model__cap_mim
* device instance $1887 r0 *1 214.2,51.35 sky130_fd_pr__model__cap_mim
C$1887 \$423 TOP_P|VINP 8.647288e-15 sky130_fd_pr__model__cap_mim
* device instance $1888 r0 *1 143.385,93.65 sky130_fd_pr__model__cap_mim
C$1888 \$432 BOOST_P 1.99528e-13 sky130_fd_pr__model__cap_mim
* device instance $1889 r0 *1 154.685,93.65 sky130_fd_pr__model__cap_mim
C$1889 \$437 BOOST_N 1.99528e-13 sky130_fd_pr__model__cap_mim
* device instance $1890 r0 *1 187.035,112.2 sky130_fd_pr__model__cap_mim
C$1890 BPREF_P TOP_P|VINP 4.434864e-12 sky130_fd_pr__model__cap_mim
* device instance $1891 r0 *1 235.435,112.2 sky130_fd_pr__model__cap_mim
C$1891 BPREF_N TOP_N|VINN 4.434864e-12 sky130_fd_pr__model__cap_mim
.ENDS gen_compose_0
