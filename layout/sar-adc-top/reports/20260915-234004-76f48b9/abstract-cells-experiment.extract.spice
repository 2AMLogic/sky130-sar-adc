* extracted by klt extract --deck sky130

* cell gen_compose_0
* pin BUSY
* pin CLK
* pin DOUT0
* pin DOUT1
* pin DOUT2
* pin DOUT3
* pin DOUT4
* pin DOUT5
* pin DOUT6
* pin DOUT7
* pin DOUT8
* pin DOUT9
* pin RST_B
* pin TOP_N,TOP_P,VINN,VINP,VREFN
* pin VCM
* pin VDD
* pin VINN
* pin VINP
* pin VREFP
.SUBCKT gen_compose_0 BUSY CLK DOUT0 DOUT1 DOUT2 DOUT3 DOUT4 DOUT5 DOUT6 DOUT7
+ DOUT8 DOUT9 RST_B TOP_N|TOP_P|VINN|VINP|VREFN VCM VDD VINN VINP VREFP
* cell instance cdac_array__cdac_array_0 r0 *1 0,0
Xcdac_array__cdac_array_0 \$244 \$249 \$248 \$245 \$226 \$247 \$243 \$250 \$246
+ DOUT0 DOUT1 DOUT2 DOUT3 DOUT4 DOUT5 DOUT6 DOUT7 DOUT8
+ TOP_N|TOP_P|VINN|VINP|VREFN TOP_N|TOP_P|VINN|VINP|VREFN VDD
+ TOP_N|TOP_P|VINN|VINP|VREFN VREFP cdac_array__cdac_array
* cell instance sar_sequencer__sar_sequencer_0 r0 *1 0,0
Xsar_sequencer__sar_sequencer_0 BUSY CLK OUTP DOUT0 DOUT1 DOUT2 DOUT3 DOUT4
+ DOUT5 DOUT6 DOUT7 DOUT8 DOUT9 \$180 \$175 \$114 \$72 \$132 \$57 \$61 \$47 \$4
+ \$83 \$183 SAMPLE RST_B \$12 \$1 sar_sequencer__sar_sequencer
* cell instance seln_inverters__seln_inverters_0 r0 *1 0,0
Xseln_inverters__seln_inverters_0 DOUT0 DOUT1 DOUT2 DOUT3 DOUT4 DOUT5 DOUT6
+ DOUT7 DOUT8 \$244 \$249 \$248 \$245 \$226 \$247 \$243 \$250 \$246 \$35 \$11
+ seln_inverters__seln_inverters
* device instance $1 r0 *1 111.42,88.75 nfet
M$1 \$259 \$255 GND GND nfet L=0.15U W=1U AS=0.47P AD=0.47P PS=2.94U PD=2.94U
* device instance $2 r0 *1 113.71,88.75 nfet
M$2 \$259 SAMPLE VINP GND nfet L=0.15U W=1U AS=0.47P AD=0.47P PS=2.94U PD=2.94U
* device instance $3 r0 *1 116.125,88.75 nfet
M$3 \$254 \$255 GND GND nfet L=0.5U W=1U AS=0.42P AD=0.42P PS=2.84U PD=2.84U
* device instance $4 r0 *1 123.245,88.75 nfet
M$4 \$262 \$255 GND GND nfet L=0.5U W=1U AS=0.42P AD=0.42P PS=2.84U PD=2.84U
* device instance $5 r0 *1 125.66,88.75 nfet
M$5 \$261 SAMPLE VINN GND nfet L=0.15U W=1U AS=0.47P AD=0.47P PS=2.94U PD=2.94U
* device instance $6 r0 *1 127.95,88.75 nfet
M$6 \$261 \$255 GND GND nfet L=0.15U W=1U AS=0.47P AD=0.47P PS=2.94U PD=2.94U
* device instance $7 r0 *1 130.24,88.75 nfet
M$7 \$255 SAMPLE GND GND nfet L=0.15U W=1U AS=0.47P AD=0.47P PS=2.94U PD=2.94U
* device instance $8 r0 *1 106.84,89.25 nfet
M$8 VINP \$254 TOP_N|TOP_P|VINN|VINP|VREFN GND nfet L=0.15U W=2U AS=0.94P
+ AD=0.94P PS=4.94U PD=4.94U
* device instance $9 r0 *1 109.13,89.25 nfet
M$9 VINN \$262 TOP_N|TOP_P|VINN|VINP|VREFN GND nfet L=0.15U W=2U AS=0.94P
+ AD=0.94P PS=4.94U PD=4.94U
* device instance $10 r0 *1 118.54,96.25 nfet
M$10 BPREF_P SAMPLE VCM GND nfet L=0.15U W=16U AS=7.52P AD=7.52P PS=32.94U
+ PD=32.94U
* device instance $11 r0 *1 120.83,96.25 nfet
M$11 BPREF_N SAMPLE VCM GND nfet L=0.15U W=16U AS=7.52P AD=7.52P PS=32.94U
+ PD=32.94U
* device instance $12 r0 *1 106.37,192.19 nfet
M$12 \$268 TOP_N|TOP_P|VINN|VINP|VREFN \$270 GND nfet L=0.5U W=2U AS=0.84P
+ AD=0.84P PS=4.84U PD=4.84U
* device instance $13 r0 *1 108.11,192.19 nfet
M$13 \$269 TOP_N|TOP_P|VINN|VINP|VREFN \$270 GND nfet L=0.5U W=2U AS=0.84P
+ AD=0.84P PS=4.84U PD=4.84U
* device instance $14 r0 *1 111.57,191.19 nfet
M$14 OUTP OUTN \$268 GND nfet L=0.5U W=4U AS=1.68P AD=1.68P PS=8.84U PD=8.84U
* device instance $15 r0 *1 106.37,195.41 nfet
M$15 \$269 TOP_N|TOP_P|VINN|VINP|VREFN \$270 GND nfet L=0.5U W=2U AS=0.84P
+ AD=0.84P PS=4.84U PD=4.84U
* device instance $16 r0 *1 108.11,195.41 nfet
M$16 \$268 TOP_N|TOP_P|VINN|VINP|VREFN \$270 GND nfet L=0.5U W=2U AS=0.84P
+ AD=0.84P PS=4.84U PD=4.84U
* device instance $17 r0 *1 102.87,193.8 nfet
M$17 \$270 CLK GND GND nfet L=0.5U W=8U AS=3.36P AD=3.36P PS=16.84U PD=16.84U
* device instance $18 r0 *1 111.57,196.41 nfet
M$18 OUTN OUTP \$269 GND nfet L=0.5U W=4U AS=1.68P AD=1.68P PS=8.84U PD=8.84U
* device instance $19 r0 *1 66.495,88.75 pfet
M$19 BOOST_P \$254 VDD BOOST_P pfet L=0.5U W=1U AS=0.42P AD=0.42P PS=2.84U
+ PD=2.84U
* device instance $20 r0 *1 69.57,88.75 pfet
M$20 \$254 \$255 BOOST_P BOOST_P pfet L=0.15U W=1U AS=0.47P AD=0.47P PS=2.94U
+ PD=2.94U
* device instance $21 r0 *1 74.71,88.75 pfet
M$21 \$259 \$255 VINP VDD pfet L=0.15U W=1U AS=0.47P AD=0.47P PS=2.94U PD=2.94U
* device instance $22 r0 *1 87.51,88.75 pfet
M$22 \$261 \$255 VINN VDD pfet L=0.15U W=1U AS=0.47P AD=0.47P PS=2.94U PD=2.94U
* device instance $23 r0 *1 92.65,88.75 pfet
M$23 \$262 \$255 BOOST_N BOOST_N pfet L=0.15U W=1U AS=0.47P AD=0.47P PS=2.94U
+ PD=2.94U
* device instance $24 r0 *1 95.975,88.75 pfet
M$24 BOOST_N \$262 VDD BOOST_N pfet L=0.5U W=1U AS=0.42P AD=0.42P PS=2.84U
+ PD=2.84U
* device instance $25 r0 *1 81.11,89.25 pfet
M$25 \$255 SAMPLE VDD VDD pfet L=0.15U W=2U AS=0.94P AD=0.94P PS=4.94U PD=4.94U
* device instance $26 r0 *1 77.91,96.25 pfet
M$26 BPREF_P \$255 VCM VDD pfet L=0.15U W=16U AS=7.52P AD=7.52P PS=32.94U
+ PD=32.94U
* device instance $27 r0 *1 84.31,96.25 pfet
M$27 BPREF_N \$255 VCM VDD pfet L=0.15U W=16U AS=7.52P AD=7.52P PS=32.94U
+ PD=32.94U
* device instance $28 r0 *1 115.07,189.19 pfet
M$28 OUTP OUTN VDD VDD pfet L=0.5U W=8U AS=3.36P AD=3.36P PS=16.84U PD=16.84U
* device instance $29 r0 *1 118.87,185.19 pfet
M$29 OUTP CLK VDD VDD pfet L=0.5U W=16U AS=6.72P AD=6.72P PS=32.84U PD=32.84U
* device instance $30 r0 *1 123.87,191.19 pfet
M$30 \$268 CLK VDD VDD pfet L=0.5U W=4U AS=1.68P AD=1.68P PS=8.84U PD=8.84U
* device instance $31 r0 *1 123.87,196.41 pfet
M$31 \$269 CLK VDD VDD pfet L=0.5U W=4U AS=1.68P AD=1.68P PS=8.84U PD=8.84U
* device instance $32 r0 *1 115.07,198.41 pfet
M$32 OUTN OUTP VDD VDD pfet L=0.5U W=8U AS=3.36P AD=3.36P PS=16.84U PD=16.84U
* device instance $33 r0 *1 118.87,202.41 pfet
M$33 OUTN CLK VDD VDD pfet L=0.5U W=16U AS=6.72P AD=6.72P PS=32.84U PD=32.84U
* device instance $34 r0 *1 143.385,93.65 sky130_fd_pr__model__cap_mim
C$34 \$259 BOOST_P 1.99528e-13
* device instance $35 r0 *1 154.685,93.65 sky130_fd_pr__model__cap_mim
C$35 \$261 BOOST_N 1.99528e-13
* device instance $36 r0 *1 187.035,112.2 sky130_fd_pr__model__cap_mim
C$36 BPREF_P TOP_N|TOP_P|VINN|VINP|VREFN 4.434864e-12
* device instance $37 r0 *1 235.435,112.2 sky130_fd_pr__model__cap_mim
C$37 BPREF_N TOP_N|TOP_P|VINN|VINP|VREFN 4.434864e-12
.ENDS gen_compose_0

* cell seln_inverters__seln_inverters
* pin DOUT0
* pin DOUT1
* pin DOUT2
* pin DOUT3
* pin DOUT4
* pin DOUT5
* pin DOUT6
* pin DOUT7
* pin DOUT8
* pin SELn0
* pin SELn1
* pin SELn2
* pin SELn3
* pin SELn4
* pin SELn5
* pin SELn6
* pin SELn7
* pin SELn8
* pin VGND
* pin VPWR
.SUBCKT seln_inverters__seln_inverters DOUT0 DOUT1 DOUT2 DOUT3 DOUT4 DOUT5
+ DOUT6 DOUT7 DOUT8 SELn0 SELn1 SELn2 SELn3 SELn4 SELn5 SELn6 SELn7 SELn8 VGND
+ VPWR
.ENDS seln_inverters__seln_inverters

* cell sar_sequencer__sar_sequencer
* pin BUSY
* pin CLK
* pin COMP_OUT
* pin DOUT0
* pin DOUT1
* pin DOUT2
* pin DOUT3
* pin DOUT4
* pin DOUT5
* pin DOUT6
* pin DOUT7
* pin DOUT8
* pin DOUT9
* pin PH_B0
* pin PH_B1
* pin PH_B2
* pin PH_B3
* pin PH_B4
* pin PH_B5
* pin PH_B6
* pin PH_B7
* pin PH_B8
* pin PH_B9
* pin PH_EOC
* pin PH_SAMPLE
* pin RST_B
* pin VGND
* pin VPWR
.SUBCKT sar_sequencer__sar_sequencer BUSY CLK COMP_OUT DOUT0 DOUT1 DOUT2 DOUT3
+ DOUT4 DOUT5 DOUT6 DOUT7 DOUT8 DOUT9 PH_B0 PH_B1 PH_B2 PH_B3 PH_B4 PH_B5 PH_B6
+ PH_B7 PH_B8 PH_B9 PH_EOC PH_SAMPLE RST_B VGND VPWR
.ENDS sar_sequencer__sar_sequencer

* cell cdac_array__cdac_array
* pin SELn0
* pin SELn1
* pin SELn2
* pin SELn3
* pin SELn4
* pin SELn5
* pin SELn6
* pin SELn7
* pin SELn8
* pin SELp0
* pin SELp1
* pin SELp2
* pin SELp3
* pin SELp4
* pin SELp5
* pin SELp6
* pin SELp7
* pin SELp8
* pin TOP_N
* pin TOP_P
* pin VDD
* pin VREFN
* pin VREFP
.SUBCKT cdac_array__cdac_array SELn0 SELn1 SELn2 SELn3 SELn4 SELn5 SELn6 SELn7
+ SELn8 SELp0 SELp1 SELp2 SELp3 SELp4 SELp5 SELp6 SELp7 SELp8 TOP_N TOP_P VDD
+ VREFN VREFP
.ENDS cdac_array__cdac_array
