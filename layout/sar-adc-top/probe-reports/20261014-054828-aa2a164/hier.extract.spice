* extracted by klt extract --deck sky130

* cell gen_compose_0
* pin A,A0,B,DOUT0,Q
* pin A,A0,B,DOUT1,Q
* pin A,A0,B,DOUT2,Q
* pin A,A0,B,DOUT3,Q
* pin A,A0,B,DOUT4,Q
* pin A,A0,B,DOUT5,Q
* pin A,A0,B,DOUT6,Q
* pin A,A0,B,DOUT7,Q
* pin A,A0,B,DOUT8,Q
* pin A,A0,B,DOUT9,Q
* pin A,B,BUSY,X
* pin A,CLK
* pin GND,VGND,VSS
* pin RESET_B,RST_B
* pin VCM
* pin VDD
* pin VINN
* pin VINP
* pin VPB,VPWR
* pin VREFN
* pin VREFP
.SUBCKT gen_compose_0 A|A0|B|DOUT0|Q A|A0|B|DOUT1|Q A|A0|B|DOUT2|Q
+ A|A0|B|DOUT3|Q A|A0|B|DOUT4|Q A|A0|B|DOUT5|Q A|A0|B|DOUT6|Q A|A0|B|DOUT7|Q
+ A|A0|B|DOUT8|Q A|A0|B|DOUT9|Q A|B|BUSY|X A|CLK GND|VGND|VSS RESET_B|RST_B VCM
+ VDD VINN VINP VPB|VPWR VREFN VREFP
* cell instance cdac_array__cdac_array_1 r0 *1 0,0
Xcdac_array__cdac_array_1 VREFN SELp0|X GND|VGND|VSS SELp1|X SELp2|X SELp3|X
+ SELp4|X SELp5|X SELp6|X SELp7|X SELp8|X SELn0|X SELn1|X SELn2|X SELn3|X
+ SELn4|X SELn5|X SELn6|X SELn7|X SELn8|X VREFP VDD TOP_P|VINP TOP_N|VINN
+ cdac_array__cdac_array
* cell instance comparator__gen_compose_0_1 r0 *1 0,0
Xcomparator__gen_compose_0_1 GND|VGND|VSS CLK|CLKN|Y TOP_N|VINN TOP_P|VINP
+ A|A1|OUTN|OUTN_NC A1|COMP_OUT|OUTP VDD comparator__gen_compose_0
* cell instance halflsb_offset__gen_compose_0_1 r0 *1 0,0
Xhalflsb_offset__gen_compose_0_1 VCM A|HALF_LSB_EN|X GND|VGND|VSS VREFP VDD
+ HALF_LSB_ENN|Y VPB|VPWR TOP_N|VINN TOP_P|VINP halflsb_offset__gen_compose_0
* cell instance sampling_frontend__gen_compose_0_1 r0 *1 0,0
Xsampling_frontend__gen_compose_0_1 TOP_P|VINP VINP GND|VGND|VSS TOP_N|VINN
+ VINN D|PH_SAMPLE|SAMPLE|Y VCM VDD sampling_frontend__gen_compose_0
* cell instance sar_sequencer__sar_sequencer_1 r0 *1 0,0
Xsar_sequencer__sar_sequencer_1 GND|VGND|VSS RESET_B|RST_B A1|COMP_OUT|OUTP
+ A|A0|B|DOUT4|Q A|A0|B|DOUT5|Q A|A0|B|DOUT3|Q A|A0|B|DOUT2|Q A|CLK
+ A|A0|B|DOUT6|Q A|A0|B|DOUT1|Q A|A_N|D|PH_B9|Q|S A|B|BUSY|X
+ D|PH_SAMPLE|SAMPLE|Y A|A0|B|DOUT7|Q A|A0|B|DOUT0|Q A|A0|B|DOUT9|Q
+ A|A0|B|DOUT8|Q VPB|VPWR sar_sequencer__sar_sequencer
* cell instance top_glue__top_glue_1 r0 *1 0,0
Xtop_glue__top_glue_1 GND|VGND|VSS A|A0|B|DOUT0|Q A|A0|B|DOUT2|Q A|A0|B|DOUT8|Q
+ A|A0|B|DOUT3|Q A|HALF_LSB_EN|X HALF_LSB_ENN|Y SELn8|X A|A0|B|DOUT9|Q
+ A|A0|B|DOUT7|Q SELp0|X A|A0|B|DOUT6|Q SELp2|X SELp6|X SELn3|X SELn7|X
+ A|A1|OUTN|OUTN_NC A|A_N|D|PH_B9|Q|S A|B|BUSY|X A|A0|B|DOUT1|Q SELp1|X SELn2|X
+ A|A0|B|DOUT4|Q A|A0|B|DOUT5|Q A|CLK CLK|CLKN|Y SELp7|X SELn1|X SELp8|X
+ SELp5|X SELp3|X SELn0|X SELn5|X SELn4|X SELp4|X SELn6|X VPB|VPWR
+ top_glue__top_glue
* device instance $1088 r0 *1 219.95,-126.05 sky130_fd_pr__model__cap_mim
C$1088 GND|VGND|VSS VPB|VPWR 4.434864e-12
* device instance $1089 r0 *1 219.95,-74.05 sky130_fd_pr__model__cap_mim
C$1089 GND|VGND|VSS VPB|VPWR 4.434864e-12
* device instance $2120 r0 *1 151.95,173.95 sky130_fd_pr__model__cap_mim
C$2120 GND|VGND|VSS VDD 4.434864e-12
* device instance $2121 r0 *1 203.95,173.95 sky130_fd_pr__model__cap_mim
C$2121 GND|VGND|VSS VDD 4.434864e-12
.ENDS gen_compose_0

* cell top_glue__top_glue
* pin GND|VGND|VSS
* pin A|A0|B|DOUT0|Q
* pin A|A0|B|DOUT2|Q
* pin A|A0|B|DOUT8|Q
* pin A|A0|B|DOUT3|Q
* pin A|HALF_LSB_EN|X
* pin HALF_LSB_ENN|Y
* pin SELn8|X
* pin A|A0|B|DOUT9|Q
* pin A|A0|B|DOUT7|Q
* pin SELp0|X
* pin A|A0|B|DOUT6|Q
* pin SELp2|X
* pin SELp6|X
* pin SELn3|X
* pin SELn7|X
* pin A|A1|OUTN|OUTN_NC
* pin A|A_N|D|PH_B9|Q|S
* pin A|B|BUSY|X
* pin A|A0|B|DOUT1|Q
* pin SELp1|X
* pin SELn2|X
* pin A|A0|B|DOUT4|Q
* pin A|A0|B|DOUT5|Q
* pin A|CLK
* pin CLK|CLKN|Y
* pin SELp7|X
* pin SELn1|X
* pin SELp8|X
* pin SELp5|X
* pin SELp3|X
* pin SELn0|X
* pin SELn5|X
* pin SELn4|X
* pin SELp4|X
* pin SELn6|X
* pin VPB|VPWR
.SUBCKT top_glue__top_glue GND\x7cVGND\x7cVSS A\x7cA0\x7cB\x7cDOUT0\x7cQ
+ A\x7cA0\x7cB\x7cDOUT2\x7cQ A\x7cA0\x7cB\x7cDOUT8\x7cQ
+ A\x7cA0\x7cB\x7cDOUT3\x7cQ A\x7cHALF_LSB_EN\x7cX HALF_LSB_ENN\x7cY SELn8\x7cX
+ A\x7cA0\x7cB\x7cDOUT9\x7cQ A\x7cA0\x7cB\x7cDOUT7\x7cQ SELp0\x7cX
+ A\x7cA0\x7cB\x7cDOUT6\x7cQ SELp2\x7cX SELp6\x7cX SELn3\x7cX SELn7\x7cX
+ A\x7cA1\x7cOUTN\x7cOUTN_NC A\x7cA_N\x7cD\x7cPH_B9\x7cQ\x7cS
+ A\x7cB\x7cBUSY\x7cX A\x7cA0\x7cB\x7cDOUT1\x7cQ SELp1\x7cX SELn2\x7cX
+ A\x7cA0\x7cB\x7cDOUT4\x7cQ A\x7cA0\x7cB\x7cDOUT5\x7cQ A\x7cCLK
+ CLK\x7cCLKN\x7cY SELp7\x7cX SELn1\x7cX SELp8\x7cX SELp5\x7cX SELp3\x7cX
+ SELn0\x7cX SELn5\x7cX SELn4\x7cX SELp4\x7cX SELn6\x7cX VPB\x7cVPWR
* device instance $1 r0 *1 0,0 nfet
M$1 \$0 B\x7cY GND\x7cVGND\x7cVSS GND\x7cVGND\x7cVSS nfet L=0.15U W=0.65U
+ AS=0.169P AD=0.08775P PS=1.82U PD=0.92U
* device instance $2 r0 *1 0,0 nfet
M$2 GND\x7cVGND\x7cVSS A\x7cA0\x7cB\x7cDOUT0\x7cQ \$0 GND\x7cVGND\x7cVSS nfet
+ L=0.15U W=0.65U AS=0.08775P AD=0.08775P PS=0.92U PD=0.92U
* device instance $3 r0 *1 0,0 nfet
M$3 \$0$1 A\x7cA0\x7cB\x7cDOUT0\x7cQ GND\x7cVGND\x7cVSS GND\x7cVGND\x7cVSS nfet
+ L=0.15U W=0.65U AS=0.08775P AD=0.08775P PS=0.92U PD=0.92U
* device instance $4 r0 *1 0,0 nfet
M$4 \$0$2 B\x7cY GND\x7cVGND\x7cVSS GND\x7cVGND\x7cVSS nfet L=0.15U W=0.65U
+ AS=0.169P AD=0.08775P PS=1.82U PD=0.92U
* device instance $5 r0 *1 0,0 nfet
M$5 ADCOUT0\x7cX B\x7cY \$0$1 GND\x7cVGND\x7cVSS nfet L=0.15U W=0.65U
+ AS=0.08775P AD=0.25025P PS=0.92U PD=1.42U
* device instance $6 r0 *1 0,0 nfet
M$6 GND\x7cVGND\x7cVSS A\x7cA0\x7cB\x7cDOUT2\x7cQ \$0$2 GND\x7cVGND\x7cVSS nfet
+ L=0.15U W=0.65U AS=0.08775P AD=0.08775P PS=0.92U PD=0.92U
* device instance $7 r0 *1 0,0 nfet
M$7 \$0$3 A\x7cA0\x7cB\x7cDOUT2\x7cQ GND\x7cVGND\x7cVSS GND\x7cVGND\x7cVSS nfet
+ L=0.15U W=0.65U AS=0.08775P AD=0.08775P PS=0.92U PD=0.92U
* device instance $8 r0 *1 0,0 nfet
M$8 \$0$4 B\x7cY GND\x7cVGND\x7cVSS GND\x7cVGND\x7cVSS nfet L=0.15U W=0.65U
+ AS=0.169P AD=0.08775P PS=1.82U PD=0.92U
* device instance $9 r0 *1 0,0 nfet
M$9 ADCOUT2\x7cX B\x7cY \$0$3 GND\x7cVGND\x7cVSS nfet L=0.15U W=0.65U
+ AS=0.08775P AD=0.25025P PS=0.92U PD=1.42U
* device instance $10 r0 *1 0,0 nfet
M$10 GND\x7cVGND\x7cVSS \$0 ADCOUT0\x7cX GND\x7cVGND\x7cVSS nfet L=0.15U
+ W=0.65U AS=0.25025P AD=0.208P PS=1.42U PD=1.94U
* device instance $11 r0 *1 0,0 nfet
M$11 GND\x7cVGND\x7cVSS A\x7cA0\x7cB\x7cDOUT8\x7cQ \$0$4 GND\x7cVGND\x7cVSS
+ nfet L=0.15U W=0.65U AS=0.08775P AD=0.08775P PS=0.92U PD=0.92U
* device instance $12 r0 *1 0,0 nfet
M$12 \$0$5 A\x7cA0\x7cB\x7cDOUT8\x7cQ GND\x7cVGND\x7cVSS GND\x7cVGND\x7cVSS
+ nfet L=0.15U W=0.65U AS=0.08775P AD=0.08775P PS=0.92U PD=0.92U
* device instance $13 r0 *1 0,0 nfet
M$13 ADCOUT8\x7cX B\x7cY \$0$5 GND\x7cVGND\x7cVSS nfet L=0.15U W=0.65U
+ AS=0.08775P AD=0.25025P PS=0.92U PD=1.42U
* device instance $14 r0 *1 0,0 nfet
M$14 GND\x7cVGND\x7cVSS \$0$2 ADCOUT2\x7cX GND\x7cVGND\x7cVSS nfet L=0.15U
+ W=0.65U AS=0.25025P AD=0.208P PS=1.42U PD=1.94U
* device instance $15 r0 *1 0,0 nfet
M$15 GND\x7cVGND\x7cVSS \$0$4 ADCOUT8\x7cX GND\x7cVGND\x7cVSS nfet L=0.15U
+ W=0.65U AS=0.25025P AD=0.208P PS=1.42U PD=1.94U
* device instance $16 r0 *1 0,0 nfet
M$16 \$0$7 A\x7cA0\x7cB\x7cDOUT8\x7cQ \$0$6 GND\x7cVGND\x7cVSS nfet L=0.15U
+ W=0.42U AS=0.1176P AD=0.0567P PS=1.4U PD=0.69U
* device instance $17 r0 *1 0,0 nfet
M$17 \$0$8 B\x7cY GND\x7cVGND\x7cVSS GND\x7cVGND\x7cVSS nfet L=0.15U W=0.65U
+ AS=0.169P AD=0.08775P PS=1.82U PD=0.92U
* device instance $18 r0 *1 0,0 nfet
M$18 \$0$7 B\x7cY GND\x7cVGND\x7cVSS GND\x7cVGND\x7cVSS nfet L=0.15U W=0.42U
+ AS=0.1118P AD=0.0567P PS=1.04U PD=0.69U
* device instance $19 r0 *1 0,0 nfet
M$19 GND\x7cVGND\x7cVSS A\x7cA0\x7cB\x7cDOUT3\x7cQ \$0$8 GND\x7cVGND\x7cVSS
+ nfet L=0.15U W=0.65U AS=0.08775P AD=0.08775P PS=0.92U PD=0.92U
* device instance $20 r0 *1 0,0 nfet
M$20 HALF_LSB_ENN\x7cY A\x7cHALF_LSB_EN\x7cX GND\x7cVGND\x7cVSS
+ GND\x7cVGND\x7cVSS nfet L=0.15U W=0.65U AS=0.169P AD=0.169P PS=1.82U PD=1.82U
* device instance $21 r0 *1 0,0 nfet
M$21 SELn8\x7cX \$0$6 GND\x7cVGND\x7cVSS GND\x7cVGND\x7cVSS nfet L=0.15U
+ W=0.65U AS=0.1118P AD=0.182P PS=1.04U PD=1.86U
* device instance $22 r0 *1 0,0 nfet
M$22 \$0$9 A\x7cA0\x7cB\x7cDOUT3\x7cQ GND\x7cVGND\x7cVSS GND\x7cVGND\x7cVSS
+ nfet L=0.15U W=0.65U AS=0.08775P AD=0.08775P PS=0.92U PD=0.92U
* device instance $23 r0 *1 0,0 nfet
M$23 ADCOUT3\x7cX B\x7cY \$0$9 GND\x7cVGND\x7cVSS nfet L=0.15U W=0.65U
+ AS=0.08775P AD=0.25025P PS=0.92U PD=1.42U
* device instance $24 r0 *1 0,0 nfet
M$24 GND\x7cVGND\x7cVSS \$0$8 ADCOUT3\x7cX GND\x7cVGND\x7cVSS nfet L=0.15U
+ W=0.65U AS=0.25025P AD=0.208P PS=1.42U PD=1.94U
* device instance $25 r0 *1 0,0 nfet
M$25 \$0$10 B\x7cY GND\x7cVGND\x7cVSS GND\x7cVGND\x7cVSS nfet L=0.15U W=0.65U
+ AS=0.169P AD=0.08775P PS=1.82U PD=0.92U
* device instance $26 r0 *1 0,0 nfet
M$26 \$0$12 A\x7cA0\x7cB\x7cDOUT9\x7cQ \$0$11 GND\x7cVGND\x7cVSS nfet L=0.15U
+ W=0.42U AS=0.1176P AD=0.0567P PS=1.4U PD=0.69U
* device instance $27 r0 *1 0,0 nfet
M$27 GND\x7cVGND\x7cVSS A\x7cA0\x7cB\x7cDOUT7\x7cQ \$0$10 GND\x7cVGND\x7cVSS
+ nfet L=0.15U W=0.65U AS=0.08775P AD=0.08775P PS=0.92U PD=0.92U
* device instance $28 r0 *1 0,0 nfet
M$28 \$0$12 A\x7cA0\x7cB\x7cDOUT0\x7cQ GND\x7cVGND\x7cVSS GND\x7cVGND\x7cVSS
+ nfet L=0.15U W=0.42U AS=0.1118P AD=0.0567P PS=1.04U PD=0.69U
* device instance $29 r0 *1 0,0 nfet
M$29 \$0$13 A\x7cA0\x7cB\x7cDOUT7\x7cQ GND\x7cVGND\x7cVSS GND\x7cVGND\x7cVSS
+ nfet L=0.15U W=0.65U AS=0.08775P AD=0.08775P PS=0.92U PD=0.92U
* device instance $30 r0 *1 0,0 nfet
M$30 \$0$15 A\x7cA0\x7cB\x7cDOUT9\x7cQ \$0$14 GND\x7cVGND\x7cVSS nfet L=0.15U
+ W=0.42U AS=0.1176P AD=0.0567P PS=1.4U PD=0.69U
* device instance $31 r0 *1 0,0 nfet
M$31 SELp0\x7cX \$0$11 GND\x7cVGND\x7cVSS GND\x7cVGND\x7cVSS nfet L=0.15U
+ W=0.65U AS=0.1118P AD=0.182P PS=1.04U PD=1.86U
* device instance $32 r0 *1 0,0 nfet
M$32 ADCOUT7\x7cX B\x7cY \$0$13 GND\x7cVGND\x7cVSS nfet L=0.15U W=0.65U
+ AS=0.08775P AD=0.25025P PS=0.92U PD=1.42U
* device instance $33 r0 *1 0,0 nfet
M$33 \$0$15 A\x7cA0\x7cB\x7cDOUT2\x7cQ GND\x7cVGND\x7cVSS GND\x7cVGND\x7cVSS
+ nfet L=0.15U W=0.42U AS=0.1118P AD=0.0567P PS=1.04U PD=0.69U
* device instance $34 r0 *1 0,0 nfet
M$34 \$0$17 A\x7cA0\x7cB\x7cDOUT9\x7cQ \$0$16 GND\x7cVGND\x7cVSS nfet L=0.15U
+ W=0.42U AS=0.1176P AD=0.0567P PS=1.4U PD=0.69U
* device instance $35 r0 *1 0,0 nfet
M$35 \$0$17 A\x7cA0\x7cB\x7cDOUT6\x7cQ GND\x7cVGND\x7cVSS GND\x7cVGND\x7cVSS
+ nfet L=0.15U W=0.42U AS=0.1118P AD=0.0567P PS=1.04U PD=0.69U
* device instance $36 r0 *1 0,0 nfet
M$36 SELp2\x7cX \$0$14 GND\x7cVGND\x7cVSS GND\x7cVGND\x7cVSS nfet L=0.15U
+ W=0.65U AS=0.1118P AD=0.182P PS=1.04U PD=1.86U
* device instance $37 r0 *1 0,0 nfet
M$37 GND\x7cVGND\x7cVSS \$0$10 ADCOUT7\x7cX GND\x7cVGND\x7cVSS nfet L=0.15U
+ W=0.65U AS=0.25025P AD=0.208P PS=1.42U PD=1.94U
* device instance $38 r0 *1 0,0 nfet
M$38 SELp6\x7cX \$0$16 GND\x7cVGND\x7cVSS GND\x7cVGND\x7cVSS nfet L=0.15U
+ W=0.65U AS=0.1118P AD=0.182P PS=1.04U PD=1.86U
* device instance $39 r0 *1 0,0 nfet
M$39 \$0$19 A\x7cA0\x7cB\x7cDOUT3\x7cQ \$0$18 GND\x7cVGND\x7cVSS nfet L=0.15U
+ W=0.42U AS=0.1176P AD=0.0567P PS=1.4U PD=0.69U
* device instance $40 r0 *1 0,0 nfet
M$40 \$0$19 B\x7cY GND\x7cVGND\x7cVSS GND\x7cVGND\x7cVSS nfet L=0.15U W=0.42U
+ AS=0.1118P AD=0.0567P PS=1.04U PD=0.69U
* device instance $41 r0 *1 0,0 nfet
M$41 \$0$21 A\x7cA0\x7cB\x7cDOUT7\x7cQ \$0$20 GND\x7cVGND\x7cVSS nfet L=0.15U
+ W=0.42U AS=0.1176P AD=0.0567P PS=1.4U PD=0.69U
* device instance $42 r0 *1 0,0 nfet
M$42 \$0$21 B\x7cY GND\x7cVGND\x7cVSS GND\x7cVGND\x7cVSS nfet L=0.15U W=0.42U
+ AS=0.1118P AD=0.0567P PS=1.04U PD=0.69U
* device instance $43 r0 *1 0,0 nfet
M$43 SELn3\x7cX \$0$18 GND\x7cVGND\x7cVSS GND\x7cVGND\x7cVSS nfet L=0.15U
+ W=0.65U AS=0.1118P AD=0.182P PS=1.04U PD=1.86U
* device instance $44 r0 *1 0,0 nfet
M$44 SELn7\x7cX \$0$20 GND\x7cVGND\x7cVSS GND\x7cVGND\x7cVSS nfet L=0.15U
+ W=0.65U AS=0.1118P AD=0.182P PS=1.04U PD=1.86U
* device instance $45 r0 *1 0,0 nfet
M$45 \$0$23 A\x7cA0\x7cB\x7cDOUT9\x7cQ \$0$22 GND\x7cVGND\x7cVSS nfet L=0.15U
+ W=0.65U AS=0.169P AD=0.06825P PS=1.82U PD=0.86U
* device instance $46 r0 *1 0,0 nfet
M$46 GND\x7cVGND\x7cVSS A\x7cA1\x7cOUTN\x7cOUTN_NC \$0$23 GND\x7cVGND\x7cVSS
+ nfet L=0.15U W=0.65U AS=0.06825P AD=0.08775P PS=0.86U PD=0.92U
* device instance $47 r0 *1 0,0 nfet
M$47 \$0$24 A\x7cA1\x7cOUTN\x7cOUTN_NC GND\x7cVGND\x7cVSS GND\x7cVGND\x7cVSS
+ nfet L=0.15U W=0.65U AS=0.08775P AD=0.169P PS=0.92U PD=1.82U
* device instance $48 r0 *1 0,0 nfet
M$48 GND\x7cVGND\x7cVSS \$0$25 DUMLOAD_MUX_NC\x7cX GND\x7cVGND\x7cVSS nfet
+ L=0.15U W=0.65U AS=0.169P AD=0.11285P PS=1.82U PD=1.045U
* device instance $49 r0 *1 0,0 nfet
M$49 \$0$26 A\x7cA_N\x7cD\x7cPH_B9\x7cQ\x7cS GND\x7cVGND\x7cVSS
+ GND\x7cVGND\x7cVSS nfet L=0.15U W=0.42U AS=0.1092P AD=0.1092P PS=1.36U
+ PD=1.36U
* device instance $50 r0 *1 0,0 nfet
M$50 \$0$27 A\x7cA_N\x7cD\x7cPH_B9\x7cQ\x7cS GND\x7cVGND\x7cVSS
+ GND\x7cVGND\x7cVSS nfet L=0.15U W=0.42U AS=0.11285P AD=0.0693P PS=1.045U
+ PD=0.75U
* device instance $51 r0 *1 0,0 nfet
M$51 \$0$24 A\x7cA0\x7cB\x7cDOUT9\x7cQ GND\x7cVGND\x7cVSS GND\x7cVGND\x7cVSS
+ nfet L=0.15U W=0.65U AS=0.169P AD=0.08775P PS=1.82U PD=0.92U
* device instance $52 r0 *1 0,0 nfet
M$52 \$0$29 \$0$26 \$0$28 GND\x7cVGND\x7cVSS nfet L=0.15U W=0.42U AS=0.1092P
+ AD=0.0504P PS=1.36U PD=0.66U
* device instance $53 r0 *1 0,0 nfet
M$53 \$0$25 A\x7cA1\x7cOUTN\x7cOUTN_NC \$0$27 GND\x7cVGND\x7cVSS nfet L=0.15U
+ W=0.42U AS=0.0693P AD=0.09975P PS=0.75U PD=0.895U
* device instance $54 r0 *1 0,0 nfet
M$54 DUMLOAD_XNOR_NC\x7cY \$0$22 \$0$24 GND\x7cVGND\x7cVSS nfet L=0.15U W=0.65U
+ AS=0.08775P AD=0.195P PS=0.92U PD=1.9U
* device instance $55 r0 *1 0,0 nfet
M$55 \$0$29 A\x7cB\x7cBUSY\x7cX GND\x7cVGND\x7cVSS GND\x7cVGND\x7cVSS nfet
+ L=0.15U W=0.42U AS=0.1013P AD=0.0504P PS=0.99U PD=0.66U
* device instance $56 r0 *1 0,0 nfet
M$56 \$0$30 A\x7cA0\x7cB\x7cDOUT9\x7cQ \$0$25 GND\x7cVGND\x7cVSS nfet L=0.15U
+ W=0.42U AS=0.09975P AD=0.0693P PS=0.895U PD=0.75U
* device instance $57 r0 *1 0,0 nfet
M$57 A\x7cHALF_LSB_EN\x7cX \$0$28 GND\x7cVGND\x7cVSS GND\x7cVGND\x7cVSS nfet
+ L=0.15U W=0.65U AS=0.1013P AD=0.169P PS=0.99U PD=1.82U
* device instance $58 r0 *1 0,0 nfet
M$58 GND\x7cVGND\x7cVSS \$0$31 \$0$30 GND\x7cVGND\x7cVSS nfet L=0.15U W=0.42U
+ AS=0.0693P AD=0.1449P PS=0.75U PD=1.11U
* device instance $59 r0 *1 0,0 nfet
M$59 \$0$33 A\x7cA0\x7cB\x7cDOUT9\x7cQ \$0$32 GND\x7cVGND\x7cVSS nfet L=0.15U
+ W=0.42U AS=0.1176P AD=0.0567P PS=1.4U PD=0.69U
* device instance $60 r0 *1 0,0 nfet
M$60 \$0$31 A\x7cA_N\x7cD\x7cPH_B9\x7cQ\x7cS GND\x7cVGND\x7cVSS
+ GND\x7cVGND\x7cVSS nfet L=0.15U W=0.42U AS=0.1449P AD=0.1092P PS=1.11U
+ PD=1.36U
* device instance $61 r0 *1 0,0 nfet
M$61 \$0$33 A\x7cA0\x7cB\x7cDOUT1\x7cQ GND\x7cVGND\x7cVSS GND\x7cVGND\x7cVSS
+ nfet L=0.15U W=0.42U AS=0.1118P AD=0.0567P PS=1.04U PD=0.69U
* device instance $62 r0 *1 0,0 nfet
M$62 \$0$34 B\x7cY GND\x7cVGND\x7cVSS GND\x7cVGND\x7cVSS nfet L=0.15U W=0.65U
+ AS=0.169P AD=0.08775P PS=1.82U PD=0.92U
* device instance $63 r0 *1 0,0 nfet
M$63 SELp1\x7cX \$0$32 GND\x7cVGND\x7cVSS GND\x7cVGND\x7cVSS nfet L=0.15U
+ W=0.65U AS=0.1118P AD=0.182P PS=1.04U PD=1.86U
* device instance $64 r0 *1 0,0 nfet
M$64 GND\x7cVGND\x7cVSS A\x7cA0\x7cB\x7cDOUT1\x7cQ \$0$34 GND\x7cVGND\x7cVSS
+ nfet L=0.15U W=0.65U AS=0.08775P AD=0.08775P PS=0.92U PD=0.92U
* device instance $65 r0 *1 0,0 nfet
M$65 \$0$35 A\x7cA0\x7cB\x7cDOUT1\x7cQ GND\x7cVGND\x7cVSS GND\x7cVGND\x7cVSS
+ nfet L=0.15U W=0.65U AS=0.08775P AD=0.08775P PS=0.92U PD=0.92U
* device instance $66 r0 *1 0,0 nfet
M$66 \$0$37 A\x7cA0\x7cB\x7cDOUT2\x7cQ \$0$36 GND\x7cVGND\x7cVSS nfet L=0.15U
+ W=0.42U AS=0.1176P AD=0.0567P PS=1.4U PD=0.69U
* device instance $67 r0 *1 0,0 nfet
M$67 ADCOUT1\x7cX B\x7cY \$0$35 GND\x7cVGND\x7cVSS nfet L=0.15U W=0.65U
+ AS=0.08775P AD=0.25025P PS=0.92U PD=1.42U
* device instance $68 r0 *1 0,0 nfet
M$68 \$0$37 B\x7cY GND\x7cVGND\x7cVSS GND\x7cVGND\x7cVSS nfet L=0.15U W=0.42U
+ AS=0.1118P AD=0.0567P PS=1.04U PD=0.69U
* device instance $69 r0 *1 0,0 nfet
M$69 \$0$38 B\x7cY GND\x7cVGND\x7cVSS GND\x7cVGND\x7cVSS nfet L=0.15U W=0.65U
+ AS=0.169P AD=0.08775P PS=1.82U PD=0.92U
* device instance $70 r0 *1 0,0 nfet
M$70 SELn2\x7cX \$0$36 GND\x7cVGND\x7cVSS GND\x7cVGND\x7cVSS nfet L=0.15U
+ W=0.65U AS=0.1118P AD=0.182P PS=1.04U PD=1.86U
* device instance $71 r0 *1 0,0 nfet
M$71 GND\x7cVGND\x7cVSS \$0$34 ADCOUT1\x7cX GND\x7cVGND\x7cVSS nfet L=0.15U
+ W=0.65U AS=0.25025P AD=0.208P PS=1.42U PD=1.94U
* device instance $72 r0 *1 0,0 nfet
M$72 GND\x7cVGND\x7cVSS A\x7cA0\x7cB\x7cDOUT4\x7cQ \$0$38 GND\x7cVGND\x7cVSS
+ nfet L=0.15U W=0.65U AS=0.08775P AD=0.08775P PS=0.92U PD=0.92U
* device instance $73 r0 *1 0,0 nfet
M$73 \$0$39 A\x7cA0\x7cB\x7cDOUT4\x7cQ GND\x7cVGND\x7cVSS GND\x7cVGND\x7cVSS
+ nfet L=0.15U W=0.65U AS=0.08775P AD=0.08775P PS=0.92U PD=0.92U
* device instance $74 r0 *1 0,0 nfet
M$74 ADCOUT4\x7cX B\x7cY \$0$39 GND\x7cVGND\x7cVSS nfet L=0.15U W=0.65U
+ AS=0.08775P AD=0.25025P PS=0.92U PD=1.42U
* device instance $75 r0 *1 0,0 nfet
M$75 \$0$40 B\x7cY GND\x7cVGND\x7cVSS GND\x7cVGND\x7cVSS nfet L=0.15U W=0.65U
+ AS=0.169P AD=0.08775P PS=1.82U PD=0.92U
* device instance $76 r0 *1 0,0 nfet
M$76 GND\x7cVGND\x7cVSS A\x7cA0\x7cB\x7cDOUT5\x7cQ \$0$40 GND\x7cVGND\x7cVSS
+ nfet L=0.15U W=0.65U AS=0.08775P AD=0.08775P PS=0.92U PD=0.92U
* device instance $77 r0 *1 0,0 nfet
M$77 GND\x7cVGND\x7cVSS \$0$38 ADCOUT4\x7cX GND\x7cVGND\x7cVSS nfet L=0.15U
+ W=0.65U AS=0.25025P AD=0.208P PS=1.42U PD=1.94U
* device instance $78 r0 *1 0,0 nfet
M$78 \$0$41 A\x7cA0\x7cB\x7cDOUT5\x7cQ GND\x7cVGND\x7cVSS GND\x7cVGND\x7cVSS
+ nfet L=0.15U W=0.65U AS=0.08775P AD=0.08775P PS=0.92U PD=0.92U
* device instance $79 r0 *1 0,0 nfet
M$79 \$0$42 B\x7cY GND\x7cVGND\x7cVSS GND\x7cVGND\x7cVSS nfet L=0.15U W=0.65U
+ AS=0.169P AD=0.08775P PS=1.82U PD=0.92U
* device instance $80 r0 *1 0,0 nfet
M$80 ADCOUT5\x7cX B\x7cY \$0$41 GND\x7cVGND\x7cVSS nfet L=0.15U W=0.65U
+ AS=0.08775P AD=0.25025P PS=0.92U PD=1.42U
* device instance $81 r0 *1 0,0 nfet
M$81 GND\x7cVGND\x7cVSS A\x7cA0\x7cB\x7cDOUT6\x7cQ \$0$42 GND\x7cVGND\x7cVSS
+ nfet L=0.15U W=0.65U AS=0.08775P AD=0.08775P PS=0.92U PD=0.92U
* device instance $82 r0 *1 0,0 nfet
M$82 \$0$43 A\x7cA0\x7cB\x7cDOUT6\x7cQ GND\x7cVGND\x7cVSS GND\x7cVGND\x7cVSS
+ nfet L=0.15U W=0.65U AS=0.08775P AD=0.08775P PS=0.92U PD=0.92U
* device instance $83 r0 *1 0,0 nfet
M$83 GND\x7cVGND\x7cVSS \$0$40 ADCOUT5\x7cX GND\x7cVGND\x7cVSS nfet L=0.15U
+ W=0.65U AS=0.25025P AD=0.208P PS=1.42U PD=1.94U
* device instance $84 r0 *1 0,0 nfet
M$84 ADCOUT6\x7cX B\x7cY \$0$43 GND\x7cVGND\x7cVSS nfet L=0.15U W=0.65U
+ AS=0.08775P AD=0.25025P PS=0.92U PD=1.42U
* device instance $85 r0 *1 0,0 nfet
M$85 GND\x7cVGND\x7cVSS \$0$42 ADCOUT6\x7cX GND\x7cVGND\x7cVSS nfet L=0.15U
+ W=0.65U AS=0.25025P AD=0.208P PS=1.42U PD=1.94U
* device instance $86 r0 *1 0,0 nfet
M$86 CLK\x7cCLKN\x7cY A\x7cCLK GND\x7cVGND\x7cVSS GND\x7cVGND\x7cVSS nfet
+ L=0.15U W=0.65U AS=0.169P AD=0.169P PS=1.82U PD=1.82U
* device instance $87 r0 *1 0,0 nfet
M$87 \$0$45 A\x7cA0\x7cB\x7cDOUT9\x7cQ \$0$44 GND\x7cVGND\x7cVSS nfet L=0.15U
+ W=0.42U AS=0.1176P AD=0.0567P PS=1.4U PD=0.69U
* device instance $88 r0 *1 0,0 nfet
M$88 \$0$45 A\x7cA0\x7cB\x7cDOUT7\x7cQ GND\x7cVGND\x7cVSS GND\x7cVGND\x7cVSS
+ nfet L=0.15U W=0.42U AS=0.1118P AD=0.0567P PS=1.04U PD=0.69U
* device instance $89 r0 *1 0,0 nfet
M$89 \$0$47 A\x7cA0\x7cB\x7cDOUT1\x7cQ \$0$46 GND\x7cVGND\x7cVSS nfet L=0.15U
+ W=0.42U AS=0.1176P AD=0.0567P PS=1.4U PD=0.69U
* device instance $90 r0 *1 0,0 nfet
M$90 \$0$47 B\x7cY GND\x7cVGND\x7cVSS GND\x7cVGND\x7cVSS nfet L=0.15U W=0.42U
+ AS=0.1118P AD=0.0567P PS=1.04U PD=0.69U
* device instance $91 r0 *1 0,0 nfet
M$91 SELp7\x7cX \$0$44 GND\x7cVGND\x7cVSS GND\x7cVGND\x7cVSS nfet L=0.15U
+ W=0.65U AS=0.1118P AD=0.182P PS=1.04U PD=1.86U
* device instance $92 r0 *1 0,0 nfet
M$92 \$0$49 A\x7cA0\x7cB\x7cDOUT9\x7cQ \$0$48 GND\x7cVGND\x7cVSS nfet L=0.15U
+ W=0.42U AS=0.1176P AD=0.0567P PS=1.4U PD=0.69U
* device instance $93 r0 *1 0,0 nfet
M$93 \$0$51 A\x7cA0\x7cB\x7cDOUT9\x7cQ \$0$50 GND\x7cVGND\x7cVSS nfet L=0.15U
+ W=0.42U AS=0.1176P AD=0.0567P PS=1.4U PD=0.69U
* device instance $94 r0 *1 0,0 nfet
M$94 SELn1\x7cX \$0$46 GND\x7cVGND\x7cVSS GND\x7cVGND\x7cVSS nfet L=0.15U
+ W=0.65U AS=0.1118P AD=0.182P PS=1.04U PD=1.86U
* device instance $95 r0 *1 0,0 nfet
M$95 \$0$49 A\x7cA0\x7cB\x7cDOUT8\x7cQ GND\x7cVGND\x7cVSS GND\x7cVGND\x7cVSS
+ nfet L=0.15U W=0.42U AS=0.1118P AD=0.0567P PS=1.04U PD=0.69U
* device instance $96 r0 *1 0,0 nfet
M$96 \$0$51 A\x7cA0\x7cB\x7cDOUT5\x7cQ GND\x7cVGND\x7cVSS GND\x7cVGND\x7cVSS
+ nfet L=0.15U W=0.42U AS=0.1118P AD=0.0567P PS=1.04U PD=0.69U
* device instance $97 r0 *1 0,0 nfet
M$97 SELp8\x7cX \$0$48 GND\x7cVGND\x7cVSS GND\x7cVGND\x7cVSS nfet L=0.15U
+ W=0.65U AS=0.1118P AD=0.182P PS=1.04U PD=1.86U
* device instance $98 r0 *1 0,0 nfet
M$98 SELp5\x7cX \$0$50 GND\x7cVGND\x7cVSS GND\x7cVGND\x7cVSS nfet L=0.15U
+ W=0.65U AS=0.1118P AD=0.182P PS=1.04U PD=1.86U
* device instance $99 r0 *1 0,0 nfet
M$99 \$0$53 A\x7cA0\x7cB\x7cDOUT9\x7cQ \$0$52 GND\x7cVGND\x7cVSS nfet L=0.15U
+ W=0.42U AS=0.1176P AD=0.0567P PS=1.4U PD=0.69U
* device instance $100 r0 *1 0,0 nfet
M$100 \$0$55 A\x7cA0\x7cB\x7cDOUT0\x7cQ \$0$54 GND\x7cVGND\x7cVSS nfet L=0.15U
+ W=0.42U AS=0.1176P AD=0.0567P PS=1.4U PD=0.69U
* device instance $101 r0 *1 0,0 nfet
M$101 \$0$53 A\x7cA0\x7cB\x7cDOUT3\x7cQ GND\x7cVGND\x7cVSS GND\x7cVGND\x7cVSS
+ nfet L=0.15U W=0.42U AS=0.1118P AD=0.0567P PS=1.04U PD=0.69U
* device instance $102 r0 *1 0,0 nfet
M$102 \$0$55 B\x7cY GND\x7cVGND\x7cVSS GND\x7cVGND\x7cVSS nfet L=0.15U W=0.42U
+ AS=0.1118P AD=0.0567P PS=1.04U PD=0.69U
* device instance $103 r0 *1 0,0 nfet
M$103 SELp3\x7cX \$0$52 GND\x7cVGND\x7cVSS GND\x7cVGND\x7cVSS nfet L=0.15U
+ W=0.65U AS=0.1118P AD=0.182P PS=1.04U PD=1.86U
* device instance $104 r0 *1 0,0 nfet
M$104 SELn0\x7cX \$0$54 GND\x7cVGND\x7cVSS GND\x7cVGND\x7cVSS nfet L=0.15U
+ W=0.65U AS=0.1118P AD=0.182P PS=1.04U PD=1.86U
* device instance $105 r0 *1 0,0 nfet
M$105 B\x7cY A\x7cA0\x7cB\x7cDOUT9\x7cQ GND\x7cVGND\x7cVSS GND\x7cVGND\x7cVSS
+ nfet L=0.15U W=0.65U AS=0.169P AD=0.169P PS=1.82U PD=1.82U
* device instance $106 r0 *1 0,0 nfet
M$106 \$0$57 A\x7cA0\x7cB\x7cDOUT5\x7cQ \$0$56 GND\x7cVGND\x7cVSS nfet L=0.15U
+ W=0.42U AS=0.1176P AD=0.0567P PS=1.4U PD=0.69U
* device instance $107 r0 *1 0,0 nfet
M$107 \$0$57 B\x7cY GND\x7cVGND\x7cVSS GND\x7cVGND\x7cVSS nfet L=0.15U W=0.42U
+ AS=0.1118P AD=0.0567P PS=1.04U PD=0.69U
* device instance $108 r0 *1 0,0 nfet
M$108 \$0$59 A\x7cA0\x7cB\x7cDOUT4\x7cQ \$0$58 GND\x7cVGND\x7cVSS nfet L=0.15U
+ W=0.42U AS=0.1176P AD=0.0567P PS=1.4U PD=0.69U
* device instance $109 r0 *1 0,0 nfet
M$109 \$0$59 B\x7cY GND\x7cVGND\x7cVSS GND\x7cVGND\x7cVSS nfet L=0.15U W=0.42U
+ AS=0.1118P AD=0.0567P PS=1.04U PD=0.69U
* device instance $110 r0 *1 0,0 nfet
M$110 \$0$61 A\x7cA0\x7cB\x7cDOUT9\x7cQ \$0$60 GND\x7cVGND\x7cVSS nfet L=0.15U
+ W=0.42U AS=0.1176P AD=0.0567P PS=1.4U PD=0.69U
* device instance $111 r0 *1 0,0 nfet
M$111 \$0$63 A\x7cA0\x7cB\x7cDOUT6\x7cQ \$0$62 GND\x7cVGND\x7cVSS nfet L=0.15U
+ W=0.42U AS=0.1176P AD=0.0567P PS=1.4U PD=0.69U
* device instance $112 r0 *1 0,0 nfet
M$112 SELn5\x7cX \$0$56 GND\x7cVGND\x7cVSS GND\x7cVGND\x7cVSS nfet L=0.15U
+ W=0.65U AS=0.1118P AD=0.182P PS=1.04U PD=1.86U
* device instance $113 r0 *1 0,0 nfet
M$113 \$0$61 A\x7cA0\x7cB\x7cDOUT4\x7cQ GND\x7cVGND\x7cVSS GND\x7cVGND\x7cVSS
+ nfet L=0.15U W=0.42U AS=0.1118P AD=0.0567P PS=1.04U PD=0.69U
* device instance $114 r0 *1 0,0 nfet
M$114 \$0$63 B\x7cY GND\x7cVGND\x7cVSS GND\x7cVGND\x7cVSS nfet L=0.15U W=0.42U
+ AS=0.1118P AD=0.0567P PS=1.04U PD=0.69U
* device instance $115 r0 *1 0,0 nfet
M$115 SELn4\x7cX \$0$58 GND\x7cVGND\x7cVSS GND\x7cVGND\x7cVSS nfet L=0.15U
+ W=0.65U AS=0.1118P AD=0.182P PS=1.04U PD=1.86U
* device instance $116 r0 *1 0,0 nfet
M$116 SELp4\x7cX \$0$60 GND\x7cVGND\x7cVSS GND\x7cVGND\x7cVSS nfet L=0.15U
+ W=0.65U AS=0.1118P AD=0.182P PS=1.04U PD=1.86U
* device instance $117 r0 *1 0,0 nfet
M$117 SELn6\x7cX \$0$62 GND\x7cVGND\x7cVSS GND\x7cVGND\x7cVSS nfet L=0.15U
+ W=0.65U AS=0.1118P AD=0.182P PS=1.04U PD=1.86U
* device instance $118 r0 *1 0,0 pfet
M$118 \$0$64 B\x7cY \$0 VPB\x7cVPWR pfet L=0.15U W=1U AS=0.26P AD=0.135P
+ PS=2.52U PD=1.27U
* device instance $119 r0 *1 0,0 pfet
M$119 VPB\x7cVPWR A\x7cA0\x7cB\x7cDOUT0\x7cQ \$0$64 VPB\x7cVPWR pfet L=0.15U
+ W=1U AS=0.135P AD=0.135P PS=1.27U PD=1.27U
* device instance $120 r0 *1 0,0 pfet
M$120 \$0$65 A\x7cA0\x7cB\x7cDOUT0\x7cQ VPB\x7cVPWR VPB\x7cVPWR pfet L=0.15U
+ W=1U AS=0.135P AD=0.135P PS=1.27U PD=1.27U
* device instance $121 r0 *1 0,0 pfet
M$121 \$0$66 B\x7cY \$0$2 VPB\x7cVPWR pfet L=0.15U W=1U AS=0.26P AD=0.135P
+ PS=2.52U PD=1.27U
* device instance $122 r0 *1 0,0 pfet
M$122 VPB\x7cVPWR B\x7cY \$0$65 VPB\x7cVPWR pfet L=0.15U W=1U AS=0.135P
+ AD=0.26P PS=1.27U PD=2.52U
* device instance $123 r0 *1 0,0 pfet
M$123 VPB\x7cVPWR A\x7cA0\x7cB\x7cDOUT2\x7cQ \$0$66 VPB\x7cVPWR pfet L=0.15U
+ W=1U AS=0.135P AD=0.135P PS=1.27U PD=1.27U
* device instance $124 r0 *1 0,0 pfet
M$124 \$0$67 A\x7cA0\x7cB\x7cDOUT2\x7cQ VPB\x7cVPWR VPB\x7cVPWR pfet L=0.15U
+ W=1U AS=0.135P AD=0.135P PS=1.27U PD=1.27U
* device instance $125 r0 *1 0,0 pfet
M$125 \$0$68 B\x7cY \$0$4 VPB\x7cVPWR pfet L=0.15U W=1U AS=0.26P AD=0.135P
+ PS=2.52U PD=1.27U
* device instance $126 r0 *1 0,0 pfet
M$126 VPB\x7cVPWR B\x7cY \$0$67 VPB\x7cVPWR pfet L=0.15U W=1U AS=0.135P
+ AD=0.26P PS=1.27U PD=2.52U
* device instance $127 r0 *1 0,0 pfet
M$127 ADCOUT0\x7cX \$0 \$0$65 VPB\x7cVPWR pfet L=0.15U W=1U AS=0.26P AD=0.3P
+ PS=2.52U PD=2.6U
* device instance $128 r0 *1 0,0 pfet
M$128 VPB\x7cVPWR A\x7cA0\x7cB\x7cDOUT8\x7cQ \$0$68 VPB\x7cVPWR pfet L=0.15U
+ W=1U AS=0.135P AD=0.135P PS=1.27U PD=1.27U
* device instance $129 r0 *1 0,0 pfet
M$129 \$0$69 A\x7cA0\x7cB\x7cDOUT8\x7cQ VPB\x7cVPWR VPB\x7cVPWR pfet L=0.15U
+ W=1U AS=0.135P AD=0.135P PS=1.27U PD=1.27U
* device instance $130 r0 *1 0,0 pfet
M$130 VPB\x7cVPWR B\x7cY \$0$69 VPB\x7cVPWR pfet L=0.15U W=1U AS=0.135P
+ AD=0.26P PS=1.27U PD=2.52U
* device instance $131 r0 *1 0,0 pfet
M$131 ADCOUT2\x7cX \$0$2 \$0$67 VPB\x7cVPWR pfet L=0.15U W=1U AS=0.26P AD=0.3P
+ PS=2.52U PD=2.6U
* device instance $132 r0 *1 0,0 pfet
M$132 ADCOUT8\x7cX \$0$4 \$0$69 VPB\x7cVPWR pfet L=0.15U W=1U AS=0.26P AD=0.3P
+ PS=2.52U PD=2.6U
* device instance $133 r0 *1 0,0 pfet
M$133 \$0$6 A\x7cA0\x7cB\x7cDOUT8\x7cQ VPB\x7cVPWR VPB\x7cVPWR pfet L=0.15U
+ W=0.42U AS=0.1176P AD=0.0567P PS=1.4U PD=0.69U
* device instance $134 r0 *1 0,0 pfet
M$134 \$0$70 B\x7cY \$0$8 VPB\x7cVPWR pfet L=0.15U W=1U AS=0.26P AD=0.135P
+ PS=2.52U PD=1.27U
* device instance $135 r0 *1 0,0 pfet
M$135 \$0$6 B\x7cY VPB\x7cVPWR VPB\x7cVPWR pfet L=0.15U W=0.42U AS=0.16655P
+ AD=0.0567P PS=1.39U PD=0.69U
* device instance $136 r0 *1 0,0 pfet
M$136 VPB\x7cVPWR A\x7cA0\x7cB\x7cDOUT3\x7cQ \$0$70 VPB\x7cVPWR pfet L=0.15U
+ W=1U AS=0.135P AD=0.135P PS=1.27U PD=1.27U
* device instance $137 r0 *1 0,0 pfet
M$137 HALF_LSB_ENN\x7cY A\x7cHALF_LSB_EN\x7cX VPB\x7cVPWR VPB\x7cVPWR pfet
+ L=0.15U W=1U AS=0.26P AD=0.26P PS=2.52U PD=2.52U
* device instance $138 r0 *1 0,0 pfet
M$138 SELn8\x7cX \$0$6 VPB\x7cVPWR VPB\x7cVPWR pfet L=0.15U W=1U AS=0.16655P
+ AD=0.475P PS=1.39U PD=2.95U
* device instance $139 r0 *1 0,0 pfet
M$139 \$0$71 A\x7cA0\x7cB\x7cDOUT3\x7cQ VPB\x7cVPWR VPB\x7cVPWR pfet L=0.15U
+ W=1U AS=0.135P AD=0.135P PS=1.27U PD=1.27U
* device instance $140 r0 *1 0,0 pfet
M$140 VPB\x7cVPWR B\x7cY \$0$71 VPB\x7cVPWR pfet L=0.15U W=1U AS=0.135P
+ AD=0.26P PS=1.27U PD=2.52U
* device instance $141 r0 *1 0,0 pfet
M$141 ADCOUT3\x7cX \$0$8 \$0$71 VPB\x7cVPWR pfet L=0.15U W=1U AS=0.26P AD=0.3P
+ PS=2.52U PD=2.6U
* device instance $142 r0 *1 0,0 pfet
M$142 \$0$72 B\x7cY \$0$10 VPB\x7cVPWR pfet L=0.15U W=1U AS=0.26P AD=0.135P
+ PS=2.52U PD=1.27U
* device instance $143 r0 *1 0,0 pfet
M$143 \$0$11 A\x7cA0\x7cB\x7cDOUT9\x7cQ VPB\x7cVPWR VPB\x7cVPWR pfet L=0.15U
+ W=0.42U AS=0.1176P AD=0.0567P PS=1.4U PD=0.69U
* device instance $144 r0 *1 0,0 pfet
M$144 VPB\x7cVPWR A\x7cA0\x7cB\x7cDOUT7\x7cQ \$0$72 VPB\x7cVPWR pfet L=0.15U
+ W=1U AS=0.135P AD=0.135P PS=1.27U PD=1.27U
* device instance $145 r0 *1 0,0 pfet
M$145 \$0$11 A\x7cA0\x7cB\x7cDOUT0\x7cQ VPB\x7cVPWR VPB\x7cVPWR pfet L=0.15U
+ W=0.42U AS=0.16655P AD=0.0567P PS=1.39U PD=0.69U
* device instance $146 r0 *1 0,0 pfet
M$146 \$0$73 A\x7cA0\x7cB\x7cDOUT7\x7cQ VPB\x7cVPWR VPB\x7cVPWR pfet L=0.15U
+ W=1U AS=0.135P AD=0.135P PS=1.27U PD=1.27U
* device instance $147 r0 *1 0,0 pfet
M$147 \$0$14 A\x7cA0\x7cB\x7cDOUT9\x7cQ VPB\x7cVPWR VPB\x7cVPWR pfet L=0.15U
+ W=0.42U AS=0.1176P AD=0.0567P PS=1.4U PD=0.69U
* device instance $148 r0 *1 0,0 pfet
M$148 SELp0\x7cX \$0$11 VPB\x7cVPWR VPB\x7cVPWR pfet L=0.15U W=1U AS=0.16655P
+ AD=0.475P PS=1.39U PD=2.95U
* device instance $149 r0 *1 0,0 pfet
M$149 VPB\x7cVPWR B\x7cY \$0$73 VPB\x7cVPWR pfet L=0.15U W=1U AS=0.135P
+ AD=0.26P PS=1.27U PD=2.52U
* device instance $150 r0 *1 0,0 pfet
M$150 \$0$14 A\x7cA0\x7cB\x7cDOUT2\x7cQ VPB\x7cVPWR VPB\x7cVPWR pfet L=0.15U
+ W=0.42U AS=0.16655P AD=0.0567P PS=1.39U PD=0.69U
* device instance $151 r0 *1 0,0 pfet
M$151 \$0$16 A\x7cA0\x7cB\x7cDOUT9\x7cQ VPB\x7cVPWR VPB\x7cVPWR pfet L=0.15U
+ W=0.42U AS=0.1176P AD=0.0567P PS=1.4U PD=0.69U
* device instance $152 r0 *1 0,0 pfet
M$152 \$0$16 A\x7cA0\x7cB\x7cDOUT6\x7cQ VPB\x7cVPWR VPB\x7cVPWR pfet L=0.15U
+ W=0.42U AS=0.16655P AD=0.0567P PS=1.39U PD=0.69U
* device instance $153 r0 *1 0,0 pfet
M$153 SELp2\x7cX \$0$14 VPB\x7cVPWR VPB\x7cVPWR pfet L=0.15U W=1U AS=0.16655P
+ AD=0.475P PS=1.39U PD=2.95U
* device instance $154 r0 *1 0,0 pfet
M$154 ADCOUT7\x7cX \$0$10 \$0$73 VPB\x7cVPWR pfet L=0.15U W=1U AS=0.26P AD=0.3P
+ PS=2.52U PD=2.6U
* device instance $155 r0 *1 0,0 pfet
M$155 SELp6\x7cX \$0$16 VPB\x7cVPWR VPB\x7cVPWR pfet L=0.15U W=1U AS=0.16655P
+ AD=0.475P PS=1.39U PD=2.95U
* device instance $156 r0 *1 0,0 pfet
M$156 \$0$18 A\x7cA0\x7cB\x7cDOUT3\x7cQ VPB\x7cVPWR VPB\x7cVPWR pfet L=0.15U
+ W=0.42U AS=0.1176P AD=0.0567P PS=1.4U PD=0.69U
* device instance $157 r0 *1 0,0 pfet
M$157 \$0$18 B\x7cY VPB\x7cVPWR VPB\x7cVPWR pfet L=0.15U W=0.42U AS=0.16655P
+ AD=0.0567P PS=1.39U PD=0.69U
* device instance $158 r0 *1 0,0 pfet
M$158 \$0$20 A\x7cA0\x7cB\x7cDOUT7\x7cQ VPB\x7cVPWR VPB\x7cVPWR pfet L=0.15U
+ W=0.42U AS=0.1176P AD=0.0567P PS=1.4U PD=0.69U
* device instance $159 r0 *1 0,0 pfet
M$159 \$0$20 B\x7cY VPB\x7cVPWR VPB\x7cVPWR pfet L=0.15U W=0.42U AS=0.16655P
+ AD=0.0567P PS=1.39U PD=0.69U
* device instance $160 r0 *1 0,0 pfet
M$160 SELn3\x7cX \$0$18 VPB\x7cVPWR VPB\x7cVPWR pfet L=0.15U W=1U AS=0.16655P
+ AD=0.475P PS=1.39U PD=2.95U
* device instance $161 r0 *1 0,0 pfet
M$161 SELn7\x7cX \$0$20 VPB\x7cVPWR VPB\x7cVPWR pfet L=0.15U W=1U AS=0.16655P
+ AD=0.475P PS=1.39U PD=2.95U
* device instance $162 r0 *1 0,0 pfet
M$162 \$0$22 A\x7cA0\x7cB\x7cDOUT9\x7cQ VPB\x7cVPWR VPB\x7cVPWR pfet L=0.15U
+ W=1U AS=0.3P AD=0.135P PS=2.6U PD=1.27U
* device instance $163 r0 *1 0,0 pfet
M$163 VPB\x7cVPWR A\x7cA1\x7cOUTN\x7cOUTN_NC \$0$22 VPB\x7cVPWR pfet L=0.15U
+ W=1U AS=0.135P AD=0.365P PS=1.27U PD=1.73U
* device instance $164 r0 *1 0,0 pfet
M$164 VPB\x7cVPWR \$0$25 DUMLOAD_MUX_NC\x7cX VPB\x7cVPWR pfet L=0.15U W=1U
+ AS=0.26P AD=0.15835P PS=2.52U PD=1.395U
* device instance $165 r0 *1 0,0 pfet
M$165 VPB\x7cVPWR A\x7cA_N\x7cD\x7cPH_B9\x7cQ\x7cS \$0$26 VPB\x7cVPWR pfet
+ L=0.15U W=0.42U AS=0.1092P AD=0.0714P PS=1.36U PD=0.76U
* device instance $166 r0 *1 0,0 pfet
M$166 \$0$74 A\x7cA1\x7cOUTN\x7cOUTN_NC VPB\x7cVPWR VPB\x7cVPWR pfet L=0.15U
+ W=1U AS=0.365P AD=0.105P PS=1.73U PD=1.21U
* device instance $167 r0 *1 0,0 pfet
M$167 \$0$28 \$0$26 VPB\x7cVPWR VPB\x7cVPWR pfet L=0.15U W=0.42U AS=0.0714P
+ AD=0.0609P PS=0.76U PD=0.71U
* device instance $168 r0 *1 0,0 pfet
M$168 \$0$75 A\x7cA_N\x7cD\x7cPH_B9\x7cQ\x7cS VPB\x7cVPWR VPB\x7cVPWR pfet
+ L=0.15U W=0.42U AS=0.15835P AD=0.07665P PS=1.395U PD=0.785U
* device instance $169 r0 *1 0,0 pfet
M$169 DUMLOAD_XNOR_NC\x7cY A\x7cA0\x7cB\x7cDOUT9\x7cQ \$0$74 VPB\x7cVPWR pfet
+ L=0.15U W=1U AS=0.105P AD=0.165P PS=1.21U PD=1.33U
* device instance $170 r0 *1 0,0 pfet
M$170 VPB\x7cVPWR A\x7cB\x7cBUSY\x7cX \$0$28 VPB\x7cVPWR pfet L=0.15U W=0.42U
+ AS=0.0609P AD=0.2279P PS=0.71U PD=1.74U
* device instance $171 r0 *1 0,0 pfet
M$171 \$0$25 A\x7cA0\x7cB\x7cDOUT9\x7cQ \$0$75 VPB\x7cVPWR pfet L=0.15U W=0.42U
+ AS=0.07665P AD=0.1932P PS=0.785U PD=1.34U
* device instance $172 r0 *1 0,0 pfet
M$172 VPB\x7cVPWR \$0$22 DUMLOAD_XNOR_NC\x7cY VPB\x7cVPWR pfet L=0.15U W=1U
+ AS=0.165P AD=0.36P PS=1.33U PD=2.72U
* device instance $173 r0 *1 0,0 pfet
M$173 A\x7cHALF_LSB_EN\x7cX \$0$28 VPB\x7cVPWR VPB\x7cVPWR pfet L=0.15U W=1U
+ AS=0.2279P AD=0.26P PS=1.74U PD=2.52U
* device instance $174 r0 *1 0,0 pfet
M$174 \$0$76 A\x7cA1\x7cOUTN\x7cOUTN_NC \$0$25 VPB\x7cVPWR pfet L=0.15U W=0.42U
+ AS=0.1932P AD=0.0441P PS=1.34U PD=0.63U
* device instance $175 r0 *1 0,0 pfet
M$175 VPB\x7cVPWR \$0$31 \$0$76 VPB\x7cVPWR pfet L=0.15U W=0.42U AS=0.0441P
+ AD=0.0693P PS=0.63U PD=0.75U
* device instance $176 r0 *1 0,0 pfet
M$176 \$0$32 A\x7cA0\x7cB\x7cDOUT9\x7cQ VPB\x7cVPWR VPB\x7cVPWR pfet L=0.15U
+ W=0.42U AS=0.1176P AD=0.0567P PS=1.4U PD=0.69U
* device instance $177 r0 *1 0,0 pfet
M$177 \$0$31 A\x7cA_N\x7cD\x7cPH_B9\x7cQ\x7cS VPB\x7cVPWR VPB\x7cVPWR pfet
+ L=0.15U W=0.42U AS=0.0693P AD=0.1176P PS=0.75U PD=1.4U
* device instance $178 r0 *1 0,0 pfet
M$178 \$0$32 A\x7cA0\x7cB\x7cDOUT1\x7cQ VPB\x7cVPWR VPB\x7cVPWR pfet L=0.15U
+ W=0.42U AS=0.16655P AD=0.0567P PS=1.39U PD=0.69U
* device instance $179 r0 *1 0,0 pfet
M$179 \$0$77 B\x7cY \$0$34 VPB\x7cVPWR pfet L=0.15U W=1U AS=0.26P AD=0.135P
+ PS=2.52U PD=1.27U
* device instance $180 r0 *1 0,0 pfet
M$180 SELp1\x7cX \$0$32 VPB\x7cVPWR VPB\x7cVPWR pfet L=0.15U W=1U AS=0.16655P
+ AD=0.475P PS=1.39U PD=2.95U
* device instance $181 r0 *1 0,0 pfet
M$181 VPB\x7cVPWR A\x7cA0\x7cB\x7cDOUT1\x7cQ \$0$77 VPB\x7cVPWR pfet L=0.15U
+ W=1U AS=0.135P AD=0.135P PS=1.27U PD=1.27U
* device instance $182 r0 *1 0,0 pfet
M$182 \$0$78 A\x7cA0\x7cB\x7cDOUT1\x7cQ VPB\x7cVPWR VPB\x7cVPWR pfet L=0.15U
+ W=1U AS=0.135P AD=0.135P PS=1.27U PD=1.27U
* device instance $183 r0 *1 0,0 pfet
M$183 \$0$36 A\x7cA0\x7cB\x7cDOUT2\x7cQ VPB\x7cVPWR VPB\x7cVPWR pfet L=0.15U
+ W=0.42U AS=0.1176P AD=0.0567P PS=1.4U PD=0.69U
* device instance $184 r0 *1 0,0 pfet
M$184 VPB\x7cVPWR B\x7cY \$0$78 VPB\x7cVPWR pfet L=0.15U W=1U AS=0.135P
+ AD=0.26P PS=1.27U PD=2.52U
* device instance $185 r0 *1 0,0 pfet
M$185 \$0$36 B\x7cY VPB\x7cVPWR VPB\x7cVPWR pfet L=0.15U W=0.42U AS=0.16655P
+ AD=0.0567P PS=1.39U PD=0.69U
* device instance $186 r0 *1 0,0 pfet
M$186 \$0$79 B\x7cY \$0$38 VPB\x7cVPWR pfet L=0.15U W=1U AS=0.26P AD=0.135P
+ PS=2.52U PD=1.27U
* device instance $187 r0 *1 0,0 pfet
M$187 SELn2\x7cX \$0$36 VPB\x7cVPWR VPB\x7cVPWR pfet L=0.15U W=1U AS=0.16655P
+ AD=0.475P PS=1.39U PD=2.95U
* device instance $188 r0 *1 0,0 pfet
M$188 ADCOUT1\x7cX \$0$34 \$0$78 VPB\x7cVPWR pfet L=0.15U W=1U AS=0.26P AD=0.3P
+ PS=2.52U PD=2.6U
* device instance $189 r0 *1 0,0 pfet
M$189 VPB\x7cVPWR A\x7cA0\x7cB\x7cDOUT4\x7cQ \$0$79 VPB\x7cVPWR pfet L=0.15U
+ W=1U AS=0.135P AD=0.135P PS=1.27U PD=1.27U
* device instance $190 r0 *1 0,0 pfet
M$190 \$0$80 A\x7cA0\x7cB\x7cDOUT4\x7cQ VPB\x7cVPWR VPB\x7cVPWR pfet L=0.15U
+ W=1U AS=0.135P AD=0.135P PS=1.27U PD=1.27U
* device instance $191 r0 *1 0,0 pfet
M$191 VPB\x7cVPWR B\x7cY \$0$80 VPB\x7cVPWR pfet L=0.15U W=1U AS=0.135P
+ AD=0.26P PS=1.27U PD=2.52U
* device instance $192 r0 *1 0,0 pfet
M$192 \$0$81 B\x7cY \$0$40 VPB\x7cVPWR pfet L=0.15U W=1U AS=0.26P AD=0.135P
+ PS=2.52U PD=1.27U
* device instance $193 r0 *1 0,0 pfet
M$193 VPB\x7cVPWR A\x7cA0\x7cB\x7cDOUT5\x7cQ \$0$81 VPB\x7cVPWR pfet L=0.15U
+ W=1U AS=0.135P AD=0.135P PS=1.27U PD=1.27U
* device instance $194 r0 *1 0,0 pfet
M$194 ADCOUT4\x7cX \$0$38 \$0$80 VPB\x7cVPWR pfet L=0.15U W=1U AS=0.26P AD=0.3P
+ PS=2.52U PD=2.6U
* device instance $195 r0 *1 0,0 pfet
M$195 \$0$82 A\x7cA0\x7cB\x7cDOUT5\x7cQ VPB\x7cVPWR VPB\x7cVPWR pfet L=0.15U
+ W=1U AS=0.135P AD=0.135P PS=1.27U PD=1.27U
* device instance $196 r0 *1 0,0 pfet
M$196 \$0$83 B\x7cY \$0$42 VPB\x7cVPWR pfet L=0.15U W=1U AS=0.26P AD=0.135P
+ PS=2.52U PD=1.27U
* device instance $197 r0 *1 0,0 pfet
M$197 VPB\x7cVPWR B\x7cY \$0$82 VPB\x7cVPWR pfet L=0.15U W=1U AS=0.135P
+ AD=0.26P PS=1.27U PD=2.52U
* device instance $198 r0 *1 0,0 pfet
M$198 VPB\x7cVPWR A\x7cA0\x7cB\x7cDOUT6\x7cQ \$0$83 VPB\x7cVPWR pfet L=0.15U
+ W=1U AS=0.135P AD=0.135P PS=1.27U PD=1.27U
* device instance $199 r0 *1 0,0 pfet
M$199 \$0$84 A\x7cA0\x7cB\x7cDOUT6\x7cQ VPB\x7cVPWR VPB\x7cVPWR pfet L=0.15U
+ W=1U AS=0.135P AD=0.135P PS=1.27U PD=1.27U
* device instance $200 r0 *1 0,0 pfet
M$200 VPB\x7cVPWR B\x7cY \$0$84 VPB\x7cVPWR pfet L=0.15U W=1U AS=0.135P
+ AD=0.26P PS=1.27U PD=2.52U
* device instance $201 r0 *1 0,0 pfet
M$201 ADCOUT5\x7cX \$0$40 \$0$82 VPB\x7cVPWR pfet L=0.15U W=1U AS=0.26P AD=0.3P
+ PS=2.52U PD=2.6U
* device instance $202 r0 *1 0,0 pfet
M$202 ADCOUT6\x7cX \$0$42 \$0$84 VPB\x7cVPWR pfet L=0.15U W=1U AS=0.26P AD=0.3P
+ PS=2.52U PD=2.6U
* device instance $203 r0 *1 0,0 pfet
M$203 CLK\x7cCLKN\x7cY A\x7cCLK VPB\x7cVPWR VPB\x7cVPWR pfet L=0.15U W=1U
+ AS=0.26P AD=0.26P PS=2.52U PD=2.52U
* device instance $204 r0 *1 0,0 pfet
M$204 \$0$44 A\x7cA0\x7cB\x7cDOUT9\x7cQ VPB\x7cVPWR VPB\x7cVPWR pfet L=0.15U
+ W=0.42U AS=0.1176P AD=0.0567P PS=1.4U PD=0.69U
* device instance $205 r0 *1 0,0 pfet
M$205 \$0$44 A\x7cA0\x7cB\x7cDOUT7\x7cQ VPB\x7cVPWR VPB\x7cVPWR pfet L=0.15U
+ W=0.42U AS=0.16655P AD=0.0567P PS=1.39U PD=0.69U
* device instance $206 r0 *1 0,0 pfet
M$206 \$0$46 A\x7cA0\x7cB\x7cDOUT1\x7cQ VPB\x7cVPWR VPB\x7cVPWR pfet L=0.15U
+ W=0.42U AS=0.1176P AD=0.0567P PS=1.4U PD=0.69U
* device instance $207 r0 *1 0,0 pfet
M$207 \$0$46 B\x7cY VPB\x7cVPWR VPB\x7cVPWR pfet L=0.15U W=0.42U AS=0.16655P
+ AD=0.0567P PS=1.39U PD=0.69U
* device instance $208 r0 *1 0,0 pfet
M$208 SELp7\x7cX \$0$44 VPB\x7cVPWR VPB\x7cVPWR pfet L=0.15U W=1U AS=0.16655P
+ AD=0.475P PS=1.39U PD=2.95U
* device instance $209 r0 *1 0,0 pfet
M$209 \$0$48 A\x7cA0\x7cB\x7cDOUT9\x7cQ VPB\x7cVPWR VPB\x7cVPWR pfet L=0.15U
+ W=0.42U AS=0.1176P AD=0.0567P PS=1.4U PD=0.69U
* device instance $210 r0 *1 0,0 pfet
M$210 \$0$50 A\x7cA0\x7cB\x7cDOUT9\x7cQ VPB\x7cVPWR VPB\x7cVPWR pfet L=0.15U
+ W=0.42U AS=0.1176P AD=0.0567P PS=1.4U PD=0.69U
* device instance $211 r0 *1 0,0 pfet
M$211 SELn1\x7cX \$0$46 VPB\x7cVPWR VPB\x7cVPWR pfet L=0.15U W=1U AS=0.16655P
+ AD=0.475P PS=1.39U PD=2.95U
* device instance $212 r0 *1 0,0 pfet
M$212 \$0$48 A\x7cA0\x7cB\x7cDOUT8\x7cQ VPB\x7cVPWR VPB\x7cVPWR pfet L=0.15U
+ W=0.42U AS=0.16655P AD=0.0567P PS=1.39U PD=0.69U
* device instance $213 r0 *1 0,0 pfet
M$213 \$0$50 A\x7cA0\x7cB\x7cDOUT5\x7cQ VPB\x7cVPWR VPB\x7cVPWR pfet L=0.15U
+ W=0.42U AS=0.16655P AD=0.0567P PS=1.39U PD=0.69U
* device instance $214 r0 *1 0,0 pfet
M$214 SELp8\x7cX \$0$48 VPB\x7cVPWR VPB\x7cVPWR pfet L=0.15U W=1U AS=0.16655P
+ AD=0.475P PS=1.39U PD=2.95U
* device instance $215 r0 *1 0,0 pfet
M$215 SELp5\x7cX \$0$50 VPB\x7cVPWR VPB\x7cVPWR pfet L=0.15U W=1U AS=0.16655P
+ AD=0.475P PS=1.39U PD=2.95U
* device instance $216 r0 *1 0,0 pfet
M$216 \$0$52 A\x7cA0\x7cB\x7cDOUT9\x7cQ VPB\x7cVPWR VPB\x7cVPWR pfet L=0.15U
+ W=0.42U AS=0.1176P AD=0.0567P PS=1.4U PD=0.69U
* device instance $217 r0 *1 0,0 pfet
M$217 \$0$54 A\x7cA0\x7cB\x7cDOUT0\x7cQ VPB\x7cVPWR VPB\x7cVPWR pfet L=0.15U
+ W=0.42U AS=0.1176P AD=0.0567P PS=1.4U PD=0.69U
* device instance $218 r0 *1 0,0 pfet
M$218 \$0$52 A\x7cA0\x7cB\x7cDOUT3\x7cQ VPB\x7cVPWR VPB\x7cVPWR pfet L=0.15U
+ W=0.42U AS=0.16655P AD=0.0567P PS=1.39U PD=0.69U
* device instance $219 r0 *1 0,0 pfet
M$219 \$0$54 B\x7cY VPB\x7cVPWR VPB\x7cVPWR pfet L=0.15U W=0.42U AS=0.16655P
+ AD=0.0567P PS=1.39U PD=0.69U
* device instance $220 r0 *1 0,0 pfet
M$220 SELp3\x7cX \$0$52 VPB\x7cVPWR VPB\x7cVPWR pfet L=0.15U W=1U AS=0.16655P
+ AD=0.475P PS=1.39U PD=2.95U
* device instance $221 r0 *1 0,0 pfet
M$221 SELn0\x7cX \$0$54 VPB\x7cVPWR VPB\x7cVPWR pfet L=0.15U W=1U AS=0.16655P
+ AD=0.475P PS=1.39U PD=2.95U
* device instance $222 r0 *1 0,0 pfet
M$222 B\x7cY A\x7cA0\x7cB\x7cDOUT9\x7cQ VPB\x7cVPWR VPB\x7cVPWR pfet L=0.15U
+ W=1U AS=0.26P AD=0.26P PS=2.52U PD=2.52U
* device instance $223 r0 *1 0,0 pfet
M$223 \$0$56 A\x7cA0\x7cB\x7cDOUT5\x7cQ VPB\x7cVPWR VPB\x7cVPWR pfet L=0.15U
+ W=0.42U AS=0.1176P AD=0.0567P PS=1.4U PD=0.69U
* device instance $224 r0 *1 0,0 pfet
M$224 \$0$56 B\x7cY VPB\x7cVPWR VPB\x7cVPWR pfet L=0.15U W=0.42U AS=0.16655P
+ AD=0.0567P PS=1.39U PD=0.69U
* device instance $225 r0 *1 0,0 pfet
M$225 \$0$58 A\x7cA0\x7cB\x7cDOUT4\x7cQ VPB\x7cVPWR VPB\x7cVPWR pfet L=0.15U
+ W=0.42U AS=0.1176P AD=0.0567P PS=1.4U PD=0.69U
* device instance $226 r0 *1 0,0 pfet
M$226 \$0$58 B\x7cY VPB\x7cVPWR VPB\x7cVPWR pfet L=0.15U W=0.42U AS=0.16655P
+ AD=0.0567P PS=1.39U PD=0.69U
* device instance $227 r0 *1 0,0 pfet
M$227 \$0$60 A\x7cA0\x7cB\x7cDOUT9\x7cQ VPB\x7cVPWR VPB\x7cVPWR pfet L=0.15U
+ W=0.42U AS=0.1176P AD=0.0567P PS=1.4U PD=0.69U
* device instance $228 r0 *1 0,0 pfet
M$228 \$0$62 A\x7cA0\x7cB\x7cDOUT6\x7cQ VPB\x7cVPWR VPB\x7cVPWR pfet L=0.15U
+ W=0.42U AS=0.1176P AD=0.0567P PS=1.4U PD=0.69U
* device instance $229 r0 *1 0,0 pfet
M$229 SELn5\x7cX \$0$56 VPB\x7cVPWR VPB\x7cVPWR pfet L=0.15U W=1U AS=0.16655P
+ AD=0.475P PS=1.39U PD=2.95U
* device instance $230 r0 *1 0,0 pfet
M$230 \$0$60 A\x7cA0\x7cB\x7cDOUT4\x7cQ VPB\x7cVPWR VPB\x7cVPWR pfet L=0.15U
+ W=0.42U AS=0.16655P AD=0.0567P PS=1.39U PD=0.69U
* device instance $231 r0 *1 0,0 pfet
M$231 \$0$62 B\x7cY VPB\x7cVPWR VPB\x7cVPWR pfet L=0.15U W=0.42U AS=0.16655P
+ AD=0.0567P PS=1.39U PD=0.69U
* device instance $232 r0 *1 0,0 pfet
M$232 SELn4\x7cX \$0$58 VPB\x7cVPWR VPB\x7cVPWR pfet L=0.15U W=1U AS=0.16655P
+ AD=0.475P PS=1.39U PD=2.95U
* device instance $233 r0 *1 0,0 pfet
M$233 SELp4\x7cX \$0$60 VPB\x7cVPWR VPB\x7cVPWR pfet L=0.15U W=1U AS=0.16655P
+ AD=0.475P PS=1.39U PD=2.95U
* device instance $234 r0 *1 0,0 pfet
M$234 SELn6\x7cX \$0$62 VPB\x7cVPWR VPB\x7cVPWR pfet L=0.15U W=1U AS=0.16655P
+ AD=0.475P PS=1.39U PD=2.95U
.ENDS top_glue__top_glue

* cell sar_sequencer__sar_sequencer
* pin GND|VGND|VSS
* pin RESET_B|RST_B
* pin A1|COMP_OUT|OUTP
* pin A|A0|B|DOUT4|Q
* pin A|A0|B|DOUT5|Q
* pin A|A0|B|DOUT3|Q
* pin A|A0|B|DOUT2|Q
* pin A|CLK
* pin A|A0|B|DOUT6|Q
* pin A|A0|B|DOUT1|Q
* pin A|A_N|D|PH_B9|Q|S
* pin A|B|BUSY|X
* pin D|PH_SAMPLE|SAMPLE|Y
* pin A|A0|B|DOUT7|Q
* pin A|A0|B|DOUT0|Q
* pin A|A0|B|DOUT9|Q
* pin A|A0|B|DOUT8|Q
* pin VPB|VPWR
.SUBCKT sar_sequencer__sar_sequencer GND\x7cVGND\x7cVSS RESET_B\x7cRST_B
+ A1\x7cCOMP_OUT\x7cOUTP A\x7cA0\x7cB\x7cDOUT4\x7cQ A\x7cA0\x7cB\x7cDOUT5\x7cQ
+ A\x7cA0\x7cB\x7cDOUT3\x7cQ A\x7cA0\x7cB\x7cDOUT2\x7cQ A\x7cCLK
+ A\x7cA0\x7cB\x7cDOUT6\x7cQ A\x7cA0\x7cB\x7cDOUT1\x7cQ
+ A\x7cA_N\x7cD\x7cPH_B9\x7cQ\x7cS A\x7cB\x7cBUSY\x7cX
+ D\x7cPH_SAMPLE\x7cSAMPLE\x7cY A\x7cA0\x7cB\x7cDOUT7\x7cQ
+ A\x7cA0\x7cB\x7cDOUT0\x7cQ A\x7cA0\x7cB\x7cDOUT9\x7cQ
+ A\x7cA0\x7cB\x7cDOUT8\x7cQ VPB\x7cVPWR
* device instance $1 r0 *1 0,0 nfet
M$1 GND\x7cVGND\x7cVSS A\x7cCLK\x7cX \$0 GND\x7cVGND\x7cVSS nfet L=0.15U
+ W=0.42U AS=0.1092P AD=0.0567P PS=1.36U PD=0.69U
* device instance $2 r0 *1 0,0 nfet
M$2 GND\x7cVGND\x7cVSS CLK\x7cX \$0$1 GND\x7cVGND\x7cVSS nfet L=0.15U W=0.42U
+ AS=0.1092P AD=0.0567P PS=1.36U PD=0.69U
* device instance $3 r0 *1 0,0 nfet
M$3 GND\x7cVGND\x7cVSS CLK\x7cX \$0$2 GND\x7cVGND\x7cVSS nfet L=0.15U W=0.42U
+ AS=0.1092P AD=0.0567P PS=1.36U PD=0.69U
* device instance $4 r0 *1 0,0 nfet
M$4 GND\x7cVGND\x7cVSS CLK\x7cX \$0$3 GND\x7cVGND\x7cVSS nfet L=0.15U W=0.42U
+ AS=0.1092P AD=0.0567P PS=1.36U PD=0.69U
* device instance $5 r0 *1 0,0 nfet
M$5 \$0$4 \$0 GND\x7cVGND\x7cVSS GND\x7cVGND\x7cVSS nfet L=0.15U W=0.42U
+ AS=0.0567P AD=0.1092P PS=0.69U PD=1.36U
* device instance $6 r0 *1 0,0 nfet
M$6 \$0$5 \$0$1 GND\x7cVGND\x7cVSS GND\x7cVGND\x7cVSS nfet L=0.15U W=0.42U
+ AS=0.0567P AD=0.1092P PS=0.69U PD=1.36U
* device instance $7 r0 *1 0,0 nfet
M$7 \$0$6 \$0$2 GND\x7cVGND\x7cVSS GND\x7cVGND\x7cVSS nfet L=0.15U W=0.42U
+ AS=0.0567P AD=0.1092P PS=0.69U PD=1.36U
* device instance $8 r0 *1 0,0 nfet
M$8 \$0$7 \$0$3 GND\x7cVGND\x7cVSS GND\x7cVGND\x7cVSS nfet L=0.15U W=0.42U
+ AS=0.0567P AD=0.1092P PS=0.69U PD=1.36U
* device instance $9 r0 *1 0,0 nfet
M$9 GND\x7cVGND\x7cVSS CLK\x7cX \$0$8 GND\x7cVGND\x7cVSS nfet L=0.15U W=0.42U
+ AS=0.1092P AD=0.0567P PS=1.36U PD=0.69U
* device instance $10 r0 *1 0,0 nfet
M$10 \$0$9 \$0$8 GND\x7cVGND\x7cVSS GND\x7cVGND\x7cVSS nfet L=0.15U W=0.42U
+ AS=0.0567P AD=0.1092P PS=0.69U PD=1.36U
* device instance $11 r0 *1 0,0 nfet
M$11 GND\x7cVGND\x7cVSS A\x7cCLK\x7cX \$0$10 GND\x7cVGND\x7cVSS nfet L=0.15U
+ W=0.42U AS=0.1092P AD=0.0567P PS=1.36U PD=0.69U
* device instance $12 r0 *1 0,0 nfet
M$12 GND\x7cVGND\x7cVSS CLK\x7cX \$0$11 GND\x7cVGND\x7cVSS nfet L=0.15U W=0.42U
+ AS=0.1092P AD=0.0567P PS=1.36U PD=0.69U
* device instance $13 r0 *1 0,0 nfet
M$13 \$0$12 D\x7cX GND\x7cVGND\x7cVSS GND\x7cVGND\x7cVSS nfet L=0.15U W=0.42U
+ AS=0.2205P AD=0.066P PS=1.89U PD=0.745U
* device instance $14 r0 *1 0,0 nfet
M$14 \$0$13 B\x7cD\x7cPH_B4\x7cQ\x7cS GND\x7cVGND\x7cVSS GND\x7cVGND\x7cVSS
+ nfet L=0.15U W=0.42U AS=0.2205P AD=0.066P PS=1.89U PD=0.745U
* device instance $15 r0 *1 0,0 nfet
M$15 \$0$14 D\x7cX_2 GND\x7cVGND\x7cVSS GND\x7cVGND\x7cVSS nfet L=0.15U W=0.42U
+ AS=0.2205P AD=0.066P PS=1.89U PD=0.745U
* device instance $16 r0 *1 0,0 nfet
M$16 \$0$15 C\x7cD\x7cPH_B3\x7cQ\x7cS GND\x7cVGND\x7cVSS GND\x7cVGND\x7cVSS
+ nfet L=0.15U W=0.42U AS=0.2205P AD=0.066P PS=1.89U PD=0.745U
* device instance $17 r0 *1 0,0 nfet
M$17 \$0$16 \$0$10 GND\x7cVGND\x7cVSS GND\x7cVGND\x7cVSS nfet L=0.15U W=0.42U
+ AS=0.0567P AD=0.1092P PS=0.69U PD=1.36U
* device instance $18 r0 *1 0,0 nfet
M$18 \$0$17 \$0$11 GND\x7cVGND\x7cVSS GND\x7cVGND\x7cVSS nfet L=0.15U W=0.42U
+ AS=0.0567P AD=0.1092P PS=0.69U PD=1.36U
* device instance $19 r0 *1 0,0 nfet
M$19 \$0$18 \$0 \$0$12 GND\x7cVGND\x7cVSS nfet L=0.15U W=0.36U AS=0.066P
+ AD=0.0594P PS=0.745U PD=0.69U
* device instance $20 r0 *1 0,0 nfet
M$20 \$0$19 \$0$1 \$0$13 GND\x7cVGND\x7cVSS nfet L=0.15U W=0.36U AS=0.066P
+ AD=0.0594P PS=0.745U PD=0.69U
* device instance $21 r0 *1 0,0 nfet
M$21 \$0$20 \$0$2 \$0$14 GND\x7cVGND\x7cVSS nfet L=0.15U W=0.36U AS=0.066P
+ AD=0.0594P PS=0.745U PD=0.69U
* device instance $22 r0 *1 0,0 nfet
M$22 \$0$21 \$0$3 \$0$15 GND\x7cVGND\x7cVSS nfet L=0.15U W=0.36U AS=0.066P
+ AD=0.0594P PS=0.745U PD=0.69U
* device instance $23 r0 *1 0,0 nfet
M$23 \$0$22 D\x7cX_3 GND\x7cVGND\x7cVSS GND\x7cVGND\x7cVSS nfet L=0.15U W=0.42U
+ AS=0.2205P AD=0.066P PS=1.89U PD=0.745U
* device instance $24 r0 *1 0,0 nfet
M$24 \$0$23 \$0$4 \$0$18 GND\x7cVGND\x7cVSS nfet L=0.15U W=0.36U AS=0.0594P
+ AD=0.1401P PS=0.69U PD=1.1U
* device instance $25 r0 *1 0,0 nfet
M$25 \$0$24 \$0$5 \$0$19 GND\x7cVGND\x7cVSS nfet L=0.15U W=0.36U AS=0.0594P
+ AD=0.1401P PS=0.69U PD=1.1U
* device instance $26 r0 *1 0,0 nfet
M$26 \$0$25 \$0$6 \$0$20 GND\x7cVGND\x7cVSS nfet L=0.15U W=0.36U AS=0.0594P
+ AD=0.1401P PS=0.69U PD=1.1U
* device instance $27 r0 *1 0,0 nfet
M$27 \$0$26 \$0$7 \$0$21 GND\x7cVGND\x7cVSS nfet L=0.15U W=0.36U AS=0.0594P
+ AD=0.1401P PS=0.69U PD=1.1U
* device instance $28 r0 *1 0,0 nfet
M$28 \$0$27 D\x7cX_4 GND\x7cVGND\x7cVSS GND\x7cVGND\x7cVSS nfet L=0.15U W=0.42U
+ AS=0.2205P AD=0.066P PS=1.89U PD=0.745U
* device instance $29 r0 *1 0,0 nfet
M$29 \$0$28 A\x7cD\x7cPH_B5\x7cQ\x7cS GND\x7cVGND\x7cVSS GND\x7cVGND\x7cVSS
+ nfet L=0.15U W=0.42U AS=0.2205P AD=0.066P PS=1.89U PD=0.745U
* device instance $30 r0 *1 0,0 nfet
M$30 \$0$29 \$0$8 \$0$22 GND\x7cVGND\x7cVSS nfet L=0.15U W=0.36U AS=0.066P
+ AD=0.0594P PS=0.745U PD=0.69U
* device instance $31 r0 *1 0,0 nfet
M$31 \$0$31 \$0$30 \$0$23 GND\x7cVGND\x7cVSS nfet L=0.15U W=0.42U AS=0.1401P
+ AD=0.0441P PS=1.1U PD=0.63U
* device instance $32 r0 *1 0,0 nfet
M$32 \$0$33 \$0$32 \$0$24 GND\x7cVGND\x7cVSS nfet L=0.15U W=0.42U AS=0.1401P
+ AD=0.0441P PS=1.1U PD=0.63U
* device instance $33 r0 *1 0,0 nfet
M$33 \$0$35 \$0$34 \$0$25 GND\x7cVGND\x7cVSS nfet L=0.15U W=0.42U AS=0.1401P
+ AD=0.0441P PS=1.1U PD=0.63U
* device instance $34 r0 *1 0,0 nfet
M$34 \$0$37 \$0$36 \$0$26 GND\x7cVGND\x7cVSS nfet L=0.15U W=0.42U AS=0.1401P
+ AD=0.0441P PS=1.1U PD=0.63U
* device instance $35 r0 *1 0,0 nfet
M$35 \$0$38 \$0$10 \$0$27 GND\x7cVGND\x7cVSS nfet L=0.15U W=0.36U AS=0.066P
+ AD=0.0594P PS=0.745U PD=0.69U
* device instance $36 r0 *1 0,0 nfet
M$36 \$0$39 \$0$11 \$0$28 GND\x7cVGND\x7cVSS nfet L=0.15U W=0.36U AS=0.066P
+ AD=0.0594P PS=0.745U PD=0.69U
* device instance $37 r0 *1 0,0 nfet
M$37 \$0$29 \$0$9 \$0$40 GND\x7cVGND\x7cVSS nfet L=0.15U W=0.36U AS=0.1401P
+ AD=0.0594P PS=1.1U PD=0.69U
* device instance $38 r0 *1 0,0 nfet
M$38 GND\x7cVGND\x7cVSS \$0$41 D\x7cX_3 GND\x7cVGND\x7cVSS nfet L=0.15U W=0.65U
+ AS=0.169P AD=0.11285P PS=1.82U PD=1.045U
* device instance $39 r0 *1 0,0 nfet
M$39 GND\x7cVGND\x7cVSS RESET_B\x7cRST_B \$0$31 GND\x7cVGND\x7cVSS nfet L=0.15U
+ W=0.42U AS=0.0441P AD=0.1346P PS=0.63U PD=1.15U
* device instance $40 r0 *1 0,0 nfet
M$40 GND\x7cVGND\x7cVSS RESET_B\x7cRST_B \$0$33 GND\x7cVGND\x7cVSS nfet L=0.15U
+ W=0.42U AS=0.0441P AD=0.1346P PS=0.63U PD=1.15U
* device instance $41 r0 *1 0,0 nfet
M$41 GND\x7cVGND\x7cVSS RESET_B\x7cRST_B \$0$35 GND\x7cVGND\x7cVSS nfet L=0.15U
+ W=0.42U AS=0.0441P AD=0.1346P PS=0.63U PD=1.15U
* device instance $42 r0 *1 0,0 nfet
M$42 GND\x7cVGND\x7cVSS RESET_B\x7cRST_B \$0$37 GND\x7cVGND\x7cVSS nfet L=0.15U
+ W=0.42U AS=0.0441P AD=0.1346P PS=0.63U PD=1.15U
* device instance $43 r0 *1 0,0 nfet
M$43 \$0$38 \$0$16 \$0$42 GND\x7cVGND\x7cVSS nfet L=0.15U W=0.36U AS=0.1401P
+ AD=0.0594P PS=1.1U PD=0.69U
* device instance $44 r0 *1 0,0 nfet
M$44 \$0$39 \$0$17 \$0$43 GND\x7cVGND\x7cVSS nfet L=0.15U W=0.36U AS=0.1401P
+ AD=0.0594P PS=1.1U PD=0.69U
* device instance $45 r0 *1 0,0 nfet
M$45 GND\x7cVGND\x7cVSS \$0$44 D\x7cX GND\x7cVGND\x7cVSS nfet L=0.15U W=0.65U
+ AS=0.169P AD=0.11285P PS=1.82U PD=1.045U
* device instance $46 r0 *1 0,0 nfet
M$46 GND\x7cVGND\x7cVSS \$0$45 D\x7cX_2 GND\x7cVGND\x7cVSS nfet L=0.15U W=0.65U
+ AS=0.169P AD=0.11285P PS=1.82U PD=1.045U
* device instance $47 r0 *1 0,0 nfet
M$47 \$0$46 B\x7cD\x7cPH_B4\x7cQ\x7cS GND\x7cVGND\x7cVSS GND\x7cVGND\x7cVSS
+ nfet L=0.15U W=0.42U AS=0.11285P AD=0.0693P PS=1.045U PD=0.75U
* device instance $48 r0 *1 0,0 nfet
M$48 \$0$48 \$0$47 \$0$40 GND\x7cVGND\x7cVSS nfet L=0.15U W=0.42U AS=0.1401P
+ AD=0.0441P PS=1.1U PD=0.63U
* device instance $49 r0 *1 0,0 nfet
M$49 \$0$30 \$0$18 GND\x7cVGND\x7cVSS GND\x7cVGND\x7cVSS nfet L=0.15U W=0.64U
+ AS=0.1346P AD=0.0999P PS=1.15U PD=0.985U
* device instance $50 r0 *1 0,0 nfet
M$50 \$0$32 \$0$19 GND\x7cVGND\x7cVSS GND\x7cVGND\x7cVSS nfet L=0.15U W=0.64U
+ AS=0.1346P AD=0.0999P PS=1.15U PD=0.985U
* device instance $51 r0 *1 0,0 nfet
M$51 \$0$34 \$0$20 GND\x7cVGND\x7cVSS GND\x7cVGND\x7cVSS nfet L=0.15U W=0.64U
+ AS=0.1346P AD=0.0999P PS=1.15U PD=0.985U
* device instance $52 r0 *1 0,0 nfet
M$52 \$0$36 \$0$21 GND\x7cVGND\x7cVSS GND\x7cVGND\x7cVSS nfet L=0.15U W=0.64U
+ AS=0.1346P AD=0.0999P PS=1.15U PD=0.985U
* device instance $53 r0 *1 0,0 nfet
M$53 \$0$49 A\x7cD\x7cPH_B5\x7cQ\x7cS GND\x7cVGND\x7cVSS GND\x7cVGND\x7cVSS
+ nfet L=0.15U W=0.42U AS=0.11285P AD=0.0693P PS=1.045U PD=0.75U
* device instance $54 r0 *1 0,0 nfet
M$54 \$0$50 C\x7cD\x7cPH_B3\x7cQ\x7cS GND\x7cVGND\x7cVSS GND\x7cVGND\x7cVSS
+ nfet L=0.15U W=0.42U AS=0.11285P AD=0.0693P PS=1.045U PD=0.75U
* device instance $55 r0 *1 0,0 nfet
M$55 \$0$41 A1\x7cCOMP_OUT\x7cOUTP \$0$46 GND\x7cVGND\x7cVSS nfet L=0.15U
+ W=0.42U AS=0.0693P AD=0.09975P PS=0.75U PD=0.895U
* device instance $56 r0 *1 0,0 nfet
M$56 \$0$48 RESET_B\x7cRST_B GND\x7cVGND\x7cVSS GND\x7cVGND\x7cVSS nfet L=0.15U
+ W=0.42U AS=0.1346P AD=0.0441P PS=1.15U PD=0.63U
* device instance $57 r0 *1 0,0 nfet
M$57 \$0$52 \$0$51 \$0$42 GND\x7cVGND\x7cVSS nfet L=0.15U W=0.42U AS=0.1401P
+ AD=0.0441P PS=1.1U PD=0.63U
* device instance $58 r0 *1 0,0 nfet
M$58 \$0$54 \$0$53 \$0$43 GND\x7cVGND\x7cVSS nfet L=0.15U W=0.42U AS=0.1401P
+ AD=0.0441P PS=1.1U PD=0.63U
* device instance $59 r0 *1 0,0 nfet
M$59 \$0$55 \$0$4 \$0$30 GND\x7cVGND\x7cVSS nfet L=0.15U W=0.36U AS=0.0999P
+ AD=0.0711P PS=0.985U PD=0.755U
* device instance $60 r0 *1 0,0 nfet
M$60 \$0$56 \$0$5 \$0$32 GND\x7cVGND\x7cVSS nfet L=0.15U W=0.36U AS=0.0999P
+ AD=0.0711P PS=0.985U PD=0.755U
* device instance $61 r0 *1 0,0 nfet
M$61 \$0$57 \$0$6 \$0$34 GND\x7cVGND\x7cVSS nfet L=0.15U W=0.36U AS=0.0999P
+ AD=0.0711P PS=0.985U PD=0.755U
* device instance $62 r0 *1 0,0 nfet
M$62 \$0$58 \$0$7 \$0$36 GND\x7cVGND\x7cVSS nfet L=0.15U W=0.36U AS=0.0999P
+ AD=0.0711P PS=0.985U PD=0.755U
* device instance $63 r0 *1 0,0 nfet
M$63 GND\x7cVGND\x7cVSS \$0$59 D\x7cX_4 GND\x7cVGND\x7cVSS nfet L=0.15U W=0.65U
+ AS=0.169P AD=0.11285P PS=1.82U PD=1.045U
* device instance $64 r0 *1 0,0 nfet
M$64 \$0$44 A1\x7cCOMP_OUT\x7cOUTP \$0$49 GND\x7cVGND\x7cVSS nfet L=0.15U
+ W=0.42U AS=0.0693P AD=0.09975P PS=0.75U PD=0.895U
* device instance $65 r0 *1 0,0 nfet
M$65 \$0$45 A1\x7cCOMP_OUT\x7cOUTP \$0$50 GND\x7cVGND\x7cVSS nfet L=0.15U
+ W=0.42U AS=0.0693P AD=0.09975P PS=0.75U PD=0.895U
* device instance $66 r0 *1 0,0 nfet
M$66 \$0$52 RESET_B\x7cRST_B GND\x7cVGND\x7cVSS GND\x7cVGND\x7cVSS nfet L=0.15U
+ W=0.42U AS=0.1346P AD=0.0441P PS=1.15U PD=0.63U
* device instance $67 r0 *1 0,0 nfet
M$67 \$0$54 RESET_B\x7cRST_B GND\x7cVGND\x7cVSS GND\x7cVGND\x7cVSS nfet L=0.15U
+ W=0.42U AS=0.1346P AD=0.0441P PS=1.15U PD=0.63U
* device instance $68 r0 *1 0,0 nfet
M$68 \$0$60 A\x7cA0\x7cB\x7cDOUT4\x7cQ \$0$41 GND\x7cVGND\x7cVSS nfet L=0.15U
+ W=0.42U AS=0.09975P AD=0.0693P PS=0.895U PD=0.75U
* device instance $69 r0 *1 0,0 nfet
M$69 \$0$47 \$0$29 GND\x7cVGND\x7cVSS GND\x7cVGND\x7cVSS nfet L=0.15U W=0.64U
+ AS=0.1346P AD=0.0999P PS=1.15U PD=0.985U
* device instance $70 r0 *1 0,0 nfet
M$70 \$0$61 \$0 \$0$55 GND\x7cVGND\x7cVSS nfet L=0.15U W=0.36U AS=0.0711P
+ AD=0.0669P PS=0.755U PD=0.75U
* device instance $71 r0 *1 0,0 nfet
M$71 \$0$62 \$0$1 \$0$56 GND\x7cVGND\x7cVSS nfet L=0.15U W=0.36U AS=0.0711P
+ AD=0.0669P PS=0.755U PD=0.75U
* device instance $72 r0 *1 0,0 nfet
M$72 \$0$63 \$0$2 \$0$57 GND\x7cVGND\x7cVSS nfet L=0.15U W=0.36U AS=0.0711P
+ AD=0.0669P PS=0.755U PD=0.75U
* device instance $73 r0 *1 0,0 nfet
M$73 \$0$64 \$0$3 \$0$58 GND\x7cVGND\x7cVSS nfet L=0.15U W=0.36U AS=0.0711P
+ AD=0.0669P PS=0.755U PD=0.75U
* device instance $74 r0 *1 0,0 nfet
M$74 \$0$65 D\x7cPH_B2\x7cQ\x7cS GND\x7cVGND\x7cVSS GND\x7cVGND\x7cVSS nfet
+ L=0.15U W=0.42U AS=0.11285P AD=0.0693P PS=1.045U PD=0.75U
* device instance $75 r0 *1 0,0 nfet
M$75 \$0$66 A\x7cA0\x7cB\x7cDOUT5\x7cQ \$0$44 GND\x7cVGND\x7cVSS nfet L=0.15U
+ W=0.42U AS=0.09975P AD=0.0693P PS=0.895U PD=0.75U
* device instance $76 r0 *1 0,0 nfet
M$76 \$0$67 A\x7cA0\x7cB\x7cDOUT3\x7cQ \$0$45 GND\x7cVGND\x7cVSS nfet L=0.15U
+ W=0.42U AS=0.09975P AD=0.0693P PS=0.895U PD=0.75U
* device instance $77 r0 *1 0,0 nfet
M$77 GND\x7cVGND\x7cVSS \$0$68 \$0$60 GND\x7cVGND\x7cVSS nfet L=0.15U W=0.42U
+ AS=0.0693P AD=0.1449P PS=0.75U PD=1.11U
* device instance $78 r0 *1 0,0 nfet
M$78 \$0$51 \$0$38 GND\x7cVGND\x7cVSS GND\x7cVGND\x7cVSS nfet L=0.15U W=0.64U
+ AS=0.1346P AD=0.0999P PS=1.15U PD=0.985U
* device instance $79 r0 *1 0,0 nfet
M$79 \$0$53 \$0$39 GND\x7cVGND\x7cVSS GND\x7cVGND\x7cVSS nfet L=0.15U W=0.64U
+ AS=0.1346P AD=0.0999P PS=1.15U PD=0.985U
* device instance $80 r0 *1 0,0 nfet
M$80 \$0$69 \$0$9 \$0$47 GND\x7cVGND\x7cVSS nfet L=0.15U W=0.36U AS=0.0999P
+ AD=0.0711P PS=0.985U PD=0.755U
* device instance $81 r0 *1 0,0 nfet
M$81 GND\x7cVGND\x7cVSS \$0$70 \$0$61 GND\x7cVGND\x7cVSS nfet L=0.15U W=0.42U
+ AS=0.0669P AD=0.12495P PS=0.75U PD=1.015U
* device instance $82 r0 *1 0,0 nfet
M$82 GND\x7cVGND\x7cVSS \$0$71 \$0$62 GND\x7cVGND\x7cVSS nfet L=0.15U W=0.42U
+ AS=0.0669P AD=0.12495P PS=0.75U PD=1.015U
* device instance $83 r0 *1 0,0 nfet
M$83 GND\x7cVGND\x7cVSS \$0$72 \$0$63 GND\x7cVGND\x7cVSS nfet L=0.15U W=0.42U
+ AS=0.0669P AD=0.12495P PS=0.75U PD=1.015U
* device instance $84 r0 *1 0,0 nfet
M$84 GND\x7cVGND\x7cVSS \$0$73 \$0$64 GND\x7cVGND\x7cVSS nfet L=0.15U W=0.42U
+ AS=0.0669P AD=0.12495P PS=0.75U PD=1.015U
* device instance $85 r0 *1 0,0 nfet
M$85 \$0$59 A1\x7cCOMP_OUT\x7cOUTP \$0$65 GND\x7cVGND\x7cVSS nfet L=0.15U
+ W=0.42U AS=0.0693P AD=0.09975P PS=0.75U PD=0.895U
* device instance $86 r0 *1 0,0 nfet
M$86 GND\x7cVGND\x7cVSS \$0$74 \$0$66 GND\x7cVGND\x7cVSS nfet L=0.15U W=0.42U
+ AS=0.0693P AD=0.1449P PS=0.75U PD=1.11U
* device instance $87 r0 *1 0,0 nfet
M$87 GND\x7cVGND\x7cVSS \$0$75 \$0$67 GND\x7cVGND\x7cVSS nfet L=0.15U W=0.42U
+ AS=0.0693P AD=0.1449P PS=0.75U PD=1.11U
* device instance $88 r0 *1 0,0 nfet
M$88 \$0$76 \$0$16 \$0$51 GND\x7cVGND\x7cVSS nfet L=0.15U W=0.36U AS=0.0999P
+ AD=0.0711P PS=0.985U PD=0.755U
* device instance $89 r0 *1 0,0 nfet
M$89 \$0$77 \$0$17 \$0$53 GND\x7cVGND\x7cVSS nfet L=0.15U W=0.36U AS=0.0999P
+ AD=0.0711P PS=0.985U PD=0.755U
* device instance $90 r0 *1 0,0 nfet
M$90 \$0$69 \$0$8 \$0$78 GND\x7cVGND\x7cVSS nfet L=0.15U W=0.36U AS=0.0669P
+ AD=0.0711P PS=0.75U PD=0.755U
* device instance $91 r0 *1 0,0 nfet
M$91 \$0$68 B\x7cD\x7cPH_B4\x7cQ\x7cS GND\x7cVGND\x7cVSS GND\x7cVGND\x7cVSS
+ nfet L=0.15U W=0.42U AS=0.1449P AD=0.1092P PS=1.11U PD=1.36U
* device instance $92 r0 *1 0,0 nfet
M$92 \$0$79 A\x7cA0\x7cB\x7cDOUT2\x7cQ \$0$59 GND\x7cVGND\x7cVSS nfet L=0.15U
+ W=0.42U AS=0.09975P AD=0.0693P PS=0.895U PD=0.75U
* device instance $93 r0 *1 0,0 nfet
M$93 \$0$80 RESET_B\x7cRST_B GND\x7cVGND\x7cVSS GND\x7cVGND\x7cVSS nfet L=0.15U
+ W=0.42U AS=0.12495P AD=0.06405P PS=1.015U PD=0.725U
* device instance $94 r0 *1 0,0 nfet
M$94 \$0$81 RESET_B\x7cRST_B GND\x7cVGND\x7cVSS GND\x7cVGND\x7cVSS nfet L=0.15U
+ W=0.42U AS=0.12495P AD=0.06405P PS=1.015U PD=0.725U
* device instance $95 r0 *1 0,0 nfet
M$95 \$0$82 RESET_B\x7cRST_B GND\x7cVGND\x7cVSS GND\x7cVGND\x7cVSS nfet L=0.15U
+ W=0.42U AS=0.12495P AD=0.06405P PS=1.015U PD=0.725U
* device instance $96 r0 *1 0,0 nfet
M$96 \$0$83 RESET_B\x7cRST_B GND\x7cVGND\x7cVSS GND\x7cVGND\x7cVSS nfet L=0.15U
+ W=0.42U AS=0.12495P AD=0.06405P PS=1.015U PD=0.725U
* device instance $97 r0 *1 0,0 nfet
M$97 GND\x7cVGND\x7cVSS A\x7cCLK\x7cX \$0$84 GND\x7cVGND\x7cVSS nfet L=0.15U
+ W=0.42U AS=0.1092P AD=0.0567P PS=1.36U PD=0.69U
* device instance $98 r0 *1 0,0 nfet
M$98 \$0$76 \$0$10 \$0$85 GND\x7cVGND\x7cVSS nfet L=0.15U W=0.36U AS=0.0669P
+ AD=0.0711P PS=0.75U PD=0.755U
* device instance $99 r0 *1 0,0 nfet
M$99 \$0$77 \$0$11 \$0$86 GND\x7cVGND\x7cVSS nfet L=0.15U W=0.36U AS=0.0669P
+ AD=0.0711P PS=0.75U PD=0.755U
* device instance $100 r0 *1 0,0 nfet
M$100 GND\x7cVGND\x7cVSS \$0$87 \$0$78 GND\x7cVGND\x7cVSS nfet L=0.15U W=0.42U
+ AS=0.0669P AD=0.12495P PS=0.75U PD=1.015U
* device instance $101 r0 *1 0,0 nfet
M$101 \$0$74 A\x7cD\x7cPH_B5\x7cQ\x7cS GND\x7cVGND\x7cVSS GND\x7cVGND\x7cVSS
+ nfet L=0.15U W=0.42U AS=0.1449P AD=0.1092P PS=1.11U PD=1.36U
* device instance $102 r0 *1 0,0 nfet
M$102 \$0$75 C\x7cD\x7cPH_B3\x7cQ\x7cS GND\x7cVGND\x7cVSS GND\x7cVGND\x7cVSS
+ nfet L=0.15U W=0.42U AS=0.1449P AD=0.1092P PS=1.11U PD=1.36U
* device instance $103 r0 *1 0,0 nfet
M$103 GND\x7cVGND\x7cVSS \$0$88 \$0$79 GND\x7cVGND\x7cVSS nfet L=0.15U W=0.42U
+ AS=0.0693P AD=0.1449P PS=0.75U PD=1.11U
* device instance $104 r0 *1 0,0 nfet
M$104 \$0$70 \$0$55 \$0$80 GND\x7cVGND\x7cVSS nfet L=0.15U W=0.42U AS=0.06405P
+ AD=0.1092P PS=0.725U PD=1.36U
* device instance $105 r0 *1 0,0 nfet
M$105 \$0$71 \$0$56 \$0$81 GND\x7cVGND\x7cVSS nfet L=0.15U W=0.42U AS=0.06405P
+ AD=0.1092P PS=0.725U PD=1.36U
* device instance $106 r0 *1 0,0 nfet
M$106 \$0$72 \$0$57 \$0$82 GND\x7cVGND\x7cVSS nfet L=0.15U W=0.42U AS=0.06405P
+ AD=0.1092P PS=0.725U PD=1.36U
* device instance $107 r0 *1 0,0 nfet
M$107 \$0$73 \$0$58 \$0$83 GND\x7cVGND\x7cVSS nfet L=0.15U W=0.42U AS=0.06405P
+ AD=0.1092P PS=0.725U PD=1.36U
* device instance $108 r0 *1 0,0 nfet
M$108 \$0$89 \$0$84 GND\x7cVGND\x7cVSS GND\x7cVGND\x7cVSS nfet L=0.15U W=0.42U
+ AS=0.0567P AD=0.1092P PS=0.69U PD=1.36U
* device instance $109 r0 *1 0,0 nfet
M$109 GND\x7cVGND\x7cVSS \$0$90 \$0$85 GND\x7cVGND\x7cVSS nfet L=0.15U W=0.42U
+ AS=0.0669P AD=0.12495P PS=0.75U PD=1.015U
* device instance $110 r0 *1 0,0 nfet
M$110 GND\x7cVGND\x7cVSS \$0$91 \$0$86 GND\x7cVGND\x7cVSS nfet L=0.15U W=0.42U
+ AS=0.0669P AD=0.12495P PS=0.75U PD=1.015U
* device instance $111 r0 *1 0,0 nfet
M$111 \$0$92 RESET_B\x7cRST_B GND\x7cVGND\x7cVSS GND\x7cVGND\x7cVSS nfet
+ L=0.15U W=0.42U AS=0.12495P AD=0.06405P PS=1.015U PD=0.725U
* device instance $112 r0 *1 0,0 nfet
M$112 GND\x7cVGND\x7cVSS CLK\x7cX \$0$93 GND\x7cVGND\x7cVSS nfet L=0.15U
+ W=0.42U AS=0.1092P AD=0.0567P PS=1.36U PD=0.69U
* device instance $113 r0 *1 0,0 nfet
M$113 \$0$88 D\x7cPH_B2\x7cQ\x7cS GND\x7cVGND\x7cVSS GND\x7cVGND\x7cVSS nfet
+ L=0.15U W=0.42U AS=0.1449P AD=0.1092P PS=1.11U PD=1.36U
* device instance $114 r0 *1 0,0 nfet
M$114 \$0$87 \$0$69 \$0$92 GND\x7cVGND\x7cVSS nfet L=0.15U W=0.42U AS=0.06405P
+ AD=0.1092P PS=0.725U PD=1.36U
* device instance $115 r0 *1 0,0 nfet
M$115 \$0$94 RESET_B\x7cRST_B GND\x7cVGND\x7cVSS GND\x7cVGND\x7cVSS nfet
+ L=0.15U W=0.42U AS=0.12495P AD=0.06405P PS=1.015U PD=0.725U
* device instance $116 r0 *1 0,0 nfet
M$116 \$0$95 RESET_B\x7cRST_B GND\x7cVGND\x7cVSS GND\x7cVGND\x7cVSS nfet
+ L=0.15U W=0.42U AS=0.12495P AD=0.06405P PS=1.015U PD=0.725U
* device instance $117 r0 *1 0,0 nfet
M$117 \$0$96 \$0$93 GND\x7cVGND\x7cVSS GND\x7cVGND\x7cVSS nfet L=0.15U W=0.42U
+ AS=0.0567P AD=0.1092P PS=0.69U PD=1.36U
* device instance $118 r0 *1 0,0 nfet
M$118 A\x7cA0\x7cB\x7cDOUT5\x7cQ \$0$70 GND\x7cVGND\x7cVSS GND\x7cVGND\x7cVSS
+ nfet L=0.15U W=0.65U AS=0.2087P AD=0.169P PS=2.02U PD=1.82U
* device instance $119 r0 *1 0,0 nfet
M$119 C\x7cD\x7cPH_B3\x7cQ\x7cS \$0$71 GND\x7cVGND\x7cVSS GND\x7cVGND\x7cVSS
+ nfet L=0.15U W=0.65U AS=0.2087P AD=0.169P PS=2.02U PD=1.82U
* device instance $120 r0 *1 0,0 nfet
M$120 A\x7cA0\x7cB\x7cDOUT3\x7cQ \$0$72 GND\x7cVGND\x7cVSS GND\x7cVGND\x7cVSS
+ nfet L=0.15U W=0.65U AS=0.2087P AD=0.169P PS=2.02U PD=1.82U
* device instance $121 r0 *1 0,0 nfet
M$121 D\x7cPH_B2\x7cQ\x7cS \$0$73 GND\x7cVGND\x7cVSS GND\x7cVGND\x7cVSS nfet
+ L=0.15U W=0.65U AS=0.2087P AD=0.169P PS=2.02U PD=1.82U
* device instance $122 r0 *1 0,0 nfet
M$122 \$0$97 D\x7cX_5 GND\x7cVGND\x7cVSS GND\x7cVGND\x7cVSS nfet L=0.15U
+ W=0.42U AS=0.2205P AD=0.066P PS=1.89U PD=0.745U
* device instance $123 r0 *1 0,0 nfet
M$123 \$0$90 \$0$76 \$0$94 GND\x7cVGND\x7cVSS nfet L=0.15U W=0.42U AS=0.06405P
+ AD=0.1092P PS=0.725U PD=1.36U
* device instance $124 r0 *1 0,0 nfet
M$124 \$0$91 \$0$77 \$0$95 GND\x7cVGND\x7cVSS nfet L=0.15U W=0.42U AS=0.06405P
+ AD=0.1092P PS=0.725U PD=1.36U
* device instance $125 r0 *1 0,0 nfet
M$125 \$0$98 \$0$84 \$0$97 GND\x7cVGND\x7cVSS nfet L=0.15U W=0.36U AS=0.066P
+ AD=0.0594P PS=0.745U PD=0.69U
* device instance $126 r0 *1 0,0 nfet
M$126 A\x7cA0\x7cB\x7cDOUT4\x7cQ \$0$87 GND\x7cVGND\x7cVSS GND\x7cVGND\x7cVSS
+ nfet L=0.15U W=0.65U AS=0.2087P AD=0.169P PS=2.02U PD=1.82U
* device instance $127 r0 *1 0,0 nfet
M$127 \$0$99 D\x7cPH_B2\x7cQ\x7cS GND\x7cVGND\x7cVSS GND\x7cVGND\x7cVSS nfet
+ L=0.15U W=0.42U AS=0.2205P AD=0.066P PS=1.89U PD=0.745U
* device instance $128 r0 *1 0,0 nfet
M$128 \$0$98 \$0$89 \$0$100 GND\x7cVGND\x7cVSS nfet L=0.15U W=0.36U AS=0.1401P
+ AD=0.0594P PS=1.1U PD=0.69U
* device instance $129 r0 *1 0,0 nfet
M$129 A\x7cA0\x7cB\x7cDOUT2\x7cQ \$0$90 GND\x7cVGND\x7cVSS GND\x7cVGND\x7cVSS
+ nfet L=0.15U W=0.65U AS=0.2087P AD=0.169P PS=2.02U PD=1.82U
* device instance $130 r0 *1 0,0 nfet
M$130 B\x7cD\x7cPH_B4\x7cQ\x7cS \$0$91 GND\x7cVGND\x7cVSS GND\x7cVGND\x7cVSS
+ nfet L=0.15U W=0.65U AS=0.2087P AD=0.169P PS=2.02U PD=1.82U
* device instance $131 r0 *1 0,0 nfet
M$131 \$0$101 \$0$93 \$0$99 GND\x7cVGND\x7cVSS nfet L=0.15U W=0.36U AS=0.066P
+ AD=0.0594P PS=0.745U PD=0.69U
* device instance $132 r0 *1 0,0 nfet
M$132 GND\x7cVGND\x7cVSS A\x7cX \$0$102 GND\x7cVGND\x7cVSS nfet L=0.15U W=0.65U
+ AS=0.169P AD=0.08775P PS=1.82U PD=0.92U
* device instance $133 r0 *1 0,0 nfet
M$133 \$0$104 \$0$103 \$0$100 GND\x7cVGND\x7cVSS nfet L=0.15U W=0.42U
+ AS=0.1401P AD=0.0441P PS=1.1U PD=0.63U
* device instance $134 r0 *1 0,0 nfet
M$134 \$0$101 \$0$96 \$0$105 GND\x7cVGND\x7cVSS nfet L=0.15U W=0.36U AS=0.1401P
+ AD=0.0594P PS=1.1U PD=0.69U
* device instance $135 r0 *1 0,0 nfet
M$135 CLK\x7cX \$0$102 GND\x7cVGND\x7cVSS GND\x7cVGND\x7cVSS nfet L=0.15U
+ W=0.65U AS=0.08775P AD=0.08775P PS=0.92U PD=0.92U
* device instance $136 r0 *1 0,0 nfet
M$136 GND\x7cVGND\x7cVSS \$0$106 D\x7cX_5 GND\x7cVGND\x7cVSS nfet L=0.15U
+ W=0.65U AS=0.169P AD=0.11285P PS=1.82U PD=1.045U
* device instance $137 r0 *1 0,0 nfet
M$137 \$0$104 RESET_B\x7cRST_B GND\x7cVGND\x7cVSS GND\x7cVGND\x7cVSS nfet
+ L=0.15U W=0.42U AS=0.1346P AD=0.0441P PS=1.15U PD=0.63U
* device instance $138 r0 *1 0,0 nfet
M$138 GND\x7cVGND\x7cVSS \$0$102 CLK\x7cX GND\x7cVGND\x7cVSS nfet L=0.15U
+ W=0.65U AS=0.08775P AD=0.08775P PS=0.92U PD=0.92U
* device instance $139 r0 *1 0,0 nfet
M$139 \$0$107 D\x7cPH_B6\x7cQ\x7cS GND\x7cVGND\x7cVSS GND\x7cVGND\x7cVSS nfet
+ L=0.15U W=0.42U AS=0.11285P AD=0.0693P PS=1.045U PD=0.75U
* device instance $140 r0 *1 0,0 nfet
M$140 \$0$109 \$0$108 \$0$105 GND\x7cVGND\x7cVSS nfet L=0.15U W=0.42U
+ AS=0.1401P AD=0.0441P PS=1.1U PD=0.63U
* device instance $141 r0 *1 0,0 nfet
M$141 CLK\x7cX \$0$102 GND\x7cVGND\x7cVSS GND\x7cVGND\x7cVSS nfet L=0.15U
+ W=0.65U AS=0.08775P AD=0.08775P PS=0.92U PD=0.92U
* device instance $142 r0 *1 0,0 nfet
M$142 \$0$103 \$0$98 GND\x7cVGND\x7cVSS GND\x7cVGND\x7cVSS nfet L=0.15U W=0.64U
+ AS=0.1346P AD=0.0999P PS=1.15U PD=0.985U
* device instance $143 r0 *1 0,0 nfet
M$143 \$0$106 A1\x7cCOMP_OUT\x7cOUTP \$0$107 GND\x7cVGND\x7cVSS nfet L=0.15U
+ W=0.42U AS=0.0693P AD=0.09975P PS=0.75U PD=0.895U
* device instance $144 r0 *1 0,0 nfet
M$144 \$0$109 RESET_B\x7cRST_B GND\x7cVGND\x7cVSS GND\x7cVGND\x7cVSS nfet
+ L=0.15U W=0.42U AS=0.1346P AD=0.0441P PS=1.15U PD=0.63U
* device instance $145 r0 *1 0,0 nfet
M$145 GND\x7cVGND\x7cVSS \$0$102 CLK\x7cX GND\x7cVGND\x7cVSS nfet L=0.15U
+ W=0.65U AS=0.08775P AD=0.169P PS=0.92U PD=1.82U
* device instance $146 r0 *1 0,0 nfet
M$146 \$0$110 \$0$89 \$0$103 GND\x7cVGND\x7cVSS nfet L=0.15U W=0.36U AS=0.0999P
+ AD=0.0711P PS=0.985U PD=0.755U
* device instance $147 r0 *1 0,0 nfet
M$147 GND\x7cVGND\x7cVSS A\x7cCLK\x7cX \$0$111 GND\x7cVGND\x7cVSS nfet L=0.15U
+ W=0.42U AS=0.1092P AD=0.0567P PS=1.36U PD=0.69U
* device instance $148 r0 *1 0,0 nfet
M$148 GND\x7cVGND\x7cVSS A\x7cCLK \$0$112 GND\x7cVGND\x7cVSS nfet L=0.15U
+ W=0.65U AS=0.169P AD=0.08775P PS=1.82U PD=0.92U
* device instance $149 r0 *1 0,0 nfet
M$149 \$0$113 A\x7cA0\x7cB\x7cDOUT6\x7cQ \$0$106 GND\x7cVGND\x7cVSS nfet
+ L=0.15U W=0.42U AS=0.09975P AD=0.0693P PS=0.895U PD=0.75U
* device instance $150 r0 *1 0,0 nfet
M$150 \$0$108 \$0$101 GND\x7cVGND\x7cVSS GND\x7cVGND\x7cVSS nfet L=0.15U
+ W=0.64U AS=0.1346P AD=0.0999P PS=1.15U PD=0.985U
* device instance $151 r0 *1 0,0 nfet
M$151 \$0$114 \$0$111 GND\x7cVGND\x7cVSS GND\x7cVGND\x7cVSS nfet L=0.15U
+ W=0.42U AS=0.0567P AD=0.1092P PS=0.69U PD=1.36U
* device instance $152 r0 *1 0,0 nfet
M$152 A\x7cX \$0$112 GND\x7cVGND\x7cVSS GND\x7cVGND\x7cVSS nfet L=0.15U W=0.65U
+ AS=0.08775P AD=0.08775P PS=0.92U PD=0.92U
* device instance $153 r0 *1 0,0 nfet
M$153 \$0$110 \$0$84 \$0$115 GND\x7cVGND\x7cVSS nfet L=0.15U W=0.36U AS=0.0669P
+ AD=0.0711P PS=0.75U PD=0.755U
* device instance $154 r0 *1 0,0 nfet
M$154 GND\x7cVGND\x7cVSS \$0$116 \$0$113 GND\x7cVGND\x7cVSS nfet L=0.15U
+ W=0.42U AS=0.0693P AD=0.1449P PS=0.75U PD=1.11U
* device instance $155 r0 *1 0,0 nfet
M$155 GND\x7cVGND\x7cVSS \$0$112 A\x7cX GND\x7cVGND\x7cVSS nfet L=0.15U W=0.65U
+ AS=0.08775P AD=0.08775P PS=0.92U PD=0.92U
* device instance $156 r0 *1 0,0 nfet
M$156 \$0$117 \$0$96 \$0$108 GND\x7cVGND\x7cVSS nfet L=0.15U W=0.36U AS=0.0999P
+ AD=0.0711P PS=0.985U PD=0.755U
* device instance $157 r0 *1 0,0 nfet
M$157 GND\x7cVGND\x7cVSS \$0$118 \$0$115 GND\x7cVGND\x7cVSS nfet L=0.15U
+ W=0.42U AS=0.0669P AD=0.12495P PS=0.75U PD=1.015U
* device instance $158 r0 *1 0,0 nfet
M$158 A\x7cX \$0$112 GND\x7cVGND\x7cVSS GND\x7cVGND\x7cVSS nfet L=0.15U W=0.65U
+ AS=0.08775P AD=0.08775P PS=0.92U PD=0.92U
* device instance $159 r0 *1 0,0 nfet
M$159 \$0$117 \$0$93 \$0$119 GND\x7cVGND\x7cVSS nfet L=0.15U W=0.36U AS=0.0669P
+ AD=0.0711P PS=0.75U PD=0.755U
* device instance $160 r0 *1 0,0 nfet
M$160 \$0$116 D\x7cPH_B6\x7cQ\x7cS GND\x7cVGND\x7cVSS GND\x7cVGND\x7cVSS nfet
+ L=0.15U W=0.42U AS=0.1449P AD=0.1092P PS=1.11U PD=1.36U
* device instance $161 r0 *1 0,0 nfet
M$161 GND\x7cVGND\x7cVSS \$0$112 A\x7cX GND\x7cVGND\x7cVSS nfet L=0.15U W=0.65U
+ AS=0.08775P AD=0.169P PS=0.92U PD=1.82U
* device instance $162 r0 *1 0,0 nfet
M$162 \$0$120 D\x7cPH_B6\x7cQ\x7cS GND\x7cVGND\x7cVSS GND\x7cVGND\x7cVSS nfet
+ L=0.15U W=0.42U AS=0.2205P AD=0.066P PS=1.89U PD=0.745U
* device instance $163 r0 *1 0,0 nfet
M$163 \$0$121 RESET_B\x7cRST_B GND\x7cVGND\x7cVSS GND\x7cVGND\x7cVSS nfet
+ L=0.15U W=0.42U AS=0.12495P AD=0.06405P PS=1.015U PD=0.725U
* device instance $164 r0 *1 0,0 nfet
M$164 GND\x7cVGND\x7cVSS CLK\x7cX \$0$122 GND\x7cVGND\x7cVSS nfet L=0.15U
+ W=0.42U AS=0.1092P AD=0.0567P PS=1.36U PD=0.69U
* device instance $165 r0 *1 0,0 nfet
M$165 GND\x7cVGND\x7cVSS \$0$123 \$0$119 GND\x7cVGND\x7cVSS nfet L=0.15U
+ W=0.42U AS=0.0669P AD=0.12495P PS=0.75U PD=1.015U
* device instance $166 r0 *1 0,0 nfet
M$166 \$0$118 \$0$110 \$0$121 GND\x7cVGND\x7cVSS nfet L=0.15U W=0.42U
+ AS=0.06405P AD=0.1092P PS=0.725U PD=1.36U
* device instance $167 r0 *1 0,0 nfet
M$167 \$0$124 \$0$111 \$0$120 GND\x7cVGND\x7cVSS nfet L=0.15U W=0.36U AS=0.066P
+ AD=0.0594P PS=0.745U PD=0.69U
* device instance $168 r0 *1 0,0 nfet
M$168 \$0$125 \$0$122 GND\x7cVGND\x7cVSS GND\x7cVGND\x7cVSS nfet L=0.15U
+ W=0.42U AS=0.0567P AD=0.1092P PS=0.69U PD=1.36U
* device instance $169 r0 *1 0,0 nfet
M$169 \$0$126 RESET_B\x7cRST_B GND\x7cVGND\x7cVSS GND\x7cVGND\x7cVSS nfet
+ L=0.15U W=0.42U AS=0.12495P AD=0.06405P PS=1.015U PD=0.725U
* device instance $170 r0 *1 0,0 nfet
M$170 \$0$127 \$0$114 \$0$124 GND\x7cVGND\x7cVSS nfet L=0.15U W=0.36U
+ AS=0.0594P AD=0.1401P PS=0.69U PD=1.1U
* device instance $171 r0 *1 0,0 nfet
M$171 \$0$123 \$0$117 \$0$126 GND\x7cVGND\x7cVSS nfet L=0.15U W=0.42U
+ AS=0.06405P AD=0.1092P PS=0.725U PD=1.36U
* device instance $172 r0 *1 0,0 nfet
M$172 A\x7cA0\x7cB\x7cDOUT6\x7cQ \$0$118 GND\x7cVGND\x7cVSS GND\x7cVGND\x7cVSS
+ nfet L=0.15U W=0.65U AS=0.2087P AD=0.169P PS=2.02U PD=1.82U
* device instance $173 r0 *1 0,0 nfet
M$173 \$0$129 \$0$128 \$0$127 GND\x7cVGND\x7cVSS nfet L=0.15U W=0.42U
+ AS=0.1401P AD=0.0441P PS=1.1U PD=0.63U
* device instance $174 r0 *1 0,0 nfet
M$174 \$0$130 A\x7cD\x7cPH_B1\x7cQ\x7cS GND\x7cVGND\x7cVSS GND\x7cVGND\x7cVSS
+ nfet L=0.15U W=0.42U AS=0.2205P AD=0.066P PS=1.89U PD=0.745U
* device instance $175 r0 *1 0,0 nfet
M$175 GND\x7cVGND\x7cVSS RESET_B\x7cRST_B \$0$129 GND\x7cVGND\x7cVSS nfet
+ L=0.15U W=0.42U AS=0.0441P AD=0.1346P PS=0.63U PD=1.15U
* device instance $176 r0 *1 0,0 nfet
M$176 \$0$131 \$0$122 \$0$130 GND\x7cVGND\x7cVSS nfet L=0.15U W=0.36U AS=0.066P
+ AD=0.0594P PS=0.745U PD=0.69U
* device instance $177 r0 *1 0,0 nfet
M$177 A\x7cD\x7cPH_B1\x7cQ\x7cS \$0$123 GND\x7cVGND\x7cVSS GND\x7cVGND\x7cVSS
+ nfet L=0.15U W=0.65U AS=0.2087P AD=0.169P PS=2.02U PD=1.82U
* device instance $178 r0 *1 0,0 nfet
M$178 GND\x7cVGND\x7cVSS A\x7cX \$0$132 GND\x7cVGND\x7cVSS nfet L=0.15U W=0.65U
+ AS=0.169P AD=0.08775P PS=1.82U PD=0.92U
* device instance $179 r0 *1 0,0 nfet
M$179 Y A\x7cCLK\x7cX GND\x7cVGND\x7cVSS GND\x7cVGND\x7cVSS nfet L=0.15U
+ W=0.65U AS=0.169P AD=0.169P PS=1.82U PD=1.82U
* device instance $180 r0 *1 0,0 nfet
M$180 \$0$131 \$0$125 \$0$133 GND\x7cVGND\x7cVSS nfet L=0.15U W=0.36U
+ AS=0.1401P AD=0.0594P PS=1.1U PD=0.69U
* device instance $181 r0 *1 0,0 nfet
M$181 \$0$128 \$0$124 GND\x7cVGND\x7cVSS GND\x7cVGND\x7cVSS nfet L=0.15U
+ W=0.64U AS=0.1346P AD=0.0999P PS=1.15U PD=0.985U
* device instance $182 r0 *1 0,0 nfet
M$182 A\x7cCLK\x7cX \$0$132 GND\x7cVGND\x7cVSS GND\x7cVGND\x7cVSS nfet L=0.15U
+ W=0.65U AS=0.08775P AD=0.08775P PS=0.92U PD=0.92U
* device instance $183 r0 *1 0,0 nfet
M$183 GND\x7cVGND\x7cVSS \$0$132 A\x7cCLK\x7cX GND\x7cVGND\x7cVSS nfet L=0.15U
+ W=0.65U AS=0.08775P AD=0.08775P PS=0.92U PD=0.92U
* device instance $184 r0 *1 0,0 nfet
M$184 \$0$134 \$0$114 \$0$128 GND\x7cVGND\x7cVSS nfet L=0.15U W=0.36U
+ AS=0.0999P AD=0.0711P PS=0.985U PD=0.755U
* device instance $185 r0 *1 0,0 nfet
M$185 \$0$136 \$0$135 \$0$133 GND\x7cVGND\x7cVSS nfet L=0.15U W=0.42U
+ AS=0.1401P AD=0.0441P PS=1.1U PD=0.63U
* device instance $186 r0 *1 0,0 nfet
M$186 A\x7cCLK\x7cX \$0$132 GND\x7cVGND\x7cVSS GND\x7cVGND\x7cVSS nfet L=0.15U
+ W=0.65U AS=0.08775P AD=0.08775P PS=0.92U PD=0.92U
* device instance $187 r0 *1 0,0 nfet
M$187 \$0$137 \$0$111 \$0$134 GND\x7cVGND\x7cVSS nfet L=0.15U W=0.36U
+ AS=0.0711P AD=0.0669P PS=0.755U PD=0.75U
* device instance $188 r0 *1 0,0 nfet
M$188 \$0$136 RESET_B\x7cRST_B GND\x7cVGND\x7cVSS GND\x7cVGND\x7cVSS nfet
+ L=0.15U W=0.42U AS=0.1346P AD=0.0441P PS=1.15U PD=0.63U
* device instance $189 r0 *1 0,0 nfet
M$189 GND\x7cVGND\x7cVSS \$0$132 A\x7cCLK\x7cX GND\x7cVGND\x7cVSS nfet L=0.15U
+ W=0.65U AS=0.08775P AD=0.169P PS=0.92U PD=1.82U
* device instance $190 r0 *1 0,0 nfet
M$190 GND\x7cVGND\x7cVSS \$0$138 \$0$137 GND\x7cVGND\x7cVSS nfet L=0.15U
+ W=0.42U AS=0.0669P AD=0.12495P PS=0.75U PD=1.015U
* device instance $191 r0 *1 0,0 nfet
M$191 \$0$135 \$0$131 GND\x7cVGND\x7cVSS GND\x7cVGND\x7cVSS nfet L=0.15U
+ W=0.64U AS=0.1346P AD=0.0999P PS=1.15U PD=0.985U
* device instance $192 r0 *1 0,0 nfet
M$192 \$0$139 RESET_B\x7cRST_B GND\x7cVGND\x7cVSS GND\x7cVGND\x7cVSS nfet
+ L=0.15U W=0.42U AS=0.12495P AD=0.06405P PS=1.015U PD=0.725U
* device instance $193 r0 *1 0,0 nfet
M$193 \$0$140 \$0$125 \$0$135 GND\x7cVGND\x7cVSS nfet L=0.15U W=0.36U
+ AS=0.0999P AD=0.0711P PS=0.985U PD=0.755U
* device instance $194 r0 *1 0,0 nfet
M$194 GND\x7cVGND\x7cVSS \$0$141 D\x7cX_6 GND\x7cVGND\x7cVSS nfet L=0.15U
+ W=0.65U AS=0.169P AD=0.11285P PS=1.82U PD=1.045U
* device instance $195 r0 *1 0,0 nfet
M$195 \$0$138 \$0$134 \$0$139 GND\x7cVGND\x7cVSS nfet L=0.15U W=0.42U
+ AS=0.06405P AD=0.1092P PS=0.725U PD=1.36U
* device instance $196 r0 *1 0,0 nfet
M$196 \$0$140 \$0$122 \$0$142 GND\x7cVGND\x7cVSS nfet L=0.15U W=0.36U
+ AS=0.0669P AD=0.0711P PS=0.75U PD=0.755U
* device instance $197 r0 *1 0,0 nfet
M$197 \$0$143 A\x7cD\x7cPH_B1\x7cQ\x7cS GND\x7cVGND\x7cVSS GND\x7cVGND\x7cVSS
+ nfet L=0.15U W=0.42U AS=0.11285P AD=0.0693P PS=1.045U PD=0.75U
* device instance $198 r0 *1 0,0 nfet
M$198 GND\x7cVGND\x7cVSS \$0$144 \$0$142 GND\x7cVGND\x7cVSS nfet L=0.15U
+ W=0.42U AS=0.0669P AD=0.12495P PS=0.75U PD=1.015U
* device instance $199 r0 *1 0,0 nfet
M$199 \$0$141 A1\x7cCOMP_OUT\x7cOUTP \$0$143 GND\x7cVGND\x7cVSS nfet L=0.15U
+ W=0.42U AS=0.0693P AD=0.09975P PS=0.75U PD=0.895U
* device instance $200 r0 *1 0,0 nfet
M$200 A\x7cD\x7cPH_B5\x7cQ\x7cS \$0$138 GND\x7cVGND\x7cVSS GND\x7cVGND\x7cVSS
+ nfet L=0.15U W=0.65U AS=0.2087P AD=0.169P PS=2.02U PD=1.82U
* device instance $201 r0 *1 0,0 nfet
M$201 \$0$145 D\x7cPH_B6\x7cQ\x7cS GND\x7cVGND\x7cVSS GND\x7cVGND\x7cVSS nfet
+ L=0.15U W=0.42U AS=0.1092P AD=0.0693P PS=1.36U PD=0.75U
* device instance $202 r0 *1 0,0 nfet
M$202 \$0$146 D\x7cPH_B2\x7cQ\x7cS GND\x7cVGND\x7cVSS GND\x7cVGND\x7cVSS nfet
+ L=0.15U W=0.42U AS=0.1092P AD=0.0693P PS=1.36U PD=0.75U
* device instance $203 r0 *1 0,0 nfet
M$203 \$0$147 A\x7cA0\x7cB\x7cDOUT1\x7cQ \$0$141 GND\x7cVGND\x7cVSS nfet
+ L=0.15U W=0.42U AS=0.09975P AD=0.0693P PS=0.895U PD=0.75U
* device instance $204 r0 *1 0,0 nfet
M$204 \$0$148 RESET_B\x7cRST_B GND\x7cVGND\x7cVSS GND\x7cVGND\x7cVSS nfet
+ L=0.15U W=0.42U AS=0.12495P AD=0.06405P PS=1.015U PD=0.725U
* device instance $205 r0 *1 0,0 nfet
M$205 GND\x7cVGND\x7cVSS A\x7cCLK\x7cX \$0$149 GND\x7cVGND\x7cVSS nfet L=0.15U
+ W=0.42U AS=0.1092P AD=0.0567P PS=1.36U PD=0.69U
* device instance $206 r0 *1 0,0 nfet
M$206 GND\x7cVGND\x7cVSS CLK\x7cX \$0$150 GND\x7cVGND\x7cVSS nfet L=0.15U
+ W=0.42U AS=0.1092P AD=0.0567P PS=1.36U PD=0.69U
* device instance $207 r0 *1 0,0 nfet
M$207 GND\x7cVGND\x7cVSS C\x7cD\x7cPH_B7\x7cQ\x7cS \$0$145 GND\x7cVGND\x7cVSS
+ nfet L=0.15U W=0.42U AS=0.0693P AD=0.0567P PS=0.75U PD=0.69U
* device instance $208 r0 *1 0,0 nfet
M$208 GND\x7cVGND\x7cVSS C\x7cD\x7cPH_B3\x7cQ\x7cS \$0$146 GND\x7cVGND\x7cVSS
+ nfet L=0.15U W=0.42U AS=0.0693P AD=0.0567P PS=0.75U PD=0.69U
* device instance $209 r0 *1 0,0 nfet
M$209 GND\x7cVGND\x7cVSS \$0$151 \$0$147 GND\x7cVGND\x7cVSS nfet L=0.15U
+ W=0.42U AS=0.0693P AD=0.1449P PS=0.75U PD=1.11U
* device instance $210 r0 *1 0,0 nfet
M$210 \$0$144 \$0$140 \$0$148 GND\x7cVGND\x7cVSS nfet L=0.15U W=0.42U
+ AS=0.06405P AD=0.1092P PS=0.725U PD=1.36U
* device instance $211 r0 *1 0,0 nfet
M$211 \$0$152 \$0$149 GND\x7cVGND\x7cVSS GND\x7cVGND\x7cVSS nfet L=0.15U
+ W=0.42U AS=0.0567P AD=0.1092P PS=0.69U PD=1.36U
* device instance $212 r0 *1 0,0 nfet
M$212 \$0$153 \$0$150 GND\x7cVGND\x7cVSS GND\x7cVGND\x7cVSS nfet L=0.15U
+ W=0.42U AS=0.0567P AD=0.1092P PS=0.69U PD=1.36U
* device instance $213 r0 *1 0,0 nfet
M$213 \$0$145 B\x7cD\x7cPH_B8\x7cQ\x7cS GND\x7cVGND\x7cVSS GND\x7cVGND\x7cVSS
+ nfet L=0.15U W=0.42U AS=0.0567P AD=0.0567P PS=0.69U PD=0.69U
* device instance $214 r0 *1 0,0 nfet
M$214 \$0$146 B\x7cD\x7cPH_B4\x7cQ\x7cS GND\x7cVGND\x7cVSS GND\x7cVGND\x7cVSS
+ nfet L=0.15U W=0.42U AS=0.0567P AD=0.0567P PS=0.69U PD=0.69U
* device instance $215 r0 *1 0,0 nfet
M$215 GND\x7cVGND\x7cVSS CLK\x7cX \$0$154 GND\x7cVGND\x7cVSS nfet L=0.15U
+ W=0.42U AS=0.1092P AD=0.0567P PS=1.36U PD=0.69U
* device instance $216 r0 *1 0,0 nfet
M$216 \$0$145 A\x7cA_N\x7cD\x7cPH_B9\x7cQ\x7cS GND\x7cVGND\x7cVSS
+ GND\x7cVGND\x7cVSS nfet L=0.15U W=0.42U AS=0.101875P AD=0.0567P PS=0.99U
+ PD=0.69U
* device instance $217 r0 *1 0,0 nfet
M$217 \$0$146 A\x7cD\x7cPH_B5\x7cQ\x7cS GND\x7cVGND\x7cVSS GND\x7cVGND\x7cVSS
+ nfet L=0.15U W=0.42U AS=0.101875P AD=0.0567P PS=0.99U PD=0.69U
* device instance $218 r0 *1 0,0 nfet
M$218 \$0$155 \$0$154 GND\x7cVGND\x7cVSS GND\x7cVGND\x7cVSS nfet L=0.15U
+ W=0.42U AS=0.0567P AD=0.1092P PS=0.69U PD=1.36U
* device instance $219 r0 *1 0,0 nfet
M$219 GND\x7cVGND\x7cVSS A\x7cCLK\x7cX \$0$156 GND\x7cVGND\x7cVSS nfet L=0.15U
+ W=0.42U AS=0.1092P AD=0.0567P PS=1.36U PD=0.69U
* device instance $220 r0 *1 0,0 nfet
M$220 \$0$151 A\x7cD\x7cPH_B1\x7cQ\x7cS GND\x7cVGND\x7cVSS GND\x7cVGND\x7cVSS
+ nfet L=0.15U W=0.42U AS=0.1449P AD=0.1092P PS=1.11U PD=1.36U
* device instance $221 r0 *1 0,0 nfet
M$221 \$0$157 \$0$156 GND\x7cVGND\x7cVSS GND\x7cVGND\x7cVSS nfet L=0.15U
+ W=0.42U AS=0.0567P AD=0.1092P PS=0.69U PD=1.36U
* device instance $222 r0 *1 0,0 nfet
M$222 A\x7cX_2 \$0$145 GND\x7cVGND\x7cVSS GND\x7cVGND\x7cVSS nfet L=0.15U
+ W=0.65U AS=0.101875P AD=0.1755P PS=0.99U PD=1.84U
* device instance $223 r0 *1 0,0 nfet
M$223 B\x7cX \$0$146 GND\x7cVGND\x7cVSS GND\x7cVGND\x7cVSS nfet L=0.15U W=0.65U
+ AS=0.101875P AD=0.1755P PS=0.99U PD=1.84U
* device instance $224 r0 *1 0,0 nfet
M$224 B\x7cD\x7cPH_B0\x7cQ\x7cS \$0$144 GND\x7cVGND\x7cVSS GND\x7cVGND\x7cVSS
+ nfet L=0.15U W=0.65U AS=0.2087P AD=0.169P PS=2.02U PD=1.82U
* device instance $225 r0 *1 0,0 nfet
M$225 GND\x7cVGND\x7cVSS A\x7cCLK\x7cX \$0$158 GND\x7cVGND\x7cVSS nfet L=0.15U
+ W=0.42U AS=0.1092P AD=0.0567P PS=1.36U PD=0.69U
* device instance $226 r0 *1 0,0 nfet
M$226 \$0$159 D\x7cX_7 GND\x7cVGND\x7cVSS GND\x7cVGND\x7cVSS nfet L=0.15U
+ W=0.42U AS=0.2205P AD=0.066P PS=1.89U PD=0.745U
* device instance $227 r0 *1 0,0 nfet
M$227 \$0$160 D\x7cX_8 GND\x7cVGND\x7cVSS GND\x7cVGND\x7cVSS nfet L=0.15U
+ W=0.42U AS=0.2205P AD=0.066P PS=1.89U PD=0.745U
* device instance $228 r0 *1 0,0 nfet
M$228 \$0$161 \$0$158 GND\x7cVGND\x7cVSS GND\x7cVGND\x7cVSS nfet L=0.15U
+ W=0.42U AS=0.0567P AD=0.1092P PS=0.69U PD=1.36U
* device instance $229 r0 *1 0,0 nfet
M$229 \$0$162 B\x7cD\x7cPH_B0\x7cQ\x7cS GND\x7cVGND\x7cVSS GND\x7cVGND\x7cVSS
+ nfet L=0.15U W=0.42U AS=0.2205P AD=0.066P PS=1.89U PD=0.745U
* device instance $230 r0 *1 0,0 nfet
M$230 \$0$163 \$0$149 \$0$159 GND\x7cVGND\x7cVSS nfet L=0.15U W=0.36U AS=0.066P
+ AD=0.0594P PS=0.745U PD=0.69U
* device instance $231 r0 *1 0,0 nfet
M$231 \$0$164 \$0$150 \$0$160 GND\x7cVGND\x7cVSS nfet L=0.15U W=0.36U AS=0.066P
+ AD=0.0594P PS=0.745U PD=0.69U
* device instance $232 r0 *1 0,0 nfet
M$232 \$0$165 C\x7cD\x7cPH_B7\x7cQ\x7cS GND\x7cVGND\x7cVSS GND\x7cVGND\x7cVSS
+ nfet L=0.15U W=0.42U AS=0.2205P AD=0.066P PS=1.89U PD=0.745U
* device instance $233 r0 *1 0,0 nfet
M$233 \$0$166 \$0$154 \$0$162 GND\x7cVGND\x7cVSS nfet L=0.15U W=0.36U AS=0.066P
+ AD=0.0594P PS=0.745U PD=0.69U
* device instance $234 r0 *1 0,0 nfet
M$234 \$0$167 \$0$152 \$0$163 GND\x7cVGND\x7cVSS nfet L=0.15U W=0.36U
+ AS=0.0594P AD=0.1401P PS=0.69U PD=1.1U
* device instance $235 r0 *1 0,0 nfet
M$235 \$0$168 \$0$153 \$0$164 GND\x7cVGND\x7cVSS nfet L=0.15U W=0.36U
+ AS=0.0594P AD=0.1401P PS=0.69U PD=1.1U
* device instance $236 r0 *1 0,0 nfet
M$236 GND\x7cVGND\x7cVSS A\x7cCLK\x7cX \$0$169 GND\x7cVGND\x7cVSS nfet L=0.15U
+ W=0.42U AS=0.1092P AD=0.0567P PS=1.36U PD=0.69U
* device instance $237 r0 *1 0,0 nfet
M$237 GND\x7cVGND\x7cVSS A\x7cCLK\x7cX \$0$170 GND\x7cVGND\x7cVSS nfet L=0.15U
+ W=0.42U AS=0.1092P AD=0.0567P PS=1.36U PD=0.69U
* device instance $238 r0 *1 0,0 nfet
M$238 GND\x7cVGND\x7cVSS \$0$171 D\x7cX_7 GND\x7cVGND\x7cVSS nfet L=0.15U
+ W=0.65U AS=0.169P AD=0.11285P PS=1.82U PD=1.045U
* device instance $239 r0 *1 0,0 nfet
M$239 GND\x7cVGND\x7cVSS A\x7cCLK\x7cX \$0$172 GND\x7cVGND\x7cVSS nfet L=0.15U
+ W=0.42U AS=0.1092P AD=0.0567P PS=1.36U PD=0.69U
* device instance $240 r0 *1 0,0 nfet
M$240 GND\x7cVGND\x7cVSS CLK\x7cX \$0$173 GND\x7cVGND\x7cVSS nfet L=0.15U
+ W=0.42U AS=0.1092P AD=0.0567P PS=1.36U PD=0.69U
* device instance $241 r0 *1 0,0 nfet
M$241 GND\x7cVGND\x7cVSS CLK\x7cX \$0$174 GND\x7cVGND\x7cVSS nfet L=0.15U
+ W=0.42U AS=0.1092P AD=0.0567P PS=1.36U PD=0.69U
* device instance $242 r0 *1 0,0 nfet
M$242 \$0$175 A\x7cA_N\x7cD\x7cPH_B9\x7cQ\x7cS GND\x7cVGND\x7cVSS
+ GND\x7cVGND\x7cVSS nfet L=0.15U W=0.42U AS=0.2205P AD=0.066P PS=1.89U
+ PD=0.745U
* device instance $243 r0 *1 0,0 nfet
M$243 \$0$176 \$0$156 \$0$165 GND\x7cVGND\x7cVSS nfet L=0.15U W=0.36U AS=0.066P
+ AD=0.0594P PS=0.745U PD=0.69U
* device instance $244 r0 *1 0,0 nfet
M$244 \$0$177 \$0$155 \$0$166 GND\x7cVGND\x7cVSS nfet L=0.15U W=0.36U
+ AS=0.0594P AD=0.1401P PS=0.69U PD=1.1U
* device instance $245 r0 *1 0,0 nfet
M$245 \$0$178 \$0$169 GND\x7cVGND\x7cVSS GND\x7cVGND\x7cVSS nfet L=0.15U
+ W=0.42U AS=0.0567P AD=0.1092P PS=0.69U PD=1.36U
* device instance $246 r0 *1 0,0 nfet
M$246 \$0$179 \$0$170 GND\x7cVGND\x7cVSS GND\x7cVGND\x7cVSS nfet L=0.15U
+ W=0.42U AS=0.0567P AD=0.1092P PS=0.69U PD=1.36U
* device instance $247 r0 *1 0,0 nfet
M$247 \$0$180 \$0$172 GND\x7cVGND\x7cVSS GND\x7cVGND\x7cVSS nfet L=0.15U
+ W=0.42U AS=0.0567P AD=0.1092P PS=0.69U PD=1.36U
* device instance $248 r0 *1 0,0 nfet
M$248 \$0$181 \$0$173 GND\x7cVGND\x7cVSS GND\x7cVGND\x7cVSS nfet L=0.15U
+ W=0.42U AS=0.0567P AD=0.1092P PS=0.69U PD=1.36U
* device instance $249 r0 *1 0,0 nfet
M$249 \$0$182 \$0$174 GND\x7cVGND\x7cVSS GND\x7cVGND\x7cVSS nfet L=0.15U
+ W=0.42U AS=0.0567P AD=0.1092P PS=0.69U PD=1.36U
* device instance $250 r0 *1 0,0 nfet
M$250 GND\x7cVGND\x7cVSS \$0$183 D\x7cX_9 GND\x7cVGND\x7cVSS nfet L=0.15U
+ W=0.65U AS=0.169P AD=0.11285P PS=1.82U PD=1.045U
* device instance $251 r0 *1 0,0 nfet
M$251 \$0$184 C\x7cD\x7cPH_B7\x7cQ\x7cS GND\x7cVGND\x7cVSS GND\x7cVGND\x7cVSS
+ nfet L=0.15U W=0.42U AS=0.11285P AD=0.0693P PS=1.045U PD=0.75U
* device instance $252 r0 *1 0,0 nfet
M$252 D\x7cPH_SAMPLE\x7cSAMPLE\x7cY A\x7cB\x7cBUSY\x7cX GND\x7cVGND\x7cVSS
+ GND\x7cVGND\x7cVSS nfet L=0.15U W=0.65U AS=0.169P AD=0.169P PS=1.82U PD=1.82U
* device instance $253 r0 *1 0,0 nfet
M$253 \$0$186 \$0$185 \$0$167 GND\x7cVGND\x7cVSS nfet L=0.15U W=0.42U
+ AS=0.1401P AD=0.0441P PS=1.1U PD=0.63U
* device instance $254 r0 *1 0,0 nfet
M$254 \$0$188 \$0$187 \$0$168 GND\x7cVGND\x7cVSS nfet L=0.15U W=0.42U
+ AS=0.1401P AD=0.0441P PS=1.1U PD=0.63U
* device instance $255 r0 *1 0,0 nfet
M$255 \$0$189 \$0$158 \$0$175 GND\x7cVGND\x7cVSS nfet L=0.15U W=0.36U AS=0.066P
+ AD=0.0594P PS=0.745U PD=0.69U
* device instance $256 r0 *1 0,0 nfet
M$256 \$0$190 \$0$157 \$0$176 GND\x7cVGND\x7cVSS nfet L=0.15U W=0.36U
+ AS=0.0594P AD=0.1401P PS=0.69U PD=1.1U
* device instance $257 r0 *1 0,0 nfet
M$257 \$0$191 B\x7cD\x7cPH_B0\x7cQ\x7cS GND\x7cVGND\x7cVSS GND\x7cVGND\x7cVSS
+ nfet L=0.15U W=0.42U AS=0.11285P AD=0.0693P PS=1.045U PD=0.75U
* device instance $258 r0 *1 0,0 nfet
M$258 \$0$171 A1\x7cCOMP_OUT\x7cOUTP \$0$184 GND\x7cVGND\x7cVSS nfet L=0.15U
+ W=0.42U AS=0.0693P AD=0.09975P PS=0.75U PD=0.895U
* device instance $259 r0 *1 0,0 nfet
M$259 GND\x7cVGND\x7cVSS RESET_B\x7cRST_B \$0$186 GND\x7cVGND\x7cVSS nfet
+ L=0.15U W=0.42U AS=0.0441P AD=0.1346P PS=0.63U PD=1.15U
* device instance $260 r0 *1 0,0 nfet
M$260 GND\x7cVGND\x7cVSS RESET_B\x7cRST_B \$0$188 GND\x7cVGND\x7cVSS nfet
+ L=0.15U W=0.42U AS=0.0441P AD=0.1346P PS=0.63U PD=1.15U
* device instance $261 r0 *1 0,0 nfet
M$261 \$0$193 \$0$192 \$0$177 GND\x7cVGND\x7cVSS nfet L=0.15U W=0.42U
+ AS=0.1401P AD=0.0441P PS=1.1U PD=0.63U
* device instance $262 r0 *1 0,0 nfet
M$262 \$0$194 \$0$161 \$0$189 GND\x7cVGND\x7cVSS nfet L=0.15U W=0.36U
+ AS=0.0594P AD=0.1401P PS=0.69U PD=1.1U
* device instance $263 r0 *1 0,0 nfet
M$263 \$0$183 A1\x7cCOMP_OUT\x7cOUTP \$0$191 GND\x7cVGND\x7cVSS nfet L=0.15U
+ W=0.42U AS=0.0693P AD=0.09975P PS=0.75U PD=0.895U
* device instance $264 r0 *1 0,0 nfet
M$264 GND\x7cVGND\x7cVSS RESET_B\x7cRST_B \$0$193 GND\x7cVGND\x7cVSS nfet
+ L=0.15U W=0.42U AS=0.0441P AD=0.1346P PS=0.63U PD=1.15U
* device instance $265 r0 *1 0,0 nfet
M$265 \$0$196 \$0$195 \$0$190 GND\x7cVGND\x7cVSS nfet L=0.15U W=0.42U
+ AS=0.1401P AD=0.0441P PS=1.1U PD=0.63U
* device instance $266 r0 *1 0,0 nfet
M$266 \$0$197 A\x7cA0\x7cB\x7cDOUT7\x7cQ \$0$171 GND\x7cVGND\x7cVSS nfet
+ L=0.15U W=0.42U AS=0.09975P AD=0.0693P PS=0.895U PD=0.75U
* device instance $267 r0 *1 0,0 nfet
M$267 \$0$198 B\x7cD\x7cPH_B8\x7cQ\x7cS GND\x7cVGND\x7cVSS GND\x7cVGND\x7cVSS
+ nfet L=0.15U W=0.42U AS=0.2205P AD=0.066P PS=1.89U PD=0.745U
* device instance $268 r0 *1 0,0 nfet
M$268 \$0$199 D\x7cX_10 GND\x7cVGND\x7cVSS GND\x7cVGND\x7cVSS nfet L=0.15U
+ W=0.42U AS=0.2205P AD=0.066P PS=1.89U PD=0.745U
* device instance $269 r0 *1 0,0 nfet
M$269 \$0$200 D\x7cPH_SAMPLE\x7cSAMPLE\x7cY GND\x7cVGND\x7cVSS
+ GND\x7cVGND\x7cVSS nfet L=0.15U W=0.42U AS=0.2205P AD=0.066P PS=1.89U
+ PD=0.745U
* device instance $270 r0 *1 0,0 nfet
M$270 \$0$201 D\x7cX_6 GND\x7cVGND\x7cVSS GND\x7cVGND\x7cVSS nfet L=0.15U
+ W=0.42U AS=0.2205P AD=0.066P PS=1.89U PD=0.745U
* device instance $271 r0 *1 0,0 nfet
M$271 \$0$202 D\x7cX_9 GND\x7cVGND\x7cVSS GND\x7cVGND\x7cVSS nfet L=0.15U
+ W=0.42U AS=0.2205P AD=0.066P PS=1.89U PD=0.745U
* device instance $272 r0 *1 0,0 nfet
M$272 \$0$185 \$0$163 GND\x7cVGND\x7cVSS GND\x7cVGND\x7cVSS nfet L=0.15U
+ W=0.64U AS=0.1346P AD=0.0999P PS=1.15U PD=0.985U
* device instance $273 r0 *1 0,0 nfet
M$273 \$0$187 \$0$164 GND\x7cVGND\x7cVSS GND\x7cVGND\x7cVSS nfet L=0.15U
+ W=0.64U AS=0.1346P AD=0.0999P PS=1.15U PD=0.985U
* device instance $274 r0 *1 0,0 nfet
M$274 GND\x7cVGND\x7cVSS C\x7cX \$0$203 GND\x7cVGND\x7cVSS nfet L=0.15U W=0.42U
+ AS=0.1092P AD=0.0567P PS=1.36U PD=0.69U
* device instance $275 r0 *1 0,0 nfet
M$275 GND\x7cVGND\x7cVSS RESET_B\x7cRST_B \$0$196 GND\x7cVGND\x7cVSS nfet
+ L=0.15U W=0.42U AS=0.0441P AD=0.1346P PS=0.63U PD=1.15U
* device instance $276 r0 *1 0,0 nfet
M$276 \$0$205 \$0$204 \$0$194 GND\x7cVGND\x7cVSS nfet L=0.15U W=0.42U
+ AS=0.1401P AD=0.0441P PS=1.1U PD=0.63U
* device instance $277 r0 *1 0,0 nfet
M$277 \$0$206 A\x7cA0\x7cB\x7cDOUT0\x7cQ \$0$183 GND\x7cVGND\x7cVSS nfet
+ L=0.15U W=0.42U AS=0.09975P AD=0.0693P PS=0.895U PD=0.75U
* device instance $278 r0 *1 0,0 nfet
M$278 GND\x7cVGND\x7cVSS \$0$207 \$0$197 GND\x7cVGND\x7cVSS nfet L=0.15U
+ W=0.42U AS=0.0693P AD=0.1449P PS=0.75U PD=1.11U
* device instance $279 r0 *1 0,0 nfet
M$279 \$0$208 \$0$169 \$0$198 GND\x7cVGND\x7cVSS nfet L=0.15U W=0.36U AS=0.066P
+ AD=0.0594P PS=0.745U PD=0.69U
* device instance $280 r0 *1 0,0 nfet
M$280 \$0$209 \$0$170 \$0$199 GND\x7cVGND\x7cVSS nfet L=0.15U W=0.36U AS=0.066P
+ AD=0.0594P PS=0.745U PD=0.69U
* device instance $281 r0 *1 0,0 nfet
M$281 \$0$210 \$0$172 \$0$200 GND\x7cVGND\x7cVSS nfet L=0.15U W=0.36U AS=0.066P
+ AD=0.0594P PS=0.745U PD=0.69U
* device instance $282 r0 *1 0,0 nfet
M$282 \$0$211 \$0$173 \$0$201 GND\x7cVGND\x7cVSS nfet L=0.15U W=0.36U AS=0.066P
+ AD=0.0594P PS=0.745U PD=0.69U
* device instance $283 r0 *1 0,0 nfet
M$283 \$0$212 \$0$174 \$0$202 GND\x7cVGND\x7cVSS nfet L=0.15U W=0.36U AS=0.066P
+ AD=0.0594P PS=0.745U PD=0.69U
* device instance $284 r0 *1 0,0 nfet
M$284 \$0$192 \$0$166 GND\x7cVGND\x7cVSS GND\x7cVGND\x7cVSS nfet L=0.15U
+ W=0.64U AS=0.1346P AD=0.0999P PS=1.15U PD=0.985U
* device instance $285 r0 *1 0,0 nfet
M$285 \$0$213 \$0$152 \$0$185 GND\x7cVGND\x7cVSS nfet L=0.15U W=0.36U
+ AS=0.0999P AD=0.0711P PS=0.985U PD=0.755U
* device instance $286 r0 *1 0,0 nfet
M$286 \$0$214 \$0$153 \$0$187 GND\x7cVGND\x7cVSS nfet L=0.15U W=0.36U
+ AS=0.0999P AD=0.0711P PS=0.985U PD=0.755U
* device instance $287 r0 *1 0,0 nfet
M$287 \$0$203 B\x7cX GND\x7cVGND\x7cVSS GND\x7cVGND\x7cVSS nfet L=0.15U W=0.42U
+ AS=0.0567P AD=0.0567P PS=0.69U PD=0.69U
* device instance $288 r0 *1 0,0 nfet
M$288 GND\x7cVGND\x7cVSS RESET_B\x7cRST_B \$0$205 GND\x7cVGND\x7cVSS nfet
+ L=0.15U W=0.42U AS=0.0441P AD=0.1346P PS=0.63U PD=1.15U
* device instance $289 r0 *1 0,0 nfet
M$289 GND\x7cVGND\x7cVSS \$0$215 \$0$206 GND\x7cVGND\x7cVSS nfet L=0.15U
+ W=0.42U AS=0.0693P AD=0.1449P PS=0.75U PD=1.11U
* device instance $290 r0 *1 0,0 nfet
M$290 \$0$216 \$0$178 \$0$208 GND\x7cVGND\x7cVSS nfet L=0.15U W=0.36U
+ AS=0.0594P AD=0.1401P PS=0.69U PD=1.1U
* device instance $291 r0 *1 0,0 nfet
M$291 \$0$209 \$0$179 \$0$217 GND\x7cVGND\x7cVSS nfet L=0.15U W=0.36U
+ AS=0.1401P AD=0.0594P PS=1.1U PD=0.69U
* device instance $292 r0 *1 0,0 nfet
M$292 \$0$210 \$0$180 \$0$218 GND\x7cVGND\x7cVSS nfet L=0.15U W=0.36U
+ AS=0.1401P AD=0.0594P PS=1.1U PD=0.69U
* device instance $293 r0 *1 0,0 nfet
M$293 \$0$211 \$0$181 \$0$219 GND\x7cVGND\x7cVSS nfet L=0.15U W=0.36U
+ AS=0.1401P AD=0.0594P PS=1.1U PD=0.69U
* device instance $294 r0 *1 0,0 nfet
M$294 \$0$220 \$0$182 \$0$212 GND\x7cVGND\x7cVSS nfet L=0.15U W=0.36U
+ AS=0.0594P AD=0.1401P PS=0.69U PD=1.1U
* device instance $295 r0 *1 0,0 nfet
M$295 \$0$195 \$0$176 GND\x7cVGND\x7cVSS GND\x7cVGND\x7cVSS nfet L=0.15U
+ W=0.64U AS=0.1346P AD=0.0999P PS=1.15U PD=0.985U
* device instance $296 r0 *1 0,0 nfet
M$296 \$0$203 A\x7cX_2 GND\x7cVGND\x7cVSS GND\x7cVGND\x7cVSS nfet L=0.15U
+ W=0.42U AS=0.101875P AD=0.0567P PS=0.99U PD=0.69U
* device instance $297 r0 *1 0,0 nfet
M$297 \$0$221 \$0$155 \$0$192 GND\x7cVGND\x7cVSS nfet L=0.15U W=0.36U
+ AS=0.0999P AD=0.0711P PS=0.985U PD=0.755U
* device instance $298 r0 *1 0,0 nfet
M$298 \$0$222 \$0$149 \$0$213 GND\x7cVGND\x7cVSS nfet L=0.15U W=0.36U
+ AS=0.0711P AD=0.0669P PS=0.755U PD=0.75U
* device instance $299 r0 *1 0,0 nfet
M$299 \$0$223 \$0$150 \$0$214 GND\x7cVGND\x7cVSS nfet L=0.15U W=0.36U
+ AS=0.0711P AD=0.0669P PS=0.755U PD=0.75U
* device instance $300 r0 *1 0,0 nfet
M$300 \$0$207 C\x7cD\x7cPH_B7\x7cQ\x7cS GND\x7cVGND\x7cVSS GND\x7cVGND\x7cVSS
+ nfet L=0.15U W=0.42U AS=0.1449P AD=0.1092P PS=1.11U PD=1.36U
* device instance $301 r0 *1 0,0 nfet
M$301 \$0$204 \$0$189 GND\x7cVGND\x7cVSS GND\x7cVGND\x7cVSS nfet L=0.15U
+ W=0.64U AS=0.1346P AD=0.0999P PS=1.15U PD=0.985U
* device instance $302 r0 *1 0,0 nfet
M$302 \$0$224 \$0$157 \$0$195 GND\x7cVGND\x7cVSS nfet L=0.15U W=0.36U
+ AS=0.0999P AD=0.0711P PS=0.985U PD=0.755U
* device instance $303 r0 *1 0,0 nfet
M$303 A\x7cB\x7cBUSY\x7cX \$0$203 GND\x7cVGND\x7cVSS GND\x7cVGND\x7cVSS nfet
+ L=0.15U W=0.65U AS=0.101875P AD=0.182P PS=0.99U PD=1.86U
* device instance $304 r0 *1 0,0 nfet
M$304 \$0$225 \$0$154 \$0$221 GND\x7cVGND\x7cVSS nfet L=0.15U W=0.36U
+ AS=0.0711P AD=0.0669P PS=0.755U PD=0.75U
* device instance $305 r0 *1 0,0 nfet
M$305 GND\x7cVGND\x7cVSS \$0$226 \$0$222 GND\x7cVGND\x7cVSS nfet L=0.15U
+ W=0.42U AS=0.0669P AD=0.12495P PS=0.75U PD=1.015U
* device instance $306 r0 *1 0,0 nfet
M$306 GND\x7cVGND\x7cVSS \$0$227 \$0$223 GND\x7cVGND\x7cVSS nfet L=0.15U
+ W=0.42U AS=0.0669P AD=0.12495P PS=0.75U PD=1.015U
* device instance $307 r0 *1 0,0 nfet
M$307 \$0$215 B\x7cD\x7cPH_B0\x7cQ\x7cS GND\x7cVGND\x7cVSS GND\x7cVGND\x7cVSS
+ nfet L=0.15U W=0.42U AS=0.1449P AD=0.1092P PS=1.11U PD=1.36U
* device instance $308 r0 *1 0,0 nfet
M$308 \$0$229 \$0$228 \$0$216 GND\x7cVGND\x7cVSS nfet L=0.15U W=0.42U
+ AS=0.1401P AD=0.0441P PS=1.1U PD=0.63U
* device instance $309 r0 *1 0,0 nfet
M$309 \$0$231 \$0$230 \$0$217 GND\x7cVGND\x7cVSS nfet L=0.15U W=0.42U
+ AS=0.1401P AD=0.0441P PS=1.1U PD=0.63U
* device instance $310 r0 *1 0,0 nfet
M$310 \$0$233 \$0$232 \$0$218 GND\x7cVGND\x7cVSS nfet L=0.15U W=0.42U
+ AS=0.1401P AD=0.0441P PS=1.1U PD=0.63U
* device instance $311 r0 *1 0,0 nfet
M$311 \$0$235 \$0$234 \$0$219 GND\x7cVGND\x7cVSS nfet L=0.15U W=0.42U
+ AS=0.1401P AD=0.0441P PS=1.1U PD=0.63U
* device instance $312 r0 *1 0,0 nfet
M$312 \$0$237 \$0$236 \$0$220 GND\x7cVGND\x7cVSS nfet L=0.15U W=0.42U
+ AS=0.1401P AD=0.0441P PS=1.1U PD=0.63U
* device instance $313 r0 *1 0,0 nfet
M$313 \$0$238 \$0$161 \$0$204 GND\x7cVGND\x7cVSS nfet L=0.15U W=0.36U
+ AS=0.0999P AD=0.0711P PS=0.985U PD=0.755U
* device instance $314 r0 *1 0,0 nfet
M$314 \$0$239 \$0$156 \$0$224 GND\x7cVGND\x7cVSS nfet L=0.15U W=0.36U
+ AS=0.0711P AD=0.0669P PS=0.755U PD=0.75U
* device instance $315 r0 *1 0,0 nfet
M$315 GND\x7cVGND\x7cVSS \$0$240 \$0$225 GND\x7cVGND\x7cVSS nfet L=0.15U
+ W=0.42U AS=0.0669P AD=0.12495P PS=0.75U PD=1.015U
* device instance $316 r0 *1 0,0 nfet
M$316 GND\x7cVGND\x7cVSS RESET_B\x7cRST_B \$0$229 GND\x7cVGND\x7cVSS nfet
+ L=0.15U W=0.42U AS=0.0441P AD=0.1346P PS=0.63U PD=1.15U
* device instance $317 r0 *1 0,0 nfet
M$317 \$0$231 RESET_B\x7cRST_B GND\x7cVGND\x7cVSS GND\x7cVGND\x7cVSS nfet
+ L=0.15U W=0.42U AS=0.1346P AD=0.0441P PS=1.15U PD=0.63U
* device instance $318 r0 *1 0,0 nfet
M$318 \$0$233 RESET_B\x7cRST_B GND\x7cVGND\x7cVSS GND\x7cVGND\x7cVSS nfet
+ L=0.15U W=0.42U AS=0.1346P AD=0.0441P PS=1.15U PD=0.63U
* device instance $319 r0 *1 0,0 nfet
M$319 \$0$235 RESET_B\x7cRST_B GND\x7cVGND\x7cVSS GND\x7cVGND\x7cVSS nfet
+ L=0.15U W=0.42U AS=0.1346P AD=0.0441P PS=1.15U PD=0.63U
* device instance $320 r0 *1 0,0 nfet
M$320 GND\x7cVGND\x7cVSS RESET_B\x7cRST_B \$0$237 GND\x7cVGND\x7cVSS nfet
+ L=0.15U W=0.42U AS=0.0441P AD=0.1346P PS=0.63U PD=1.15U
* device instance $321 r0 *1 0,0 nfet
M$321 \$0$241 RESET_B\x7cRST_B GND\x7cVGND\x7cVSS GND\x7cVGND\x7cVSS nfet
+ L=0.15U W=0.42U AS=0.12495P AD=0.06405P PS=1.015U PD=0.725U
* device instance $322 r0 *1 0,0 nfet
M$322 \$0$242 RESET_B\x7cRST_B GND\x7cVGND\x7cVSS GND\x7cVGND\x7cVSS nfet
+ L=0.15U W=0.42U AS=0.12495P AD=0.06405P PS=1.015U PD=0.725U
* device instance $323 r0 *1 0,0 nfet
M$323 GND\x7cVGND\x7cVSS \$0$243 D\x7cX_10 GND\x7cVGND\x7cVSS nfet L=0.15U
+ W=0.65U AS=0.169P AD=0.11285P PS=1.82U PD=1.045U
* device instance $324 r0 *1 0,0 nfet
M$324 GND\x7cVGND\x7cVSS \$0$244 D\x7cX_8 GND\x7cVGND\x7cVSS nfet L=0.15U
+ W=0.65U AS=0.169P AD=0.11285P PS=1.82U PD=1.045U
* device instance $325 r0 *1 0,0 nfet
M$325 \$0$245 \$0$158 \$0$238 GND\x7cVGND\x7cVSS nfet L=0.15U W=0.36U
+ AS=0.0711P AD=0.0669P PS=0.755U PD=0.75U
* device instance $326 r0 *1 0,0 nfet
M$326 GND\x7cVGND\x7cVSS \$0$246 \$0$239 GND\x7cVGND\x7cVSS nfet L=0.15U
+ W=0.42U AS=0.0669P AD=0.12495P PS=0.75U PD=1.015U
* device instance $327 r0 *1 0,0 nfet
M$327 \$0$226 \$0$213 \$0$241 GND\x7cVGND\x7cVSS nfet L=0.15U W=0.42U
+ AS=0.06405P AD=0.1092P PS=0.725U PD=1.36U
* device instance $328 r0 *1 0,0 nfet
M$328 \$0$227 \$0$214 \$0$242 GND\x7cVGND\x7cVSS nfet L=0.15U W=0.42U
+ AS=0.06405P AD=0.1092P PS=0.725U PD=1.36U
* device instance $329 r0 *1 0,0 nfet
M$329 \$0$247 RESET_B\x7cRST_B GND\x7cVGND\x7cVSS GND\x7cVGND\x7cVSS nfet
+ L=0.15U W=0.42U AS=0.12495P AD=0.06405P PS=1.015U PD=0.725U
* device instance $330 r0 *1 0,0 nfet
M$330 \$0$228 \$0$208 GND\x7cVGND\x7cVSS GND\x7cVGND\x7cVSS nfet L=0.15U
+ W=0.64U AS=0.1346P AD=0.0999P PS=1.15U PD=0.985U
* device instance $331 r0 *1 0,0 nfet
M$331 \$0$230 \$0$209 GND\x7cVGND\x7cVSS GND\x7cVGND\x7cVSS nfet L=0.15U
+ W=0.64U AS=0.1346P AD=0.0999P PS=1.15U PD=0.985U
* device instance $332 r0 *1 0,0 nfet
M$332 \$0$232 \$0$210 GND\x7cVGND\x7cVSS GND\x7cVGND\x7cVSS nfet L=0.15U
+ W=0.64U AS=0.1346P AD=0.0999P PS=1.15U PD=0.985U
* device instance $333 r0 *1 0,0 nfet
M$333 \$0$234 \$0$211 GND\x7cVGND\x7cVSS GND\x7cVGND\x7cVSS nfet L=0.15U
+ W=0.64U AS=0.1346P AD=0.0999P PS=1.15U PD=0.985U
* device instance $334 r0 *1 0,0 nfet
M$334 \$0$236 \$0$212 GND\x7cVGND\x7cVSS GND\x7cVGND\x7cVSS nfet L=0.15U
+ W=0.64U AS=0.1346P AD=0.0999P PS=1.15U PD=0.985U
* device instance $335 r0 *1 0,0 nfet
M$335 GND\x7cVGND\x7cVSS C\x7cPH_EOC\x7cQ \$0$248 GND\x7cVGND\x7cVSS nfet
+ L=0.15U W=0.42U AS=0.1092P AD=0.0567P PS=1.36U PD=0.69U
* device instance $336 r0 *1 0,0 nfet
M$336 GND\x7cVGND\x7cVSS \$0$249 \$0$245 GND\x7cVGND\x7cVSS nfet L=0.15U
+ W=0.42U AS=0.0669P AD=0.12495P PS=0.75U PD=1.015U
* device instance $337 r0 *1 0,0 nfet
M$337 \$0$250 B\x7cD\x7cPH_B8\x7cQ\x7cS GND\x7cVGND\x7cVSS GND\x7cVGND\x7cVSS
+ nfet L=0.15U W=0.42U AS=0.11285P AD=0.0693P PS=1.045U PD=0.75U
* device instance $338 r0 *1 0,0 nfet
M$338 \$0$251 A\x7cA_N\x7cD\x7cPH_B9\x7cQ\x7cS GND\x7cVGND\x7cVSS
+ GND\x7cVGND\x7cVSS nfet L=0.15U W=0.42U AS=0.11285P AD=0.0693P PS=1.045U
+ PD=0.75U
* device instance $339 r0 *1 0,0 nfet
M$339 \$0$240 \$0$221 \$0$247 GND\x7cVGND\x7cVSS nfet L=0.15U W=0.42U
+ AS=0.06405P AD=0.1092P PS=0.725U PD=1.36U
* device instance $340 r0 *1 0,0 nfet
M$340 \$0$252 RESET_B\x7cRST_B GND\x7cVGND\x7cVSS GND\x7cVGND\x7cVSS nfet
+ L=0.15U W=0.42U AS=0.12495P AD=0.06405P PS=1.015U PD=0.725U
* device instance $341 r0 *1 0,0 nfet
M$341 \$0$253 \$0$178 \$0$228 GND\x7cVGND\x7cVSS nfet L=0.15U W=0.36U
+ AS=0.0999P AD=0.0711P PS=0.985U PD=0.755U
* device instance $342 r0 *1 0,0 nfet
M$342 \$0$254 \$0$179 \$0$230 GND\x7cVGND\x7cVSS nfet L=0.15U W=0.36U
+ AS=0.0999P AD=0.0711P PS=0.985U PD=0.755U
* device instance $343 r0 *1 0,0 nfet
M$343 \$0$255 \$0$180 \$0$232 GND\x7cVGND\x7cVSS nfet L=0.15U W=0.36U
+ AS=0.0999P AD=0.0711P PS=0.985U PD=0.755U
* device instance $344 r0 *1 0,0 nfet
M$344 \$0$256 \$0$181 \$0$234 GND\x7cVGND\x7cVSS nfet L=0.15U W=0.36U
+ AS=0.0999P AD=0.0711P PS=0.985U PD=0.755U
* device instance $345 r0 *1 0,0 nfet
M$345 \$0$257 \$0$182 \$0$236 GND\x7cVGND\x7cVSS nfet L=0.15U W=0.36U
+ AS=0.0999P AD=0.0711P PS=0.985U PD=0.755U
* device instance $346 r0 *1 0,0 nfet
M$346 \$0$248 B\x7cD\x7cPH_B0\x7cQ\x7cS GND\x7cVGND\x7cVSS GND\x7cVGND\x7cVSS
+ nfet L=0.15U W=0.42U AS=0.0567P AD=0.0567P PS=0.69U PD=0.69U
* device instance $347 r0 *1 0,0 nfet
M$347 \$0$243 A1\x7cCOMP_OUT\x7cOUTP \$0$250 GND\x7cVGND\x7cVSS nfet L=0.15U
+ W=0.42U AS=0.0693P AD=0.09975P PS=0.75U PD=0.895U
* device instance $348 r0 *1 0,0 nfet
M$348 \$0$244 A1\x7cCOMP_OUT\x7cOUTP \$0$251 GND\x7cVGND\x7cVSS nfet L=0.15U
+ W=0.42U AS=0.0693P AD=0.09975P PS=0.75U PD=0.895U
* device instance $349 r0 *1 0,0 nfet
M$349 \$0$246 \$0$224 \$0$252 GND\x7cVGND\x7cVSS nfet L=0.15U W=0.42U
+ AS=0.06405P AD=0.1092P PS=0.725U PD=1.36U
* device instance $350 r0 *1 0,0 nfet
M$350 \$0$258 RESET_B\x7cRST_B GND\x7cVGND\x7cVSS GND\x7cVGND\x7cVSS nfet
+ L=0.15U W=0.42U AS=0.12495P AD=0.06405P PS=1.015U PD=0.725U
* device instance $351 r0 *1 0,0 nfet
M$351 \$0$248 A\x7cD\x7cPH_B1\x7cQ\x7cS GND\x7cVGND\x7cVSS GND\x7cVGND\x7cVSS
+ nfet L=0.15U W=0.42U AS=0.101875P AD=0.0567P PS=0.99U PD=0.69U
* device instance $352 r0 *1 0,0 nfet
M$352 A\x7cA0\x7cB\x7cDOUT7\x7cQ \$0$226 GND\x7cVGND\x7cVSS GND\x7cVGND\x7cVSS
+ nfet L=0.15U W=0.65U AS=0.2087P AD=0.169P PS=2.02U PD=1.82U
* device instance $353 r0 *1 0,0 nfet
M$353 A\x7cA0\x7cB\x7cDOUT9\x7cQ \$0$227 GND\x7cVGND\x7cVSS GND\x7cVGND\x7cVSS
+ nfet L=0.15U W=0.65U AS=0.2087P AD=0.169P PS=2.02U PD=1.82U
* device instance $354 r0 *1 0,0 nfet
M$354 \$0$259 \$0$169 \$0$253 GND\x7cVGND\x7cVSS nfet L=0.15U W=0.36U
+ AS=0.0711P AD=0.0669P PS=0.755U PD=0.75U
* device instance $355 r0 *1 0,0 nfet
M$355 \$0$254 \$0$170 \$0$260 GND\x7cVGND\x7cVSS nfet L=0.15U W=0.36U
+ AS=0.0669P AD=0.0711P PS=0.75U PD=0.755U
* device instance $356 r0 *1 0,0 nfet
M$356 \$0$255 \$0$172 \$0$261 GND\x7cVGND\x7cVSS nfet L=0.15U W=0.36U
+ AS=0.0669P AD=0.0711P PS=0.75U PD=0.755U
* device instance $357 r0 *1 0,0 nfet
M$357 \$0$256 \$0$173 \$0$262 GND\x7cVGND\x7cVSS nfet L=0.15U W=0.36U
+ AS=0.0669P AD=0.0711P PS=0.75U PD=0.755U
* device instance $358 r0 *1 0,0 nfet
M$358 \$0$263 \$0$174 \$0$257 GND\x7cVGND\x7cVSS nfet L=0.15U W=0.36U
+ AS=0.0711P AD=0.0669P PS=0.755U PD=0.75U
* device instance $359 r0 *1 0,0 nfet
M$359 \$0$264 A\x7cA0\x7cB\x7cDOUT8\x7cQ \$0$243 GND\x7cVGND\x7cVSS nfet
+ L=0.15U W=0.42U AS=0.09975P AD=0.0693P PS=0.895U PD=0.75U
* device instance $360 r0 *1 0,0 nfet
M$360 \$0$265 A\x7cA0\x7cB\x7cDOUT9\x7cQ \$0$244 GND\x7cVGND\x7cVSS nfet
+ L=0.15U W=0.42U AS=0.09975P AD=0.0693P PS=0.895U PD=0.75U
* device instance $361 r0 *1 0,0 nfet
M$361 \$0$249 \$0$238 \$0$258 GND\x7cVGND\x7cVSS nfet L=0.15U W=0.42U
+ AS=0.06405P AD=0.1092P PS=0.725U PD=1.36U
* device instance $362 r0 *1 0,0 nfet
M$362 C\x7cX \$0$248 GND\x7cVGND\x7cVSS GND\x7cVGND\x7cVSS nfet L=0.15U W=0.65U
+ AS=0.101875P AD=0.182P PS=0.99U PD=1.86U
* device instance $363 r0 *1 0,0 nfet
M$363 C\x7cPH_EOC\x7cQ \$0$240 GND\x7cVGND\x7cVSS GND\x7cVGND\x7cVSS nfet
+ L=0.15U W=0.65U AS=0.2087P AD=0.169P PS=2.02U PD=1.82U
* device instance $364 r0 *1 0,0 nfet
M$364 GND\x7cVGND\x7cVSS \$0$266 \$0$259 GND\x7cVGND\x7cVSS nfet L=0.15U
+ W=0.42U AS=0.0669P AD=0.12495P PS=0.75U PD=1.015U
* device instance $365 r0 *1 0,0 nfet
M$365 GND\x7cVGND\x7cVSS \$0$267 \$0$260 GND\x7cVGND\x7cVSS nfet L=0.15U
+ W=0.42U AS=0.0669P AD=0.12495P PS=0.75U PD=1.015U
* device instance $366 r0 *1 0,0 nfet
M$366 GND\x7cVGND\x7cVSS \$0$268 \$0$261 GND\x7cVGND\x7cVSS nfet L=0.15U
+ W=0.42U AS=0.0669P AD=0.12495P PS=0.75U PD=1.015U
* device instance $367 r0 *1 0,0 nfet
M$367 GND\x7cVGND\x7cVSS \$0$269 \$0$262 GND\x7cVGND\x7cVSS nfet L=0.15U
+ W=0.42U AS=0.0669P AD=0.12495P PS=0.75U PD=1.015U
* device instance $368 r0 *1 0,0 nfet
M$368 GND\x7cVGND\x7cVSS \$0$270 \$0$263 GND\x7cVGND\x7cVSS nfet L=0.15U
+ W=0.42U AS=0.0669P AD=0.12495P PS=0.75U PD=1.015U
* device instance $369 r0 *1 0,0 nfet
M$369 GND\x7cVGND\x7cVSS \$0$271 \$0$264 GND\x7cVGND\x7cVSS nfet L=0.15U
+ W=0.42U AS=0.0693P AD=0.1449P PS=0.75U PD=1.11U
* device instance $370 r0 *1 0,0 nfet
M$370 GND\x7cVGND\x7cVSS \$0$272 \$0$265 GND\x7cVGND\x7cVSS nfet L=0.15U
+ W=0.42U AS=0.0693P AD=0.1449P PS=0.75U PD=1.11U
* device instance $371 r0 *1 0,0 nfet
M$371 D\x7cPH_B6\x7cQ\x7cS \$0$246 GND\x7cVGND\x7cVSS GND\x7cVGND\x7cVSS nfet
+ L=0.15U W=0.65U AS=0.2087P AD=0.169P PS=2.02U PD=1.82U
* device instance $372 r0 *1 0,0 nfet
M$372 \$0$273 RESET_B\x7cRST_B GND\x7cVGND\x7cVSS GND\x7cVGND\x7cVSS nfet
+ L=0.15U W=0.42U AS=0.12495P AD=0.06405P PS=1.015U PD=0.725U
* device instance $373 r0 *1 0,0 nfet
M$373 \$0$274 RESET_B\x7cRST_B GND\x7cVGND\x7cVSS GND\x7cVGND\x7cVSS nfet
+ L=0.15U W=0.42U AS=0.12495P AD=0.06405P PS=1.015U PD=0.725U
* device instance $374 r0 *1 0,0 nfet
M$374 \$0$275 RESET_B\x7cRST_B GND\x7cVGND\x7cVSS GND\x7cVGND\x7cVSS nfet
+ L=0.15U W=0.42U AS=0.12495P AD=0.06405P PS=1.015U PD=0.725U
* device instance $375 r0 *1 0,0 nfet
M$375 \$0$276 RESET_B\x7cRST_B GND\x7cVGND\x7cVSS GND\x7cVGND\x7cVSS nfet
+ L=0.15U W=0.42U AS=0.12495P AD=0.06405P PS=1.015U PD=0.725U
* device instance $376 r0 *1 0,0 nfet
M$376 \$0$277 RESET_B\x7cRST_B GND\x7cVGND\x7cVSS GND\x7cVGND\x7cVSS nfet
+ L=0.15U W=0.42U AS=0.12495P AD=0.06405P PS=1.015U PD=0.725U
* device instance $377 r0 *1 0,0 nfet
M$377 B\x7cD\x7cPH_B8\x7cQ\x7cS \$0$249 GND\x7cVGND\x7cVSS GND\x7cVGND\x7cVSS
+ nfet L=0.15U W=0.65U AS=0.2087P AD=0.169P PS=2.02U PD=1.82U
* device instance $378 r0 *1 0,0 nfet
M$378 \$0$271 B\x7cD\x7cPH_B8\x7cQ\x7cS GND\x7cVGND\x7cVSS GND\x7cVGND\x7cVSS
+ nfet L=0.15U W=0.42U AS=0.1449P AD=0.1092P PS=1.11U PD=1.36U
* device instance $379 r0 *1 0,0 nfet
M$379 \$0$272 A\x7cA_N\x7cD\x7cPH_B9\x7cQ\x7cS GND\x7cVGND\x7cVSS
+ GND\x7cVGND\x7cVSS nfet L=0.15U W=0.42U AS=0.1449P AD=0.1092P PS=1.11U
+ PD=1.36U
* device instance $380 r0 *1 0,0 nfet
M$380 \$0$266 \$0$253 \$0$273 GND\x7cVGND\x7cVSS nfet L=0.15U W=0.42U
+ AS=0.06405P AD=0.1092P PS=0.725U PD=1.36U
* device instance $381 r0 *1 0,0 nfet
M$381 \$0$267 \$0$254 \$0$274 GND\x7cVGND\x7cVSS nfet L=0.15U W=0.42U
+ AS=0.06405P AD=0.1092P PS=0.725U PD=1.36U
* device instance $382 r0 *1 0,0 nfet
M$382 \$0$268 \$0$255 \$0$275 GND\x7cVGND\x7cVSS nfet L=0.15U W=0.42U
+ AS=0.06405P AD=0.1092P PS=0.725U PD=1.36U
* device instance $383 r0 *1 0,0 nfet
M$383 \$0$269 \$0$256 \$0$276 GND\x7cVGND\x7cVSS nfet L=0.15U W=0.42U
+ AS=0.06405P AD=0.1092P PS=0.725U PD=1.36U
* device instance $384 r0 *1 0,0 nfet
M$384 \$0$270 \$0$257 \$0$277 GND\x7cVGND\x7cVSS nfet L=0.15U W=0.42U
+ AS=0.06405P AD=0.1092P PS=0.725U PD=1.36U
* device instance $385 r0 *1 0,0 nfet
M$385 C\x7cD\x7cPH_B7\x7cQ\x7cS \$0$266 GND\x7cVGND\x7cVSS GND\x7cVGND\x7cVSS
+ nfet L=0.15U W=0.65U AS=0.2087P AD=0.169P PS=2.02U PD=1.82U
* device instance $386 r0 *1 0,0 nfet
M$386 A\x7cA0\x7cB\x7cDOUT8\x7cQ \$0$267 GND\x7cVGND\x7cVSS GND\x7cVGND\x7cVSS
+ nfet L=0.15U W=0.65U AS=0.2087P AD=0.169P PS=2.02U PD=1.82U
* device instance $387 r0 *1 0,0 nfet
M$387 A\x7cA_N\x7cD\x7cPH_B9\x7cQ\x7cS \$0$268 GND\x7cVGND\x7cVSS
+ GND\x7cVGND\x7cVSS nfet L=0.15U W=0.65U AS=0.2087P AD=0.169P PS=2.02U PD=1.82U
* device instance $388 r0 *1 0,0 nfet
M$388 A\x7cA0\x7cB\x7cDOUT1\x7cQ \$0$269 GND\x7cVGND\x7cVSS GND\x7cVGND\x7cVSS
+ nfet L=0.15U W=0.65U AS=0.2087P AD=0.169P PS=2.02U PD=1.82U
* device instance $389 r0 *1 0,0 nfet
M$389 A\x7cA0\x7cB\x7cDOUT0\x7cQ \$0$270 GND\x7cVGND\x7cVSS GND\x7cVGND\x7cVSS
+ nfet L=0.15U W=0.65U AS=0.2087P AD=0.169P PS=2.02U PD=1.82U
* device instance $390 r0 *1 0,0 pfet
M$390 VPB\x7cVPWR A\x7cCLK\x7cX \$0 VPB\x7cVPWR pfet L=0.15U W=0.64U AS=0.1664P
+ AD=0.0864P PS=1.8U PD=0.91U
* device instance $391 r0 *1 0,0 pfet
M$391 VPB\x7cVPWR CLK\x7cX \$0$1 VPB\x7cVPWR pfet L=0.15U W=0.64U AS=0.1664P
+ AD=0.0864P PS=1.8U PD=0.91U
* device instance $392 r0 *1 0,0 pfet
M$392 VPB\x7cVPWR CLK\x7cX \$0$2 VPB\x7cVPWR pfet L=0.15U W=0.64U AS=0.1664P
+ AD=0.0864P PS=1.8U PD=0.91U
* device instance $393 r0 *1 0,0 pfet
M$393 VPB\x7cVPWR CLK\x7cX \$0$3 VPB\x7cVPWR pfet L=0.15U W=0.64U AS=0.1664P
+ AD=0.0864P PS=1.8U PD=0.91U
* device instance $394 r0 *1 0,0 pfet
M$394 \$0$4 \$0 VPB\x7cVPWR VPB\x7cVPWR pfet L=0.15U W=0.64U AS=0.0864P
+ AD=0.1664P PS=0.91U PD=1.8U
* device instance $395 r0 *1 0,0 pfet
M$395 \$0$5 \$0$1 VPB\x7cVPWR VPB\x7cVPWR pfet L=0.15U W=0.64U AS=0.0864P
+ AD=0.1664P PS=0.91U PD=1.8U
* device instance $396 r0 *1 0,0 pfet
M$396 \$0$6 \$0$2 VPB\x7cVPWR VPB\x7cVPWR pfet L=0.15U W=0.64U AS=0.0864P
+ AD=0.1664P PS=0.91U PD=1.8U
* device instance $397 r0 *1 0,0 pfet
M$397 \$0$7 \$0$3 VPB\x7cVPWR VPB\x7cVPWR pfet L=0.15U W=0.64U AS=0.0864P
+ AD=0.1664P PS=0.91U PD=1.8U
* device instance $398 r0 *1 0,0 pfet
M$398 VPB\x7cVPWR CLK\x7cX \$0$8 VPB\x7cVPWR pfet L=0.15U W=0.64U AS=0.1664P
+ AD=0.0864P PS=1.8U PD=0.91U
* device instance $399 r0 *1 0,0 pfet
M$399 \$0$9 \$0$8 VPB\x7cVPWR VPB\x7cVPWR pfet L=0.15U W=0.64U AS=0.0864P
+ AD=0.1664P PS=0.91U PD=1.8U
* device instance $400 r0 *1 0,0 pfet
M$400 VPB\x7cVPWR A\x7cCLK\x7cX \$0$10 VPB\x7cVPWR pfet L=0.15U W=0.64U
+ AS=0.1664P AD=0.0864P PS=1.8U PD=0.91U
* device instance $401 r0 *1 0,0 pfet
M$401 VPB\x7cVPWR CLK\x7cX \$0$11 VPB\x7cVPWR pfet L=0.15U W=0.64U AS=0.1664P
+ AD=0.0864P PS=1.8U PD=0.91U
* device instance $402 r0 *1 0,0 pfet
M$402 \$0$12 D\x7cX VPB\x7cVPWR VPB\x7cVPWR pfet L=0.15U W=0.42U AS=0.1092P
+ AD=0.0651P PS=1.36U PD=0.73U
* device instance $403 r0 *1 0,0 pfet
M$403 \$0$13 B\x7cD\x7cPH_B4\x7cQ\x7cS VPB\x7cVPWR VPB\x7cVPWR pfet L=0.15U
+ W=0.42U AS=0.1092P AD=0.0651P PS=1.36U PD=0.73U
* device instance $404 r0 *1 0,0 pfet
M$404 \$0$14 D\x7cX_2 VPB\x7cVPWR VPB\x7cVPWR pfet L=0.15U W=0.42U AS=0.1092P
+ AD=0.0651P PS=1.36U PD=0.73U
* device instance $405 r0 *1 0,0 pfet
M$405 \$0$15 C\x7cD\x7cPH_B3\x7cQ\x7cS VPB\x7cVPWR VPB\x7cVPWR pfet L=0.15U
+ W=0.42U AS=0.1092P AD=0.0651P PS=1.36U PD=0.73U
* device instance $406 r0 *1 0,0 pfet
M$406 \$0$16 \$0$10 VPB\x7cVPWR VPB\x7cVPWR pfet L=0.15U W=0.64U AS=0.0864P
+ AD=0.1664P PS=0.91U PD=1.8U
* device instance $407 r0 *1 0,0 pfet
M$407 \$0$17 \$0$11 VPB\x7cVPWR VPB\x7cVPWR pfet L=0.15U W=0.64U AS=0.0864P
+ AD=0.1664P PS=0.91U PD=1.8U
* device instance $408 r0 *1 0,0 pfet
M$408 \$0$18 \$0$4 \$0$12 VPB\x7cVPWR pfet L=0.15U W=0.42U AS=0.0651P
+ AD=0.07245P PS=0.73U PD=0.765U
* device instance $409 r0 *1 0,0 pfet
M$409 \$0$19 \$0$5 \$0$13 VPB\x7cVPWR pfet L=0.15U W=0.42U AS=0.0651P
+ AD=0.07245P PS=0.73U PD=0.765U
* device instance $410 r0 *1 0,0 pfet
M$410 \$0$20 \$0$6 \$0$14 VPB\x7cVPWR pfet L=0.15U W=0.42U AS=0.0651P
+ AD=0.07245P PS=0.73U PD=0.765U
* device instance $411 r0 *1 0,0 pfet
M$411 \$0$21 \$0$7 \$0$15 VPB\x7cVPWR pfet L=0.15U W=0.42U AS=0.0651P
+ AD=0.07245P PS=0.73U PD=0.765U
* device instance $412 r0 *1 0,0 pfet
M$412 \$0$22 D\x7cX_3 VPB\x7cVPWR VPB\x7cVPWR pfet L=0.15U W=0.42U AS=0.1092P
+ AD=0.0651P PS=1.36U PD=0.73U
* device instance $413 r0 *1 0,0 pfet
M$413 \$0$278 \$0 \$0$18 VPB\x7cVPWR pfet L=0.15U W=0.42U AS=0.07245P
+ AD=0.1155P PS=0.765U PD=0.97U
* device instance $414 r0 *1 0,0 pfet
M$414 \$0$279 \$0$1 \$0$19 VPB\x7cVPWR pfet L=0.15U W=0.42U AS=0.07245P
+ AD=0.1155P PS=0.765U PD=0.97U
* device instance $415 r0 *1 0,0 pfet
M$415 \$0$280 \$0$2 \$0$20 VPB\x7cVPWR pfet L=0.15U W=0.42U AS=0.07245P
+ AD=0.1155P PS=0.765U PD=0.97U
* device instance $416 r0 *1 0,0 pfet
M$416 \$0$281 \$0$3 \$0$21 VPB\x7cVPWR pfet L=0.15U W=0.42U AS=0.07245P
+ AD=0.1155P PS=0.765U PD=0.97U
* device instance $417 r0 *1 0,0 pfet
M$417 \$0$27 D\x7cX_4 VPB\x7cVPWR VPB\x7cVPWR pfet L=0.15U W=0.42U AS=0.1092P
+ AD=0.0651P PS=1.36U PD=0.73U
* device instance $418 r0 *1 0,0 pfet
M$418 \$0$28 A\x7cD\x7cPH_B5\x7cQ\x7cS VPB\x7cVPWR VPB\x7cVPWR pfet L=0.15U
+ W=0.42U AS=0.1092P AD=0.0651P PS=1.36U PD=0.73U
* device instance $419 r0 *1 0,0 pfet
M$419 \$0$29 \$0$9 \$0$22 VPB\x7cVPWR pfet L=0.15U W=0.42U AS=0.0651P
+ AD=0.07245P PS=0.73U PD=0.765U
* device instance $420 r0 *1 0,0 pfet
M$420 VPB\x7cVPWR \$0$30 \$0$278 VPB\x7cVPWR pfet L=0.15U W=0.42U AS=0.1155P
+ AD=0.07035P PS=0.97U PD=0.755U
* device instance $421 r0 *1 0,0 pfet
M$421 VPB\x7cVPWR \$0$32 \$0$279 VPB\x7cVPWR pfet L=0.15U W=0.42U AS=0.1155P
+ AD=0.07035P PS=0.97U PD=0.755U
* device instance $422 r0 *1 0,0 pfet
M$422 VPB\x7cVPWR \$0$34 \$0$280 VPB\x7cVPWR pfet L=0.15U W=0.42U AS=0.1155P
+ AD=0.07035P PS=0.97U PD=0.755U
* device instance $423 r0 *1 0,0 pfet
M$423 VPB\x7cVPWR \$0$36 \$0$281 VPB\x7cVPWR pfet L=0.15U W=0.42U AS=0.1155P
+ AD=0.07035P PS=0.97U PD=0.755U
* device instance $424 r0 *1 0,0 pfet
M$424 \$0$38 \$0$16 \$0$27 VPB\x7cVPWR pfet L=0.15U W=0.42U AS=0.0651P
+ AD=0.07245P PS=0.73U PD=0.765U
* device instance $425 r0 *1 0,0 pfet
M$425 \$0$39 \$0$17 \$0$28 VPB\x7cVPWR pfet L=0.15U W=0.42U AS=0.0651P
+ AD=0.07245P PS=0.73U PD=0.765U
* device instance $426 r0 *1 0,0 pfet
M$426 \$0$282 \$0$8 \$0$29 VPB\x7cVPWR pfet L=0.15U W=0.42U AS=0.07245P
+ AD=0.1155P PS=0.765U PD=0.97U
* device instance $427 r0 *1 0,0 pfet
M$427 VPB\x7cVPWR \$0$41 D\x7cX_3 VPB\x7cVPWR pfet L=0.15U W=1U AS=0.26P
+ AD=0.15835P PS=2.52U PD=1.395U
* device instance $428 r0 *1 0,0 pfet
M$428 \$0$278 RESET_B\x7cRST_B VPB\x7cVPWR VPB\x7cVPWR pfet L=0.15U W=0.42U
+ AS=0.07035P AD=0.1092P PS=0.755U PD=1.36U
* device instance $429 r0 *1 0,0 pfet
M$429 \$0$279 RESET_B\x7cRST_B VPB\x7cVPWR VPB\x7cVPWR pfet L=0.15U W=0.42U
+ AS=0.07035P AD=0.1092P PS=0.755U PD=1.36U
* device instance $430 r0 *1 0,0 pfet
M$430 \$0$280 RESET_B\x7cRST_B VPB\x7cVPWR VPB\x7cVPWR pfet L=0.15U W=0.42U
+ AS=0.07035P AD=0.1092P PS=0.755U PD=1.36U
* device instance $431 r0 *1 0,0 pfet
M$431 \$0$281 RESET_B\x7cRST_B VPB\x7cVPWR VPB\x7cVPWR pfet L=0.15U W=0.42U
+ AS=0.07035P AD=0.1092P PS=0.755U PD=1.36U
* device instance $432 r0 *1 0,0 pfet
M$432 \$0$283 \$0$10 \$0$38 VPB\x7cVPWR pfet L=0.15U W=0.42U AS=0.07245P
+ AD=0.1155P PS=0.765U PD=0.97U
* device instance $433 r0 *1 0,0 pfet
M$433 \$0$284 \$0$11 \$0$39 VPB\x7cVPWR pfet L=0.15U W=0.42U AS=0.07245P
+ AD=0.1155P PS=0.765U PD=0.97U
* device instance $434 r0 *1 0,0 pfet
M$434 VPB\x7cVPWR \$0$44 D\x7cX VPB\x7cVPWR pfet L=0.15U W=1U AS=0.26P
+ AD=0.15835P PS=2.52U PD=1.395U
* device instance $435 r0 *1 0,0 pfet
M$435 VPB\x7cVPWR \$0$45 D\x7cX_2 VPB\x7cVPWR pfet L=0.15U W=1U AS=0.26P
+ AD=0.15835P PS=2.52U PD=1.395U
* device instance $436 r0 *1 0,0 pfet
M$436 \$0$285 B\x7cD\x7cPH_B4\x7cQ\x7cS VPB\x7cVPWR VPB\x7cVPWR pfet L=0.15U
+ W=0.42U AS=0.15835P AD=0.07665P PS=1.395U PD=0.785U
* device instance $437 r0 *1 0,0 pfet
M$437 VPB\x7cVPWR \$0$47 \$0$282 VPB\x7cVPWR pfet L=0.15U W=0.42U AS=0.1155P
+ AD=0.07035P PS=0.97U PD=0.755U
* device instance $438 r0 *1 0,0 pfet
M$438 \$0$286 A\x7cD\x7cPH_B5\x7cQ\x7cS VPB\x7cVPWR VPB\x7cVPWR pfet L=0.15U
+ W=0.42U AS=0.15835P AD=0.07665P PS=1.395U PD=0.785U
* device instance $439 r0 *1 0,0 pfet
M$439 \$0$287 C\x7cD\x7cPH_B3\x7cQ\x7cS VPB\x7cVPWR VPB\x7cVPWR pfet L=0.15U
+ W=0.42U AS=0.15835P AD=0.07665P PS=1.395U PD=0.785U
* device instance $440 r0 *1 0,0 pfet
M$440 \$0$41 A\x7cA0\x7cB\x7cDOUT4\x7cQ \$0$285 VPB\x7cVPWR pfet L=0.15U
+ W=0.42U AS=0.07665P AD=0.1932P PS=0.785U PD=1.34U
* device instance $441 r0 *1 0,0 pfet
M$441 VPB\x7cVPWR \$0$51 \$0$283 VPB\x7cVPWR pfet L=0.15U W=0.42U AS=0.1155P
+ AD=0.07035P PS=0.97U PD=0.755U
* device instance $442 r0 *1 0,0 pfet
M$442 VPB\x7cVPWR \$0$53 \$0$284 VPB\x7cVPWR pfet L=0.15U W=0.42U AS=0.1155P
+ AD=0.07035P PS=0.97U PD=0.755U
* device instance $443 r0 *1 0,0 pfet
M$443 \$0$282 RESET_B\x7cRST_B VPB\x7cVPWR VPB\x7cVPWR pfet L=0.15U W=0.42U
+ AS=0.07035P AD=0.1092P PS=0.755U PD=1.36U
* device instance $444 r0 *1 0,0 pfet
M$444 \$0$30 \$0$18 VPB\x7cVPWR VPB\x7cVPWR pfet L=0.15U W=0.84U AS=0.2184P
+ AD=0.12915P PS=2.2U PD=1.185U
* device instance $445 r0 *1 0,0 pfet
M$445 \$0$32 \$0$19 VPB\x7cVPWR VPB\x7cVPWR pfet L=0.15U W=0.84U AS=0.2184P
+ AD=0.12915P PS=2.2U PD=1.185U
* device instance $446 r0 *1 0,0 pfet
M$446 \$0$34 \$0$20 VPB\x7cVPWR VPB\x7cVPWR pfet L=0.15U W=0.84U AS=0.2184P
+ AD=0.12915P PS=2.2U PD=1.185U
* device instance $447 r0 *1 0,0 pfet
M$447 \$0$36 \$0$21 VPB\x7cVPWR VPB\x7cVPWR pfet L=0.15U W=0.84U AS=0.2184P
+ AD=0.12915P PS=2.2U PD=1.185U
* device instance $448 r0 *1 0,0 pfet
M$448 VPB\x7cVPWR \$0$59 D\x7cX_4 VPB\x7cVPWR pfet L=0.15U W=1U AS=0.26P
+ AD=0.15835P PS=2.52U PD=1.395U
* device instance $449 r0 *1 0,0 pfet
M$449 \$0$44 A\x7cA0\x7cB\x7cDOUT5\x7cQ \$0$286 VPB\x7cVPWR pfet L=0.15U
+ W=0.42U AS=0.07665P AD=0.1932P PS=0.785U PD=1.34U
* device instance $450 r0 *1 0,0 pfet
M$450 \$0$45 A\x7cA0\x7cB\x7cDOUT3\x7cQ \$0$287 VPB\x7cVPWR pfet L=0.15U
+ W=0.42U AS=0.07665P AD=0.1932P PS=0.785U PD=1.34U
* device instance $451 r0 *1 0,0 pfet
M$451 \$0$283 RESET_B\x7cRST_B VPB\x7cVPWR VPB\x7cVPWR pfet L=0.15U W=0.42U
+ AS=0.07035P AD=0.1092P PS=0.755U PD=1.36U
* device instance $452 r0 *1 0,0 pfet
M$452 \$0$284 RESET_B\x7cRST_B VPB\x7cVPWR VPB\x7cVPWR pfet L=0.15U W=0.42U
+ AS=0.07035P AD=0.1092P PS=0.755U PD=1.36U
* device instance $453 r0 *1 0,0 pfet
M$453 \$0$55 \$0 \$0$30 VPB\x7cVPWR pfet L=0.15U W=0.42U AS=0.12915P AD=0.0588P
+ PS=1.185U PD=0.7U
* device instance $454 r0 *1 0,0 pfet
M$454 \$0$56 \$0$1 \$0$32 VPB\x7cVPWR pfet L=0.15U W=0.42U AS=0.12915P
+ AD=0.0588P PS=1.185U PD=0.7U
* device instance $455 r0 *1 0,0 pfet
M$455 \$0$57 \$0$2 \$0$34 VPB\x7cVPWR pfet L=0.15U W=0.42U AS=0.12915P
+ AD=0.0588P PS=1.185U PD=0.7U
* device instance $456 r0 *1 0,0 pfet
M$456 \$0$58 \$0$3 \$0$36 VPB\x7cVPWR pfet L=0.15U W=0.42U AS=0.12915P
+ AD=0.0588P PS=1.185U PD=0.7U
* device instance $457 r0 *1 0,0 pfet
M$457 \$0$288 D\x7cPH_B2\x7cQ\x7cS VPB\x7cVPWR VPB\x7cVPWR pfet L=0.15U W=0.42U
+ AS=0.15835P AD=0.07665P PS=1.395U PD=0.785U
* device instance $458 r0 *1 0,0 pfet
M$458 \$0$47 \$0$29 VPB\x7cVPWR VPB\x7cVPWR pfet L=0.15U W=0.84U AS=0.2184P
+ AD=0.12915P PS=2.2U PD=1.185U
* device instance $459 r0 *1 0,0 pfet
M$459 \$0$289 \$0$4 \$0$55 VPB\x7cVPWR pfet L=0.15U W=0.42U AS=0.0588P
+ AD=0.0567P PS=0.7U PD=0.69U
* device instance $460 r0 *1 0,0 pfet
M$460 \$0$290 \$0$5 \$0$56 VPB\x7cVPWR pfet L=0.15U W=0.42U AS=0.0588P
+ AD=0.0567P PS=0.7U PD=0.69U
* device instance $461 r0 *1 0,0 pfet
M$461 \$0$291 \$0$6 \$0$57 VPB\x7cVPWR pfet L=0.15U W=0.42U AS=0.0588P
+ AD=0.0567P PS=0.7U PD=0.69U
* device instance $462 r0 *1 0,0 pfet
M$462 \$0$292 \$0$7 \$0$58 VPB\x7cVPWR pfet L=0.15U W=0.42U AS=0.0588P
+ AD=0.0567P PS=0.7U PD=0.69U
* device instance $463 r0 *1 0,0 pfet
M$463 \$0$293 A1\x7cCOMP_OUT\x7cOUTP \$0$41 VPB\x7cVPWR pfet L=0.15U W=0.42U
+ AS=0.1932P AD=0.0441P PS=1.34U PD=0.63U
* device instance $464 r0 *1 0,0 pfet
M$464 \$0$59 A\x7cA0\x7cB\x7cDOUT2\x7cQ \$0$288 VPB\x7cVPWR pfet L=0.15U
+ W=0.42U AS=0.07665P AD=0.1932P PS=0.785U PD=1.34U
* device instance $465 r0 *1 0,0 pfet
M$465 VPB\x7cVPWR \$0$68 \$0$293 VPB\x7cVPWR pfet L=0.15U W=0.42U AS=0.0441P
+ AD=0.0693P PS=0.63U PD=0.75U
* device instance $466 r0 *1 0,0 pfet
M$466 VPB\x7cVPWR \$0$70 \$0$289 VPB\x7cVPWR pfet L=0.15U W=0.42U AS=0.0567P
+ AD=0.0819P PS=0.69U PD=0.81U
* device instance $467 r0 *1 0,0 pfet
M$467 VPB\x7cVPWR \$0$71 \$0$290 VPB\x7cVPWR pfet L=0.15U W=0.42U AS=0.0567P
+ AD=0.0819P PS=0.69U PD=0.81U
* device instance $468 r0 *1 0,0 pfet
M$468 VPB\x7cVPWR \$0$72 \$0$291 VPB\x7cVPWR pfet L=0.15U W=0.42U AS=0.0567P
+ AD=0.0819P PS=0.69U PD=0.81U
* device instance $469 r0 *1 0,0 pfet
M$469 VPB\x7cVPWR \$0$73 \$0$292 VPB\x7cVPWR pfet L=0.15U W=0.42U AS=0.0567P
+ AD=0.0819P PS=0.69U PD=0.81U
* device instance $470 r0 *1 0,0 pfet
M$470 \$0$51 \$0$38 VPB\x7cVPWR VPB\x7cVPWR pfet L=0.15U W=0.84U AS=0.2184P
+ AD=0.12915P PS=2.2U PD=1.185U
* device instance $471 r0 *1 0,0 pfet
M$471 \$0$53 \$0$39 VPB\x7cVPWR VPB\x7cVPWR pfet L=0.15U W=0.84U AS=0.2184P
+ AD=0.12915P PS=2.2U PD=1.185U
* device instance $472 r0 *1 0,0 pfet
M$472 \$0$294 A1\x7cCOMP_OUT\x7cOUTP \$0$44 VPB\x7cVPWR pfet L=0.15U W=0.42U
+ AS=0.1932P AD=0.0441P PS=1.34U PD=0.63U
* device instance $473 r0 *1 0,0 pfet
M$473 \$0$295 A1\x7cCOMP_OUT\x7cOUTP \$0$45 VPB\x7cVPWR pfet L=0.15U W=0.42U
+ AS=0.1932P AD=0.0441P PS=1.34U PD=0.63U
* device instance $474 r0 *1 0,0 pfet
M$474 \$0$69 \$0$8 \$0$47 VPB\x7cVPWR pfet L=0.15U W=0.42U AS=0.12915P
+ AD=0.0588P PS=1.185U PD=0.7U
* device instance $475 r0 *1 0,0 pfet
M$475 VPB\x7cVPWR \$0$74 \$0$294 VPB\x7cVPWR pfet L=0.15U W=0.42U AS=0.0441P
+ AD=0.0693P PS=0.63U PD=0.75U
* device instance $476 r0 *1 0,0 pfet
M$476 VPB\x7cVPWR \$0$75 \$0$295 VPB\x7cVPWR pfet L=0.15U W=0.42U AS=0.0441P
+ AD=0.0693P PS=0.63U PD=0.75U
* device instance $477 r0 *1 0,0 pfet
M$477 \$0$68 B\x7cD\x7cPH_B4\x7cQ\x7cS VPB\x7cVPWR VPB\x7cVPWR pfet L=0.15U
+ W=0.42U AS=0.0693P AD=0.1176P PS=0.75U PD=1.4U
* device instance $478 r0 *1 0,0 pfet
M$478 \$0$296 \$0$9 \$0$69 VPB\x7cVPWR pfet L=0.15U W=0.42U AS=0.0588P
+ AD=0.0567P PS=0.7U PD=0.69U
* device instance $479 r0 *1 0,0 pfet
M$479 \$0$76 \$0$10 \$0$51 VPB\x7cVPWR pfet L=0.15U W=0.42U AS=0.12915P
+ AD=0.0588P PS=1.185U PD=0.7U
* device instance $480 r0 *1 0,0 pfet
M$480 \$0$77 \$0$11 \$0$53 VPB\x7cVPWR pfet L=0.15U W=0.42U AS=0.12915P
+ AD=0.0588P PS=1.185U PD=0.7U
* device instance $481 r0 *1 0,0 pfet
M$481 \$0$70 RESET_B\x7cRST_B VPB\x7cVPWR VPB\x7cVPWR pfet L=0.15U W=0.42U
+ AS=0.0819P AD=0.0567P PS=0.81U PD=0.69U
* device instance $482 r0 *1 0,0 pfet
M$482 \$0$71 RESET_B\x7cRST_B VPB\x7cVPWR VPB\x7cVPWR pfet L=0.15U W=0.42U
+ AS=0.0819P AD=0.0567P PS=0.81U PD=0.69U
* device instance $483 r0 *1 0,0 pfet
M$483 \$0$72 RESET_B\x7cRST_B VPB\x7cVPWR VPB\x7cVPWR pfet L=0.15U W=0.42U
+ AS=0.0819P AD=0.0567P PS=0.81U PD=0.69U
* device instance $484 r0 *1 0,0 pfet
M$484 \$0$73 RESET_B\x7cRST_B VPB\x7cVPWR VPB\x7cVPWR pfet L=0.15U W=0.42U
+ AS=0.0819P AD=0.0567P PS=0.81U PD=0.69U
* device instance $485 r0 *1 0,0 pfet
M$485 VPB\x7cVPWR A\x7cCLK\x7cX \$0$84 VPB\x7cVPWR pfet L=0.15U W=0.64U
+ AS=0.1664P AD=0.0864P PS=1.8U PD=0.91U
* device instance $486 r0 *1 0,0 pfet
M$486 \$0$74 A\x7cD\x7cPH_B5\x7cQ\x7cS VPB\x7cVPWR VPB\x7cVPWR pfet L=0.15U
+ W=0.42U AS=0.0693P AD=0.1176P PS=0.75U PD=1.4U
* device instance $487 r0 *1 0,0 pfet
M$487 \$0$75 C\x7cD\x7cPH_B3\x7cQ\x7cS VPB\x7cVPWR VPB\x7cVPWR pfet L=0.15U
+ W=0.42U AS=0.0693P AD=0.1176P PS=0.75U PD=1.4U
* device instance $488 r0 *1 0,0 pfet
M$488 VPB\x7cVPWR \$0$87 \$0$296 VPB\x7cVPWR pfet L=0.15U W=0.42U AS=0.0567P
+ AD=0.0819P PS=0.69U PD=0.81U
* device instance $489 r0 *1 0,0 pfet
M$489 VPB\x7cVPWR \$0$55 \$0$70 VPB\x7cVPWR pfet L=0.15U W=0.42U AS=0.0567P
+ AD=0.1134P PS=0.69U PD=1.38U
* device instance $490 r0 *1 0,0 pfet
M$490 \$0$297 \$0$16 \$0$76 VPB\x7cVPWR pfet L=0.15U W=0.42U AS=0.0588P
+ AD=0.0567P PS=0.7U PD=0.69U
* device instance $491 r0 *1 0,0 pfet
M$491 \$0$298 \$0$17 \$0$77 VPB\x7cVPWR pfet L=0.15U W=0.42U AS=0.0588P
+ AD=0.0567P PS=0.7U PD=0.69U
* device instance $492 r0 *1 0,0 pfet
M$492 VPB\x7cVPWR \$0$56 \$0$71 VPB\x7cVPWR pfet L=0.15U W=0.42U AS=0.0567P
+ AD=0.1134P PS=0.69U PD=1.38U
* device instance $493 r0 *1 0,0 pfet
M$493 VPB\x7cVPWR \$0$57 \$0$72 VPB\x7cVPWR pfet L=0.15U W=0.42U AS=0.0567P
+ AD=0.1134P PS=0.69U PD=1.38U
* device instance $494 r0 *1 0,0 pfet
M$494 VPB\x7cVPWR \$0$58 \$0$73 VPB\x7cVPWR pfet L=0.15U W=0.42U AS=0.0567P
+ AD=0.1134P PS=0.69U PD=1.38U
* device instance $495 r0 *1 0,0 pfet
M$495 \$0$299 A1\x7cCOMP_OUT\x7cOUTP \$0$59 VPB\x7cVPWR pfet L=0.15U W=0.42U
+ AS=0.1932P AD=0.0441P PS=1.34U PD=0.63U
* device instance $496 r0 *1 0,0 pfet
M$496 \$0$89 \$0$84 VPB\x7cVPWR VPB\x7cVPWR pfet L=0.15U W=0.64U AS=0.0864P
+ AD=0.1664P PS=0.91U PD=1.8U
* device instance $497 r0 *1 0,0 pfet
M$497 VPB\x7cVPWR \$0$88 \$0$299 VPB\x7cVPWR pfet L=0.15U W=0.42U AS=0.0441P
+ AD=0.0693P PS=0.63U PD=0.75U
* device instance $498 r0 *1 0,0 pfet
M$498 VPB\x7cVPWR \$0$90 \$0$297 VPB\x7cVPWR pfet L=0.15U W=0.42U AS=0.0567P
+ AD=0.0819P PS=0.69U PD=0.81U
* device instance $499 r0 *1 0,0 pfet
M$499 VPB\x7cVPWR \$0$91 \$0$298 VPB\x7cVPWR pfet L=0.15U W=0.42U AS=0.0567P
+ AD=0.0819P PS=0.69U PD=0.81U
* device instance $500 r0 *1 0,0 pfet
M$500 \$0$87 RESET_B\x7cRST_B VPB\x7cVPWR VPB\x7cVPWR pfet L=0.15U W=0.42U
+ AS=0.0819P AD=0.0567P PS=0.81U PD=0.69U
* device instance $501 r0 *1 0,0 pfet
M$501 VPB\x7cVPWR CLK\x7cX \$0$93 VPB\x7cVPWR pfet L=0.15U W=0.64U AS=0.1664P
+ AD=0.0864P PS=1.8U PD=0.91U
* device instance $502 r0 *1 0,0 pfet
M$502 \$0$88 D\x7cPH_B2\x7cQ\x7cS VPB\x7cVPWR VPB\x7cVPWR pfet L=0.15U W=0.42U
+ AS=0.0693P AD=0.1176P PS=0.75U PD=1.4U
* device instance $503 r0 *1 0,0 pfet
M$503 VPB\x7cVPWR \$0$69 \$0$87 VPB\x7cVPWR pfet L=0.15U W=0.42U AS=0.0567P
+ AD=0.1134P PS=0.69U PD=1.38U
* device instance $504 r0 *1 0,0 pfet
M$504 \$0$90 RESET_B\x7cRST_B VPB\x7cVPWR VPB\x7cVPWR pfet L=0.15U W=0.42U
+ AS=0.0819P AD=0.0567P PS=0.81U PD=0.69U
* device instance $505 r0 *1 0,0 pfet
M$505 \$0$91 RESET_B\x7cRST_B VPB\x7cVPWR VPB\x7cVPWR pfet L=0.15U W=0.42U
+ AS=0.0819P AD=0.0567P PS=0.81U PD=0.69U
* device instance $506 r0 *1 0,0 pfet
M$506 \$0$96 \$0$93 VPB\x7cVPWR VPB\x7cVPWR pfet L=0.15U W=0.64U AS=0.0864P
+ AD=0.1664P PS=0.91U PD=1.8U
* device instance $507 r0 *1 0,0 pfet
M$507 A\x7cA0\x7cB\x7cDOUT5\x7cQ \$0$70 VPB\x7cVPWR VPB\x7cVPWR pfet L=0.15U
+ W=1U AS=0.3012P AD=0.26P PS=2.66U PD=2.52U
* device instance $508 r0 *1 0,0 pfet
M$508 C\x7cD\x7cPH_B3\x7cQ\x7cS \$0$71 VPB\x7cVPWR VPB\x7cVPWR pfet L=0.15U
+ W=1U AS=0.3012P AD=0.26P PS=2.66U PD=2.52U
* device instance $509 r0 *1 0,0 pfet
M$509 A\x7cA0\x7cB\x7cDOUT3\x7cQ \$0$72 VPB\x7cVPWR VPB\x7cVPWR pfet L=0.15U
+ W=1U AS=0.3012P AD=0.26P PS=2.66U PD=2.52U
* device instance $510 r0 *1 0,0 pfet
M$510 D\x7cPH_B2\x7cQ\x7cS \$0$73 VPB\x7cVPWR VPB\x7cVPWR pfet L=0.15U W=1U
+ AS=0.3012P AD=0.26P PS=2.66U PD=2.52U
* device instance $511 r0 *1 0,0 pfet
M$511 VPB\x7cVPWR \$0$76 \$0$90 VPB\x7cVPWR pfet L=0.15U W=0.42U AS=0.0567P
+ AD=0.1134P PS=0.69U PD=1.38U
* device instance $512 r0 *1 0,0 pfet
M$512 VPB\x7cVPWR \$0$77 \$0$91 VPB\x7cVPWR pfet L=0.15U W=0.42U AS=0.0567P
+ AD=0.1134P PS=0.69U PD=1.38U
* device instance $513 r0 *1 0,0 pfet
M$513 \$0$97 D\x7cX_5 VPB\x7cVPWR VPB\x7cVPWR pfet L=0.15U W=0.42U AS=0.1092P
+ AD=0.0651P PS=1.36U PD=0.73U
* device instance $514 r0 *1 0,0 pfet
M$514 \$0$98 \$0$89 \$0$97 VPB\x7cVPWR pfet L=0.15U W=0.42U AS=0.0651P
+ AD=0.07245P PS=0.73U PD=0.765U
* device instance $515 r0 *1 0,0 pfet
M$515 A\x7cA0\x7cB\x7cDOUT4\x7cQ \$0$87 VPB\x7cVPWR VPB\x7cVPWR pfet L=0.15U
+ W=1U AS=0.3012P AD=0.26P PS=2.66U PD=2.52U
* device instance $516 r0 *1 0,0 pfet
M$516 \$0$99 D\x7cPH_B2\x7cQ\x7cS VPB\x7cVPWR VPB\x7cVPWR pfet L=0.15U W=0.42U
+ AS=0.1092P AD=0.0651P PS=1.36U PD=0.73U
* device instance $517 r0 *1 0,0 pfet
M$517 \$0$300 \$0$84 \$0$98 VPB\x7cVPWR pfet L=0.15U W=0.42U AS=0.07245P
+ AD=0.1155P PS=0.765U PD=0.97U
* device instance $518 r0 *1 0,0 pfet
M$518 A\x7cA0\x7cB\x7cDOUT2\x7cQ \$0$90 VPB\x7cVPWR VPB\x7cVPWR pfet L=0.15U
+ W=1U AS=0.3012P AD=0.26P PS=2.66U PD=2.52U
* device instance $519 r0 *1 0,0 pfet
M$519 B\x7cD\x7cPH_B4\x7cQ\x7cS \$0$91 VPB\x7cVPWR VPB\x7cVPWR pfet L=0.15U
+ W=1U AS=0.3012P AD=0.26P PS=2.66U PD=2.52U
* device instance $520 r0 *1 0,0 pfet
M$520 \$0$101 \$0$96 \$0$99 VPB\x7cVPWR pfet L=0.15U W=0.42U AS=0.0651P
+ AD=0.07245P PS=0.73U PD=0.765U
* device instance $521 r0 *1 0,0 pfet
M$521 VPB\x7cVPWR A\x7cX \$0$102 VPB\x7cVPWR pfet L=0.15U W=1U AS=0.26P
+ AD=0.135P PS=2.52U PD=1.27U
* device instance $522 r0 *1 0,0 pfet
M$522 VPB\x7cVPWR \$0$103 \$0$300 VPB\x7cVPWR pfet L=0.15U W=0.42U AS=0.1155P
+ AD=0.07035P PS=0.97U PD=0.755U
* device instance $523 r0 *1 0,0 pfet
M$523 \$0$301 \$0$93 \$0$101 VPB\x7cVPWR pfet L=0.15U W=0.42U AS=0.07245P
+ AD=0.1155P PS=0.765U PD=0.97U
* device instance $524 r0 *1 0,0 pfet
M$524 CLK\x7cX \$0$102 VPB\x7cVPWR VPB\x7cVPWR pfet L=0.15U W=1U AS=0.135P
+ AD=0.135P PS=1.27U PD=1.27U
* device instance $525 r0 *1 0,0 pfet
M$525 VPB\x7cVPWR \$0$106 D\x7cX_5 VPB\x7cVPWR pfet L=0.15U W=1U AS=0.26P
+ AD=0.15835P PS=2.52U PD=1.395U
* device instance $526 r0 *1 0,0 pfet
M$526 \$0$300 RESET_B\x7cRST_B VPB\x7cVPWR VPB\x7cVPWR pfet L=0.15U W=0.42U
+ AS=0.07035P AD=0.1092P PS=0.755U PD=1.36U
* device instance $527 r0 *1 0,0 pfet
M$527 VPB\x7cVPWR \$0$102 CLK\x7cX VPB\x7cVPWR pfet L=0.15U W=1U AS=0.135P
+ AD=0.135P PS=1.27U PD=1.27U
* device instance $528 r0 *1 0,0 pfet
M$528 \$0$302 D\x7cPH_B6\x7cQ\x7cS VPB\x7cVPWR VPB\x7cVPWR pfet L=0.15U W=0.42U
+ AS=0.15835P AD=0.07665P PS=1.395U PD=0.785U
* device instance $529 r0 *1 0,0 pfet
M$529 VPB\x7cVPWR \$0$108 \$0$301 VPB\x7cVPWR pfet L=0.15U W=0.42U AS=0.1155P
+ AD=0.07035P PS=0.97U PD=0.755U
* device instance $530 r0 *1 0,0 pfet
M$530 CLK\x7cX \$0$102 VPB\x7cVPWR VPB\x7cVPWR pfet L=0.15U W=1U AS=0.135P
+ AD=0.135P PS=1.27U PD=1.27U
* device instance $531 r0 *1 0,0 pfet
M$531 \$0$106 A\x7cA0\x7cB\x7cDOUT6\x7cQ \$0$302 VPB\x7cVPWR pfet L=0.15U
+ W=0.42U AS=0.07665P AD=0.1932P PS=0.785U PD=1.34U
* device instance $532 r0 *1 0,0 pfet
M$532 \$0$301 RESET_B\x7cRST_B VPB\x7cVPWR VPB\x7cVPWR pfet L=0.15U W=0.42U
+ AS=0.07035P AD=0.1092P PS=0.755U PD=1.36U
* device instance $533 r0 *1 0,0 pfet
M$533 \$0$103 \$0$98 VPB\x7cVPWR VPB\x7cVPWR pfet L=0.15U W=0.84U AS=0.2184P
+ AD=0.12915P PS=2.2U PD=1.185U
* device instance $534 r0 *1 0,0 pfet
M$534 VPB\x7cVPWR \$0$102 CLK\x7cX VPB\x7cVPWR pfet L=0.15U W=1U AS=0.135P
+ AD=0.26P PS=1.27U PD=2.52U
* device instance $535 r0 *1 0,0 pfet
M$535 VPB\x7cVPWR A\x7cCLK\x7cX \$0$111 VPB\x7cVPWR pfet L=0.15U W=0.64U
+ AS=0.1664P AD=0.0864P PS=1.8U PD=0.91U
* device instance $536 r0 *1 0,0 pfet
M$536 VPB\x7cVPWR A\x7cCLK \$0$112 VPB\x7cVPWR pfet L=0.15U W=1U AS=0.26P
+ AD=0.135P PS=2.52U PD=1.27U
* device instance $537 r0 *1 0,0 pfet
M$537 \$0$110 \$0$84 \$0$103 VPB\x7cVPWR pfet L=0.15U W=0.42U AS=0.12915P
+ AD=0.0588P PS=1.185U PD=0.7U
* device instance $538 r0 *1 0,0 pfet
M$538 \$0$114 \$0$111 VPB\x7cVPWR VPB\x7cVPWR pfet L=0.15U W=0.64U AS=0.0864P
+ AD=0.1664P PS=0.91U PD=1.8U
* device instance $539 r0 *1 0,0 pfet
M$539 A\x7cX \$0$112 VPB\x7cVPWR VPB\x7cVPWR pfet L=0.15U W=1U AS=0.135P
+ AD=0.135P PS=1.27U PD=1.27U
* device instance $540 r0 *1 0,0 pfet
M$540 \$0$108 \$0$101 VPB\x7cVPWR VPB\x7cVPWR pfet L=0.15U W=0.84U AS=0.2184P
+ AD=0.12915P PS=2.2U PD=1.185U
* device instance $541 r0 *1 0,0 pfet
M$541 \$0$303 \$0$89 \$0$110 VPB\x7cVPWR pfet L=0.15U W=0.42U AS=0.0588P
+ AD=0.0567P PS=0.7U PD=0.69U
* device instance $542 r0 *1 0,0 pfet
M$542 \$0$304 A1\x7cCOMP_OUT\x7cOUTP \$0$106 VPB\x7cVPWR pfet L=0.15U W=0.42U
+ AS=0.1932P AD=0.0441P PS=1.34U PD=0.63U
* device instance $543 r0 *1 0,0 pfet
M$543 VPB\x7cVPWR \$0$112 A\x7cX VPB\x7cVPWR pfet L=0.15U W=1U AS=0.135P
+ AD=0.135P PS=1.27U PD=1.27U
* device instance $544 r0 *1 0,0 pfet
M$544 VPB\x7cVPWR \$0$116 \$0$304 VPB\x7cVPWR pfet L=0.15U W=0.42U AS=0.0441P
+ AD=0.0693P PS=0.63U PD=0.75U
* device instance $545 r0 *1 0,0 pfet
M$545 VPB\x7cVPWR \$0$118 \$0$303 VPB\x7cVPWR pfet L=0.15U W=0.42U AS=0.0567P
+ AD=0.0819P PS=0.69U PD=0.81U
* device instance $546 r0 *1 0,0 pfet
M$546 \$0$117 \$0$93 \$0$108 VPB\x7cVPWR pfet L=0.15U W=0.42U AS=0.12915P
+ AD=0.0588P PS=1.185U PD=0.7U
* device instance $547 r0 *1 0,0 pfet
M$547 A\x7cX \$0$112 VPB\x7cVPWR VPB\x7cVPWR pfet L=0.15U W=1U AS=0.135P
+ AD=0.135P PS=1.27U PD=1.27U
* device instance $548 r0 *1 0,0 pfet
M$548 \$0$116 D\x7cPH_B6\x7cQ\x7cS VPB\x7cVPWR VPB\x7cVPWR pfet L=0.15U W=0.42U
+ AS=0.0693P AD=0.1176P PS=0.75U PD=1.4U
* device instance $549 r0 *1 0,0 pfet
M$549 \$0$305 \$0$96 \$0$117 VPB\x7cVPWR pfet L=0.15U W=0.42U AS=0.0588P
+ AD=0.0567P PS=0.7U PD=0.69U
* device instance $550 r0 *1 0,0 pfet
M$550 VPB\x7cVPWR \$0$112 A\x7cX VPB\x7cVPWR pfet L=0.15U W=1U AS=0.135P
+ AD=0.26P PS=1.27U PD=2.52U
* device instance $551 r0 *1 0,0 pfet
M$551 \$0$118 RESET_B\x7cRST_B VPB\x7cVPWR VPB\x7cVPWR pfet L=0.15U W=0.42U
+ AS=0.0819P AD=0.0567P PS=0.81U PD=0.69U
* device instance $552 r0 *1 0,0 pfet
M$552 \$0$120 D\x7cPH_B6\x7cQ\x7cS VPB\x7cVPWR VPB\x7cVPWR pfet L=0.15U W=0.42U
+ AS=0.1092P AD=0.0651P PS=1.36U PD=0.73U
* device instance $553 r0 *1 0,0 pfet
M$553 VPB\x7cVPWR CLK\x7cX \$0$122 VPB\x7cVPWR pfet L=0.15U W=0.64U AS=0.1664P
+ AD=0.0864P PS=1.8U PD=0.91U
* device instance $554 r0 *1 0,0 pfet
M$554 VPB\x7cVPWR \$0$123 \$0$305 VPB\x7cVPWR pfet L=0.15U W=0.42U AS=0.0567P
+ AD=0.0819P PS=0.69U PD=0.81U
* device instance $555 r0 *1 0,0 pfet
M$555 VPB\x7cVPWR \$0$110 \$0$118 VPB\x7cVPWR pfet L=0.15U W=0.42U AS=0.0567P
+ AD=0.1134P PS=0.69U PD=1.38U
* device instance $556 r0 *1 0,0 pfet
M$556 \$0$124 \$0$114 \$0$120 VPB\x7cVPWR pfet L=0.15U W=0.42U AS=0.0651P
+ AD=0.07245P PS=0.73U PD=0.765U
* device instance $557 r0 *1 0,0 pfet
M$557 \$0$125 \$0$122 VPB\x7cVPWR VPB\x7cVPWR pfet L=0.15U W=0.64U AS=0.0864P
+ AD=0.1664P PS=0.91U PD=1.8U
* device instance $558 r0 *1 0,0 pfet
M$558 \$0$123 RESET_B\x7cRST_B VPB\x7cVPWR VPB\x7cVPWR pfet L=0.15U W=0.42U
+ AS=0.0819P AD=0.0567P PS=0.81U PD=0.69U
* device instance $559 r0 *1 0,0 pfet
M$559 \$0$306 \$0$111 \$0$124 VPB\x7cVPWR pfet L=0.15U W=0.42U AS=0.07245P
+ AD=0.1155P PS=0.765U PD=0.97U
* device instance $560 r0 *1 0,0 pfet
M$560 VPB\x7cVPWR \$0$117 \$0$123 VPB\x7cVPWR pfet L=0.15U W=0.42U AS=0.0567P
+ AD=0.1134P PS=0.69U PD=1.38U
* device instance $561 r0 *1 0,0 pfet
M$561 A\x7cA0\x7cB\x7cDOUT6\x7cQ \$0$118 VPB\x7cVPWR VPB\x7cVPWR pfet L=0.15U
+ W=1U AS=0.3012P AD=0.26P PS=2.66U PD=2.52U
* device instance $562 r0 *1 0,0 pfet
M$562 VPB\x7cVPWR \$0$128 \$0$306 VPB\x7cVPWR pfet L=0.15U W=0.42U AS=0.1155P
+ AD=0.07035P PS=0.97U PD=0.755U
* device instance $563 r0 *1 0,0 pfet
M$563 \$0$130 A\x7cD\x7cPH_B1\x7cQ\x7cS VPB\x7cVPWR VPB\x7cVPWR pfet L=0.15U
+ W=0.42U AS=0.1092P AD=0.0651P PS=1.36U PD=0.73U
* device instance $564 r0 *1 0,0 pfet
M$564 \$0$306 RESET_B\x7cRST_B VPB\x7cVPWR VPB\x7cVPWR pfet L=0.15U W=0.42U
+ AS=0.07035P AD=0.1092P PS=0.755U PD=1.36U
* device instance $565 r0 *1 0,0 pfet
M$565 \$0$131 \$0$125 \$0$130 VPB\x7cVPWR pfet L=0.15U W=0.42U AS=0.0651P
+ AD=0.07245P PS=0.73U PD=0.765U
* device instance $566 r0 *1 0,0 pfet
M$566 A\x7cD\x7cPH_B1\x7cQ\x7cS \$0$123 VPB\x7cVPWR VPB\x7cVPWR pfet L=0.15U
+ W=1U AS=0.3012P AD=0.26P PS=2.66U PD=2.52U
* device instance $567 r0 *1 0,0 pfet
M$567 VPB\x7cVPWR A\x7cX \$0$132 VPB\x7cVPWR pfet L=0.15U W=1U AS=0.26P
+ AD=0.135P PS=2.52U PD=1.27U
* device instance $568 r0 *1 0,0 pfet
M$568 Y A\x7cCLK\x7cX VPB\x7cVPWR VPB\x7cVPWR pfet L=0.15U W=1U AS=0.26P
+ AD=0.26P PS=2.52U PD=2.52U
* device instance $569 r0 *1 0,0 pfet
M$569 \$0$307 \$0$122 \$0$131 VPB\x7cVPWR pfet L=0.15U W=0.42U AS=0.07245P
+ AD=0.1155P PS=0.765U PD=0.97U
* device instance $570 r0 *1 0,0 pfet
M$570 A\x7cCLK\x7cX \$0$132 VPB\x7cVPWR VPB\x7cVPWR pfet L=0.15U W=1U AS=0.135P
+ AD=0.135P PS=1.27U PD=1.27U
* device instance $571 r0 *1 0,0 pfet
M$571 \$0$128 \$0$124 VPB\x7cVPWR VPB\x7cVPWR pfet L=0.15U W=0.84U AS=0.2184P
+ AD=0.12915P PS=2.2U PD=1.185U
* device instance $572 r0 *1 0,0 pfet
M$572 VPB\x7cVPWR \$0$132 A\x7cCLK\x7cX VPB\x7cVPWR pfet L=0.15U W=1U AS=0.135P
+ AD=0.135P PS=1.27U PD=1.27U
* device instance $573 r0 *1 0,0 pfet
M$573 VPB\x7cVPWR \$0$135 \$0$307 VPB\x7cVPWR pfet L=0.15U W=0.42U AS=0.1155P
+ AD=0.07035P PS=0.97U PD=0.755U
* device instance $574 r0 *1 0,0 pfet
M$574 \$0$134 \$0$111 \$0$128 VPB\x7cVPWR pfet L=0.15U W=0.42U AS=0.12915P
+ AD=0.0588P PS=1.185U PD=0.7U
* device instance $575 r0 *1 0,0 pfet
M$575 A\x7cCLK\x7cX \$0$132 VPB\x7cVPWR VPB\x7cVPWR pfet L=0.15U W=1U AS=0.135P
+ AD=0.135P PS=1.27U PD=1.27U
* device instance $576 r0 *1 0,0 pfet
M$576 \$0$307 RESET_B\x7cRST_B VPB\x7cVPWR VPB\x7cVPWR pfet L=0.15U W=0.42U
+ AS=0.07035P AD=0.1092P PS=0.755U PD=1.36U
* device instance $577 r0 *1 0,0 pfet
M$577 \$0$308 \$0$114 \$0$134 VPB\x7cVPWR pfet L=0.15U W=0.42U AS=0.0588P
+ AD=0.0567P PS=0.7U PD=0.69U
* device instance $578 r0 *1 0,0 pfet
M$578 VPB\x7cVPWR \$0$132 A\x7cCLK\x7cX VPB\x7cVPWR pfet L=0.15U W=1U AS=0.135P
+ AD=0.26P PS=1.27U PD=2.52U
* device instance $579 r0 *1 0,0 pfet
M$579 VPB\x7cVPWR \$0$138 \$0$308 VPB\x7cVPWR pfet L=0.15U W=0.42U AS=0.0567P
+ AD=0.0819P PS=0.69U PD=0.81U
* device instance $580 r0 *1 0,0 pfet
M$580 \$0$135 \$0$131 VPB\x7cVPWR VPB\x7cVPWR pfet L=0.15U W=0.84U AS=0.2184P
+ AD=0.12915P PS=2.2U PD=1.185U
* device instance $581 r0 *1 0,0 pfet
M$581 \$0$138 RESET_B\x7cRST_B VPB\x7cVPWR VPB\x7cVPWR pfet L=0.15U W=0.42U
+ AS=0.0819P AD=0.0567P PS=0.81U PD=0.69U
* device instance $582 r0 *1 0,0 pfet
M$582 VPB\x7cVPWR \$0$141 D\x7cX_6 VPB\x7cVPWR pfet L=0.15U W=1U AS=0.26P
+ AD=0.15835P PS=2.52U PD=1.395U
* device instance $583 r0 *1 0,0 pfet
M$583 VPB\x7cVPWR \$0$134 \$0$138 VPB\x7cVPWR pfet L=0.15U W=0.42U AS=0.0567P
+ AD=0.1134P PS=0.69U PD=1.38U
* device instance $584 r0 *1 0,0 pfet
M$584 \$0$140 \$0$122 \$0$135 VPB\x7cVPWR pfet L=0.15U W=0.42U AS=0.12915P
+ AD=0.0588P PS=1.185U PD=0.7U
* device instance $585 r0 *1 0,0 pfet
M$585 \$0$309 A\x7cD\x7cPH_B1\x7cQ\x7cS VPB\x7cVPWR VPB\x7cVPWR pfet L=0.15U
+ W=0.42U AS=0.15835P AD=0.07665P PS=1.395U PD=0.785U
* device instance $586 r0 *1 0,0 pfet
M$586 \$0$310 \$0$125 \$0$140 VPB\x7cVPWR pfet L=0.15U W=0.42U AS=0.0588P
+ AD=0.0567P PS=0.7U PD=0.69U
* device instance $587 r0 *1 0,0 pfet
M$587 \$0$141 A\x7cA0\x7cB\x7cDOUT1\x7cQ \$0$309 VPB\x7cVPWR pfet L=0.15U
+ W=0.42U AS=0.07665P AD=0.1932P PS=0.785U PD=1.34U
* device instance $588 r0 *1 0,0 pfet
M$588 VPB\x7cVPWR \$0$144 \$0$310 VPB\x7cVPWR pfet L=0.15U W=0.42U AS=0.0567P
+ AD=0.0819P PS=0.69U PD=0.81U
* device instance $589 r0 *1 0,0 pfet
M$589 A\x7cD\x7cPH_B5\x7cQ\x7cS \$0$138 VPB\x7cVPWR VPB\x7cVPWR pfet L=0.15U
+ W=1U AS=0.3012P AD=0.26P PS=2.66U PD=2.52U
* device instance $590 r0 *1 0,0 pfet
M$590 \$0$311 D\x7cPH_B6\x7cQ\x7cS \$0$145 VPB\x7cVPWR pfet L=0.15U W=0.42U
+ AS=0.1092P AD=0.0693P PS=1.36U PD=0.75U
* device instance $591 r0 *1 0,0 pfet
M$591 \$0$312 D\x7cPH_B2\x7cQ\x7cS \$0$146 VPB\x7cVPWR pfet L=0.15U W=0.42U
+ AS=0.1092P AD=0.0693P PS=1.36U PD=0.75U
* device instance $592 r0 *1 0,0 pfet
M$592 \$0$144 RESET_B\x7cRST_B VPB\x7cVPWR VPB\x7cVPWR pfet L=0.15U W=0.42U
+ AS=0.0819P AD=0.0567P PS=0.81U PD=0.69U
* device instance $593 r0 *1 0,0 pfet
M$593 VPB\x7cVPWR A\x7cCLK\x7cX \$0$149 VPB\x7cVPWR pfet L=0.15U W=0.64U
+ AS=0.1664P AD=0.0864P PS=1.8U PD=0.91U
* device instance $594 r0 *1 0,0 pfet
M$594 VPB\x7cVPWR CLK\x7cX \$0$150 VPB\x7cVPWR pfet L=0.15U W=0.64U AS=0.1664P
+ AD=0.0864P PS=1.8U PD=0.91U
* device instance $595 r0 *1 0,0 pfet
M$595 \$0$313 C\x7cD\x7cPH_B7\x7cQ\x7cS \$0$311 VPB\x7cVPWR pfet L=0.15U
+ W=0.42U AS=0.0693P AD=0.0441P PS=0.75U PD=0.63U
* device instance $596 r0 *1 0,0 pfet
M$596 \$0$314 C\x7cD\x7cPH_B3\x7cQ\x7cS \$0$312 VPB\x7cVPWR pfet L=0.15U
+ W=0.42U AS=0.0693P AD=0.0441P PS=0.75U PD=0.63U
* device instance $597 r0 *1 0,0 pfet
M$597 VPB\x7cVPWR \$0$140 \$0$144 VPB\x7cVPWR pfet L=0.15U W=0.42U AS=0.0567P
+ AD=0.1134P PS=0.69U PD=1.38U
* device instance $598 r0 *1 0,0 pfet
M$598 \$0$315 A1\x7cCOMP_OUT\x7cOUTP \$0$141 VPB\x7cVPWR pfet L=0.15U W=0.42U
+ AS=0.1932P AD=0.0441P PS=1.34U PD=0.63U
* device instance $599 r0 *1 0,0 pfet
M$599 \$0$316 B\x7cD\x7cPH_B8\x7cQ\x7cS \$0$313 VPB\x7cVPWR pfet L=0.15U
+ W=0.42U AS=0.0441P AD=0.0693P PS=0.63U PD=0.75U
* device instance $600 r0 *1 0,0 pfet
M$600 \$0$317 B\x7cD\x7cPH_B4\x7cQ\x7cS \$0$314 VPB\x7cVPWR pfet L=0.15U
+ W=0.42U AS=0.0441P AD=0.0693P PS=0.63U PD=0.75U
* device instance $601 r0 *1 0,0 pfet
M$601 \$0$152 \$0$149 VPB\x7cVPWR VPB\x7cVPWR pfet L=0.15U W=0.64U AS=0.0864P
+ AD=0.1664P PS=0.91U PD=1.8U
* device instance $602 r0 *1 0,0 pfet
M$602 \$0$153 \$0$150 VPB\x7cVPWR VPB\x7cVPWR pfet L=0.15U W=0.64U AS=0.0864P
+ AD=0.1664P PS=0.91U PD=1.8U
* device instance $603 r0 *1 0,0 pfet
M$603 VPB\x7cVPWR CLK\x7cX \$0$154 VPB\x7cVPWR pfet L=0.15U W=0.64U AS=0.1664P
+ AD=0.0864P PS=1.8U PD=0.91U
* device instance $604 r0 *1 0,0 pfet
M$604 VPB\x7cVPWR \$0$151 \$0$315 VPB\x7cVPWR pfet L=0.15U W=0.42U AS=0.0441P
+ AD=0.0693P PS=0.63U PD=0.75U
* device instance $605 r0 *1 0,0 pfet
M$605 \$0$316 A\x7cA_N\x7cD\x7cPH_B9\x7cQ\x7cS VPB\x7cVPWR VPB\x7cVPWR pfet
+ L=0.15U W=0.42U AS=0.14825P AD=0.0693P PS=1.34U PD=0.75U
* device instance $606 r0 *1 0,0 pfet
M$606 \$0$317 A\x7cD\x7cPH_B5\x7cQ\x7cS VPB\x7cVPWR VPB\x7cVPWR pfet L=0.15U
+ W=0.42U AS=0.14825P AD=0.0693P PS=1.34U PD=0.75U
* device instance $607 r0 *1 0,0 pfet
M$607 \$0$155 \$0$154 VPB\x7cVPWR VPB\x7cVPWR pfet L=0.15U W=0.64U AS=0.0864P
+ AD=0.1664P PS=0.91U PD=1.8U
* device instance $608 r0 *1 0,0 pfet
M$608 VPB\x7cVPWR A\x7cCLK\x7cX \$0$156 VPB\x7cVPWR pfet L=0.15U W=0.64U
+ AS=0.1664P AD=0.0864P PS=1.8U PD=0.91U
* device instance $609 r0 *1 0,0 pfet
M$609 \$0$151 A\x7cD\x7cPH_B1\x7cQ\x7cS VPB\x7cVPWR VPB\x7cVPWR pfet L=0.15U
+ W=0.42U AS=0.0693P AD=0.1176P PS=0.75U PD=1.4U
* device instance $610 r0 *1 0,0 pfet
M$610 \$0$157 \$0$156 VPB\x7cVPWR VPB\x7cVPWR pfet L=0.15U W=0.64U AS=0.0864P
+ AD=0.1664P PS=0.91U PD=1.8U
* device instance $611 r0 *1 0,0 pfet
M$611 A\x7cX_2 \$0$145 VPB\x7cVPWR VPB\x7cVPWR pfet L=0.15U W=1U AS=0.14825P
+ AD=0.27P PS=1.34U PD=2.54U
* device instance $612 r0 *1 0,0 pfet
M$612 B\x7cX \$0$146 VPB\x7cVPWR VPB\x7cVPWR pfet L=0.15U W=1U AS=0.14825P
+ AD=0.27P PS=1.34U PD=2.54U
* device instance $613 r0 *1 0,0 pfet
M$613 B\x7cD\x7cPH_B0\x7cQ\x7cS \$0$144 VPB\x7cVPWR VPB\x7cVPWR pfet L=0.15U
+ W=1U AS=0.3012P AD=0.26P PS=2.66U PD=2.52U
* device instance $614 r0 *1 0,0 pfet
M$614 VPB\x7cVPWR A\x7cCLK\x7cX \$0$158 VPB\x7cVPWR pfet L=0.15U W=0.64U
+ AS=0.1664P AD=0.0864P PS=1.8U PD=0.91U
* device instance $615 r0 *1 0,0 pfet
M$615 \$0$159 D\x7cX_7 VPB\x7cVPWR VPB\x7cVPWR pfet L=0.15U W=0.42U AS=0.1092P
+ AD=0.0651P PS=1.36U PD=0.73U
* device instance $616 r0 *1 0,0 pfet
M$616 \$0$160 D\x7cX_8 VPB\x7cVPWR VPB\x7cVPWR pfet L=0.15U W=0.42U AS=0.1092P
+ AD=0.0651P PS=1.36U PD=0.73U
* device instance $617 r0 *1 0,0 pfet
M$617 \$0$161 \$0$158 VPB\x7cVPWR VPB\x7cVPWR pfet L=0.15U W=0.64U AS=0.0864P
+ AD=0.1664P PS=0.91U PD=1.8U
* device instance $618 r0 *1 0,0 pfet
M$618 \$0$163 \$0$152 \$0$159 VPB\x7cVPWR pfet L=0.15U W=0.42U AS=0.0651P
+ AD=0.07245P PS=0.73U PD=0.765U
* device instance $619 r0 *1 0,0 pfet
M$619 \$0$164 \$0$153 \$0$160 VPB\x7cVPWR pfet L=0.15U W=0.42U AS=0.0651P
+ AD=0.07245P PS=0.73U PD=0.765U
* device instance $620 r0 *1 0,0 pfet
M$620 \$0$162 B\x7cD\x7cPH_B0\x7cQ\x7cS VPB\x7cVPWR VPB\x7cVPWR pfet L=0.15U
+ W=0.42U AS=0.1092P AD=0.0651P PS=1.36U PD=0.73U
* device instance $621 r0 *1 0,0 pfet
M$621 \$0$165 C\x7cD\x7cPH_B7\x7cQ\x7cS VPB\x7cVPWR VPB\x7cVPWR pfet L=0.15U
+ W=0.42U AS=0.1092P AD=0.0651P PS=1.36U PD=0.73U
* device instance $622 r0 *1 0,0 pfet
M$622 \$0$166 \$0$155 \$0$162 VPB\x7cVPWR pfet L=0.15U W=0.42U AS=0.0651P
+ AD=0.07245P PS=0.73U PD=0.765U
* device instance $623 r0 *1 0,0 pfet
M$623 \$0$318 \$0$149 \$0$163 VPB\x7cVPWR pfet L=0.15U W=0.42U AS=0.07245P
+ AD=0.1155P PS=0.765U PD=0.97U
* device instance $624 r0 *1 0,0 pfet
M$624 \$0$319 \$0$150 \$0$164 VPB\x7cVPWR pfet L=0.15U W=0.42U AS=0.07245P
+ AD=0.1155P PS=0.765U PD=0.97U
* device instance $625 r0 *1 0,0 pfet
M$625 VPB\x7cVPWR A\x7cCLK\x7cX \$0$169 VPB\x7cVPWR pfet L=0.15U W=0.64U
+ AS=0.1664P AD=0.0864P PS=1.8U PD=0.91U
* device instance $626 r0 *1 0,0 pfet
M$626 VPB\x7cVPWR A\x7cCLK\x7cX \$0$170 VPB\x7cVPWR pfet L=0.15U W=0.64U
+ AS=0.1664P AD=0.0864P PS=1.8U PD=0.91U
* device instance $627 r0 *1 0,0 pfet
M$627 VPB\x7cVPWR \$0$171 D\x7cX_7 VPB\x7cVPWR pfet L=0.15U W=1U AS=0.26P
+ AD=0.15835P PS=2.52U PD=1.395U
* device instance $628 r0 *1 0,0 pfet
M$628 VPB\x7cVPWR A\x7cCLK\x7cX \$0$172 VPB\x7cVPWR pfet L=0.15U W=0.64U
+ AS=0.1664P AD=0.0864P PS=1.8U PD=0.91U
* device instance $629 r0 *1 0,0 pfet
M$629 VPB\x7cVPWR CLK\x7cX \$0$173 VPB\x7cVPWR pfet L=0.15U W=0.64U AS=0.1664P
+ AD=0.0864P PS=1.8U PD=0.91U
* device instance $630 r0 *1 0,0 pfet
M$630 VPB\x7cVPWR CLK\x7cX \$0$174 VPB\x7cVPWR pfet L=0.15U W=0.64U AS=0.1664P
+ AD=0.0864P PS=1.8U PD=0.91U
* device instance $631 r0 *1 0,0 pfet
M$631 \$0$176 \$0$157 \$0$165 VPB\x7cVPWR pfet L=0.15U W=0.42U AS=0.0651P
+ AD=0.07245P PS=0.73U PD=0.765U
* device instance $632 r0 *1 0,0 pfet
M$632 \$0$175 A\x7cA_N\x7cD\x7cPH_B9\x7cQ\x7cS VPB\x7cVPWR VPB\x7cVPWR pfet
+ L=0.15U W=0.42U AS=0.1092P AD=0.0651P PS=1.36U PD=0.73U
* device instance $633 r0 *1 0,0 pfet
M$633 \$0$320 \$0$154 \$0$166 VPB\x7cVPWR pfet L=0.15U W=0.42U AS=0.07245P
+ AD=0.1155P PS=0.765U PD=0.97U
* device instance $634 r0 *1 0,0 pfet
M$634 \$0$178 \$0$169 VPB\x7cVPWR VPB\x7cVPWR pfet L=0.15U W=0.64U AS=0.0864P
+ AD=0.1664P PS=0.91U PD=1.8U
* device instance $635 r0 *1 0,0 pfet
M$635 \$0$179 \$0$170 VPB\x7cVPWR VPB\x7cVPWR pfet L=0.15U W=0.64U AS=0.0864P
+ AD=0.1664P PS=0.91U PD=1.8U
* device instance $636 r0 *1 0,0 pfet
M$636 \$0$180 \$0$172 VPB\x7cVPWR VPB\x7cVPWR pfet L=0.15U W=0.64U AS=0.0864P
+ AD=0.1664P PS=0.91U PD=1.8U
* device instance $637 r0 *1 0,0 pfet
M$637 \$0$181 \$0$173 VPB\x7cVPWR VPB\x7cVPWR pfet L=0.15U W=0.64U AS=0.0864P
+ AD=0.1664P PS=0.91U PD=1.8U
* device instance $638 r0 *1 0,0 pfet
M$638 \$0$182 \$0$174 VPB\x7cVPWR VPB\x7cVPWR pfet L=0.15U W=0.64U AS=0.0864P
+ AD=0.1664P PS=0.91U PD=1.8U
* device instance $639 r0 *1 0,0 pfet
M$639 VPB\x7cVPWR \$0$183 D\x7cX_9 VPB\x7cVPWR pfet L=0.15U W=1U AS=0.26P
+ AD=0.15835P PS=2.52U PD=1.395U
* device instance $640 r0 *1 0,0 pfet
M$640 \$0$321 C\x7cD\x7cPH_B7\x7cQ\x7cS VPB\x7cVPWR VPB\x7cVPWR pfet L=0.15U
+ W=0.42U AS=0.15835P AD=0.07665P PS=1.395U PD=0.785U
* device instance $641 r0 *1 0,0 pfet
M$641 VPB\x7cVPWR \$0$185 \$0$318 VPB\x7cVPWR pfet L=0.15U W=0.42U AS=0.1155P
+ AD=0.07035P PS=0.97U PD=0.755U
* device instance $642 r0 *1 0,0 pfet
M$642 VPB\x7cVPWR \$0$187 \$0$319 VPB\x7cVPWR pfet L=0.15U W=0.42U AS=0.1155P
+ AD=0.07035P PS=0.97U PD=0.755U
* device instance $643 r0 *1 0,0 pfet
M$643 D\x7cPH_SAMPLE\x7cSAMPLE\x7cY A\x7cB\x7cBUSY\x7cX VPB\x7cVPWR VPB\x7cVPWR
+ pfet L=0.15U W=1U AS=0.26P AD=0.26P PS=2.52U PD=2.52U
* device instance $644 r0 *1 0,0 pfet
M$644 \$0$189 \$0$161 \$0$175 VPB\x7cVPWR pfet L=0.15U W=0.42U AS=0.0651P
+ AD=0.07245P PS=0.73U PD=0.765U
* device instance $645 r0 *1 0,0 pfet
M$645 \$0$322 \$0$156 \$0$176 VPB\x7cVPWR pfet L=0.15U W=0.42U AS=0.07245P
+ AD=0.1155P PS=0.765U PD=0.97U
* device instance $646 r0 *1 0,0 pfet
M$646 \$0$323 B\x7cD\x7cPH_B0\x7cQ\x7cS VPB\x7cVPWR VPB\x7cVPWR pfet L=0.15U
+ W=0.42U AS=0.15835P AD=0.07665P PS=1.395U PD=0.785U
* device instance $647 r0 *1 0,0 pfet
M$647 \$0$171 A\x7cA0\x7cB\x7cDOUT7\x7cQ \$0$321 VPB\x7cVPWR pfet L=0.15U
+ W=0.42U AS=0.07665P AD=0.1932P PS=0.785U PD=1.34U
* device instance $648 r0 *1 0,0 pfet
M$648 VPB\x7cVPWR \$0$192 \$0$320 VPB\x7cVPWR pfet L=0.15U W=0.42U AS=0.1155P
+ AD=0.07035P PS=0.97U PD=0.755U
* device instance $649 r0 *1 0,0 pfet
M$649 \$0$318 RESET_B\x7cRST_B VPB\x7cVPWR VPB\x7cVPWR pfet L=0.15U W=0.42U
+ AS=0.07035P AD=0.1092P PS=0.755U PD=1.36U
* device instance $650 r0 *1 0,0 pfet
M$650 \$0$319 RESET_B\x7cRST_B VPB\x7cVPWR VPB\x7cVPWR pfet L=0.15U W=0.42U
+ AS=0.07035P AD=0.1092P PS=0.755U PD=1.36U
* device instance $651 r0 *1 0,0 pfet
M$651 \$0$324 \$0$158 \$0$189 VPB\x7cVPWR pfet L=0.15U W=0.42U AS=0.07245P
+ AD=0.1155P PS=0.765U PD=0.97U
* device instance $652 r0 *1 0,0 pfet
M$652 \$0$183 A\x7cA0\x7cB\x7cDOUT0\x7cQ \$0$323 VPB\x7cVPWR pfet L=0.15U
+ W=0.42U AS=0.07665P AD=0.1932P PS=0.785U PD=1.34U
* device instance $653 r0 *1 0,0 pfet
M$653 VPB\x7cVPWR \$0$195 \$0$322 VPB\x7cVPWR pfet L=0.15U W=0.42U AS=0.1155P
+ AD=0.07035P PS=0.97U PD=0.755U
* device instance $654 r0 *1 0,0 pfet
M$654 \$0$320 RESET_B\x7cRST_B VPB\x7cVPWR VPB\x7cVPWR pfet L=0.15U W=0.42U
+ AS=0.07035P AD=0.1092P PS=0.755U PD=1.36U
* device instance $655 r0 *1 0,0 pfet
M$655 \$0$198 B\x7cD\x7cPH_B8\x7cQ\x7cS VPB\x7cVPWR VPB\x7cVPWR pfet L=0.15U
+ W=0.42U AS=0.1092P AD=0.0651P PS=1.36U PD=0.73U
* device instance $656 r0 *1 0,0 pfet
M$656 \$0$199 D\x7cX_10 VPB\x7cVPWR VPB\x7cVPWR pfet L=0.15U W=0.42U AS=0.1092P
+ AD=0.0651P PS=1.36U PD=0.73U
* device instance $657 r0 *1 0,0 pfet
M$657 \$0$200 D\x7cPH_SAMPLE\x7cSAMPLE\x7cY VPB\x7cVPWR VPB\x7cVPWR pfet
+ L=0.15U W=0.42U AS=0.1092P AD=0.0651P PS=1.36U PD=0.73U
* device instance $658 r0 *1 0,0 pfet
M$658 \$0$201 D\x7cX_6 VPB\x7cVPWR VPB\x7cVPWR pfet L=0.15U W=0.42U AS=0.1092P
+ AD=0.0651P PS=1.36U PD=0.73U
* device instance $659 r0 *1 0,0 pfet
M$659 \$0$202 D\x7cX_9 VPB\x7cVPWR VPB\x7cVPWR pfet L=0.15U W=0.42U AS=0.1092P
+ AD=0.0651P PS=1.36U PD=0.73U
* device instance $660 r0 *1 0,0 pfet
M$660 \$0$325 C\x7cX \$0$203 VPB\x7cVPWR pfet L=0.15U W=0.42U AS=0.1092P
+ AD=0.0441P PS=1.36U PD=0.63U
* device instance $661 r0 *1 0,0 pfet
M$661 VPB\x7cVPWR \$0$204 \$0$324 VPB\x7cVPWR pfet L=0.15U W=0.42U AS=0.1155P
+ AD=0.07035P PS=0.97U PD=0.755U
* device instance $662 r0 *1 0,0 pfet
M$662 \$0$322 RESET_B\x7cRST_B VPB\x7cVPWR VPB\x7cVPWR pfet L=0.15U W=0.42U
+ AS=0.07035P AD=0.1092P PS=0.755U PD=1.36U
* device instance $663 r0 *1 0,0 pfet
M$663 \$0$185 \$0$163 VPB\x7cVPWR VPB\x7cVPWR pfet L=0.15U W=0.84U AS=0.2184P
+ AD=0.12915P PS=2.2U PD=1.185U
* device instance $664 r0 *1 0,0 pfet
M$664 \$0$187 \$0$164 VPB\x7cVPWR VPB\x7cVPWR pfet L=0.15U W=0.84U AS=0.2184P
+ AD=0.12915P PS=2.2U PD=1.185U
* device instance $665 r0 *1 0,0 pfet
M$665 \$0$326 A1\x7cCOMP_OUT\x7cOUTP \$0$171 VPB\x7cVPWR pfet L=0.15U W=0.42U
+ AS=0.1932P AD=0.0441P PS=1.34U PD=0.63U
* device instance $666 r0 *1 0,0 pfet
M$666 \$0$327 B\x7cX \$0$325 VPB\x7cVPWR pfet L=0.15U W=0.42U AS=0.0441P
+ AD=0.0693P PS=0.63U PD=0.75U
* device instance $667 r0 *1 0,0 pfet
M$667 \$0$208 \$0$178 \$0$198 VPB\x7cVPWR pfet L=0.15U W=0.42U AS=0.0651P
+ AD=0.07245P PS=0.73U PD=0.765U
* device instance $668 r0 *1 0,0 pfet
M$668 \$0$209 \$0$179 \$0$199 VPB\x7cVPWR pfet L=0.15U W=0.42U AS=0.0651P
+ AD=0.07245P PS=0.73U PD=0.765U
* device instance $669 r0 *1 0,0 pfet
M$669 \$0$210 \$0$180 \$0$200 VPB\x7cVPWR pfet L=0.15U W=0.42U AS=0.0651P
+ AD=0.07245P PS=0.73U PD=0.765U
* device instance $670 r0 *1 0,0 pfet
M$670 \$0$211 \$0$181 \$0$201 VPB\x7cVPWR pfet L=0.15U W=0.42U AS=0.0651P
+ AD=0.07245P PS=0.73U PD=0.765U
* device instance $671 r0 *1 0,0 pfet
M$671 \$0$212 \$0$182 \$0$202 VPB\x7cVPWR pfet L=0.15U W=0.42U AS=0.0651P
+ AD=0.07245P PS=0.73U PD=0.765U
* device instance $672 r0 *1 0,0 pfet
M$672 VPB\x7cVPWR \$0$207 \$0$326 VPB\x7cVPWR pfet L=0.15U W=0.42U AS=0.0441P
+ AD=0.0693P PS=0.63U PD=0.75U
* device instance $673 r0 *1 0,0 pfet
M$673 \$0$324 RESET_B\x7cRST_B VPB\x7cVPWR VPB\x7cVPWR pfet L=0.15U W=0.42U
+ AS=0.07035P AD=0.1092P PS=0.755U PD=1.36U
* device instance $674 r0 *1 0,0 pfet
M$674 \$0$192 \$0$166 VPB\x7cVPWR VPB\x7cVPWR pfet L=0.15U W=0.84U AS=0.2184P
+ AD=0.12915P PS=2.2U PD=1.185U
* device instance $675 r0 *1 0,0 pfet
M$675 \$0$328 A1\x7cCOMP_OUT\x7cOUTP \$0$183 VPB\x7cVPWR pfet L=0.15U W=0.42U
+ AS=0.1932P AD=0.0441P PS=1.34U PD=0.63U
* device instance $676 r0 *1 0,0 pfet
M$676 \$0$213 \$0$149 \$0$185 VPB\x7cVPWR pfet L=0.15U W=0.42U AS=0.12915P
+ AD=0.0588P PS=1.185U PD=0.7U
* device instance $677 r0 *1 0,0 pfet
M$677 \$0$214 \$0$150 \$0$187 VPB\x7cVPWR pfet L=0.15U W=0.42U AS=0.12915P
+ AD=0.0588P PS=1.185U PD=0.7U
* device instance $678 r0 *1 0,0 pfet
M$678 \$0$327 A\x7cX_2 VPB\x7cVPWR VPB\x7cVPWR pfet L=0.15U W=0.42U AS=0.14825P
+ AD=0.0693P PS=1.34U PD=0.75U
* device instance $679 r0 *1 0,0 pfet
M$679 \$0$329 \$0$169 \$0$208 VPB\x7cVPWR pfet L=0.15U W=0.42U AS=0.07245P
+ AD=0.1155P PS=0.765U PD=0.97U
* device instance $680 r0 *1 0,0 pfet
M$680 \$0$330 \$0$170 \$0$209 VPB\x7cVPWR pfet L=0.15U W=0.42U AS=0.07245P
+ AD=0.1155P PS=0.765U PD=0.97U
* device instance $681 r0 *1 0,0 pfet
M$681 \$0$331 \$0$172 \$0$210 VPB\x7cVPWR pfet L=0.15U W=0.42U AS=0.07245P
+ AD=0.1155P PS=0.765U PD=0.97U
* device instance $682 r0 *1 0,0 pfet
M$682 \$0$332 \$0$173 \$0$211 VPB\x7cVPWR pfet L=0.15U W=0.42U AS=0.07245P
+ AD=0.1155P PS=0.765U PD=0.97U
* device instance $683 r0 *1 0,0 pfet
M$683 \$0$333 \$0$174 \$0$212 VPB\x7cVPWR pfet L=0.15U W=0.42U AS=0.07245P
+ AD=0.1155P PS=0.765U PD=0.97U
* device instance $684 r0 *1 0,0 pfet
M$684 VPB\x7cVPWR \$0$215 \$0$328 VPB\x7cVPWR pfet L=0.15U W=0.42U AS=0.0441P
+ AD=0.0693P PS=0.63U PD=0.75U
* device instance $685 r0 *1 0,0 pfet
M$685 \$0$207 C\x7cD\x7cPH_B7\x7cQ\x7cS VPB\x7cVPWR VPB\x7cVPWR pfet L=0.15U
+ W=0.42U AS=0.0693P AD=0.1176P PS=0.75U PD=1.4U
* device instance $686 r0 *1 0,0 pfet
M$686 \$0$195 \$0$176 VPB\x7cVPWR VPB\x7cVPWR pfet L=0.15U W=0.84U AS=0.2184P
+ AD=0.12915P PS=2.2U PD=1.185U
* device instance $687 r0 *1 0,0 pfet
M$687 \$0$334 \$0$152 \$0$213 VPB\x7cVPWR pfet L=0.15U W=0.42U AS=0.0588P
+ AD=0.0567P PS=0.7U PD=0.69U
* device instance $688 r0 *1 0,0 pfet
M$688 \$0$335 \$0$153 \$0$214 VPB\x7cVPWR pfet L=0.15U W=0.42U AS=0.0588P
+ AD=0.0567P PS=0.7U PD=0.69U
* device instance $689 r0 *1 0,0 pfet
M$689 \$0$221 \$0$154 \$0$192 VPB\x7cVPWR pfet L=0.15U W=0.42U AS=0.12915P
+ AD=0.0588P PS=1.185U PD=0.7U
* device instance $690 r0 *1 0,0 pfet
M$690 A\x7cB\x7cBUSY\x7cX \$0$203 VPB\x7cVPWR VPB\x7cVPWR pfet L=0.15U W=1U
+ AS=0.14825P AD=0.28P PS=1.34U PD=2.56U
* device instance $691 r0 *1 0,0 pfet
M$691 VPB\x7cVPWR \$0$228 \$0$329 VPB\x7cVPWR pfet L=0.15U W=0.42U AS=0.1155P
+ AD=0.07035P PS=0.97U PD=0.755U
* device instance $692 r0 *1 0,0 pfet
M$692 VPB\x7cVPWR \$0$230 \$0$330 VPB\x7cVPWR pfet L=0.15U W=0.42U AS=0.1155P
+ AD=0.07035P PS=0.97U PD=0.755U
* device instance $693 r0 *1 0,0 pfet
M$693 VPB\x7cVPWR \$0$232 \$0$331 VPB\x7cVPWR pfet L=0.15U W=0.42U AS=0.1155P
+ AD=0.07035P PS=0.97U PD=0.755U
* device instance $694 r0 *1 0,0 pfet
M$694 VPB\x7cVPWR \$0$234 \$0$332 VPB\x7cVPWR pfet L=0.15U W=0.42U AS=0.1155P
+ AD=0.07035P PS=0.97U PD=0.755U
* device instance $695 r0 *1 0,0 pfet
M$695 VPB\x7cVPWR \$0$236 \$0$333 VPB\x7cVPWR pfet L=0.15U W=0.42U AS=0.1155P
+ AD=0.07035P PS=0.97U PD=0.755U
* device instance $696 r0 *1 0,0 pfet
M$696 \$0$215 B\x7cD\x7cPH_B0\x7cQ\x7cS VPB\x7cVPWR VPB\x7cVPWR pfet L=0.15U
+ W=0.42U AS=0.0693P AD=0.1176P PS=0.75U PD=1.4U
* device instance $697 r0 *1 0,0 pfet
M$697 VPB\x7cVPWR \$0$226 \$0$334 VPB\x7cVPWR pfet L=0.15U W=0.42U AS=0.0567P
+ AD=0.0819P PS=0.69U PD=0.81U
* device instance $698 r0 *1 0,0 pfet
M$698 VPB\x7cVPWR \$0$227 \$0$335 VPB\x7cVPWR pfet L=0.15U W=0.42U AS=0.0567P
+ AD=0.0819P PS=0.69U PD=0.81U
* device instance $699 r0 *1 0,0 pfet
M$699 \$0$204 \$0$189 VPB\x7cVPWR VPB\x7cVPWR pfet L=0.15U W=0.84U AS=0.2184P
+ AD=0.12915P PS=2.2U PD=1.185U
* device instance $700 r0 *1 0,0 pfet
M$700 \$0$336 \$0$155 \$0$221 VPB\x7cVPWR pfet L=0.15U W=0.42U AS=0.0588P
+ AD=0.0567P PS=0.7U PD=0.69U
* device instance $701 r0 *1 0,0 pfet
M$701 \$0$224 \$0$156 \$0$195 VPB\x7cVPWR pfet L=0.15U W=0.42U AS=0.12915P
+ AD=0.0588P PS=1.185U PD=0.7U
* device instance $702 r0 *1 0,0 pfet
M$702 \$0$329 RESET_B\x7cRST_B VPB\x7cVPWR VPB\x7cVPWR pfet L=0.15U W=0.42U
+ AS=0.07035P AD=0.1092P PS=0.755U PD=1.36U
* device instance $703 r0 *1 0,0 pfet
M$703 \$0$330 RESET_B\x7cRST_B VPB\x7cVPWR VPB\x7cVPWR pfet L=0.15U W=0.42U
+ AS=0.07035P AD=0.1092P PS=0.755U PD=1.36U
* device instance $704 r0 *1 0,0 pfet
M$704 \$0$331 RESET_B\x7cRST_B VPB\x7cVPWR VPB\x7cVPWR pfet L=0.15U W=0.42U
+ AS=0.07035P AD=0.1092P PS=0.755U PD=1.36U
* device instance $705 r0 *1 0,0 pfet
M$705 \$0$332 RESET_B\x7cRST_B VPB\x7cVPWR VPB\x7cVPWR pfet L=0.15U W=0.42U
+ AS=0.07035P AD=0.1092P PS=0.755U PD=1.36U
* device instance $706 r0 *1 0,0 pfet
M$706 \$0$333 RESET_B\x7cRST_B VPB\x7cVPWR VPB\x7cVPWR pfet L=0.15U W=0.42U
+ AS=0.07035P AD=0.1092P PS=0.755U PD=1.36U
* device instance $707 r0 *1 0,0 pfet
M$707 VPB\x7cVPWR \$0$240 \$0$336 VPB\x7cVPWR pfet L=0.15U W=0.42U AS=0.0567P
+ AD=0.0819P PS=0.69U PD=0.81U
* device instance $708 r0 *1 0,0 pfet
M$708 \$0$337 \$0$157 \$0$224 VPB\x7cVPWR pfet L=0.15U W=0.42U AS=0.0588P
+ AD=0.0567P PS=0.7U PD=0.69U
* device instance $709 r0 *1 0,0 pfet
M$709 \$0$238 \$0$158 \$0$204 VPB\x7cVPWR pfet L=0.15U W=0.42U AS=0.12915P
+ AD=0.0588P PS=1.185U PD=0.7U
* device instance $710 r0 *1 0,0 pfet
M$710 \$0$226 RESET_B\x7cRST_B VPB\x7cVPWR VPB\x7cVPWR pfet L=0.15U W=0.42U
+ AS=0.0819P AD=0.0567P PS=0.81U PD=0.69U
* device instance $711 r0 *1 0,0 pfet
M$711 \$0$227 RESET_B\x7cRST_B VPB\x7cVPWR VPB\x7cVPWR pfet L=0.15U W=0.42U
+ AS=0.0819P AD=0.0567P PS=0.81U PD=0.69U
* device instance $712 r0 *1 0,0 pfet
M$712 VPB\x7cVPWR \$0$243 D\x7cX_10 VPB\x7cVPWR pfet L=0.15U W=1U AS=0.26P
+ AD=0.15835P PS=2.52U PD=1.395U
* device instance $713 r0 *1 0,0 pfet
M$713 VPB\x7cVPWR \$0$244 D\x7cX_8 VPB\x7cVPWR pfet L=0.15U W=1U AS=0.26P
+ AD=0.15835P PS=2.52U PD=1.395U
* device instance $714 r0 *1 0,0 pfet
M$714 VPB\x7cVPWR \$0$246 \$0$337 VPB\x7cVPWR pfet L=0.15U W=0.42U AS=0.0567P
+ AD=0.0819P PS=0.69U PD=0.81U
* device instance $715 r0 *1 0,0 pfet
M$715 \$0$338 \$0$161 \$0$238 VPB\x7cVPWR pfet L=0.15U W=0.42U AS=0.0588P
+ AD=0.0567P PS=0.7U PD=0.69U
* device instance $716 r0 *1 0,0 pfet
M$716 VPB\x7cVPWR \$0$213 \$0$226 VPB\x7cVPWR pfet L=0.15U W=0.42U AS=0.0567P
+ AD=0.1134P PS=0.69U PD=1.38U
* device instance $717 r0 *1 0,0 pfet
M$717 VPB\x7cVPWR \$0$214 \$0$227 VPB\x7cVPWR pfet L=0.15U W=0.42U AS=0.0567P
+ AD=0.1134P PS=0.69U PD=1.38U
* device instance $718 r0 *1 0,0 pfet
M$718 \$0$240 RESET_B\x7cRST_B VPB\x7cVPWR VPB\x7cVPWR pfet L=0.15U W=0.42U
+ AS=0.0819P AD=0.0567P PS=0.81U PD=0.69U
* device instance $719 r0 *1 0,0 pfet
M$719 \$0$339 C\x7cPH_EOC\x7cQ \$0$248 VPB\x7cVPWR pfet L=0.15U W=0.42U
+ AS=0.1092P AD=0.0441P PS=1.36U PD=0.63U
* device instance $720 r0 *1 0,0 pfet
M$720 \$0$340 B\x7cD\x7cPH_B8\x7cQ\x7cS VPB\x7cVPWR VPB\x7cVPWR pfet L=0.15U
+ W=0.42U AS=0.15835P AD=0.07665P PS=1.395U PD=0.785U
* device instance $721 r0 *1 0,0 pfet
M$721 \$0$341 A\x7cA_N\x7cD\x7cPH_B9\x7cQ\x7cS VPB\x7cVPWR VPB\x7cVPWR pfet
+ L=0.15U W=0.42U AS=0.15835P AD=0.07665P PS=1.395U PD=0.785U
* device instance $722 r0 *1 0,0 pfet
M$722 VPB\x7cVPWR \$0$249 \$0$338 VPB\x7cVPWR pfet L=0.15U W=0.42U AS=0.0567P
+ AD=0.0819P PS=0.69U PD=0.81U
* device instance $723 r0 *1 0,0 pfet
M$723 \$0$228 \$0$208 VPB\x7cVPWR VPB\x7cVPWR pfet L=0.15U W=0.84U AS=0.2184P
+ AD=0.12915P PS=2.2U PD=1.185U
* device instance $724 r0 *1 0,0 pfet
M$724 \$0$230 \$0$209 VPB\x7cVPWR VPB\x7cVPWR pfet L=0.15U W=0.84U AS=0.2184P
+ AD=0.12915P PS=2.2U PD=1.185U
* device instance $725 r0 *1 0,0 pfet
M$725 \$0$232 \$0$210 VPB\x7cVPWR VPB\x7cVPWR pfet L=0.15U W=0.84U AS=0.2184P
+ AD=0.12915P PS=2.2U PD=1.185U
* device instance $726 r0 *1 0,0 pfet
M$726 \$0$234 \$0$211 VPB\x7cVPWR VPB\x7cVPWR pfet L=0.15U W=0.84U AS=0.2184P
+ AD=0.12915P PS=2.2U PD=1.185U
* device instance $727 r0 *1 0,0 pfet
M$727 \$0$236 \$0$212 VPB\x7cVPWR VPB\x7cVPWR pfet L=0.15U W=0.84U AS=0.2184P
+ AD=0.12915P PS=2.2U PD=1.185U
* device instance $728 r0 *1 0,0 pfet
M$728 VPB\x7cVPWR \$0$221 \$0$240 VPB\x7cVPWR pfet L=0.15U W=0.42U AS=0.0567P
+ AD=0.1134P PS=0.69U PD=1.38U
* device instance $729 r0 *1 0,0 pfet
M$729 \$0$246 RESET_B\x7cRST_B VPB\x7cVPWR VPB\x7cVPWR pfet L=0.15U W=0.42U
+ AS=0.0819P AD=0.0567P PS=0.81U PD=0.69U
* device instance $730 r0 *1 0,0 pfet
M$730 \$0$342 B\x7cD\x7cPH_B0\x7cQ\x7cS \$0$339 VPB\x7cVPWR pfet L=0.15U
+ W=0.42U AS=0.0441P AD=0.0693P PS=0.63U PD=0.75U
* device instance $731 r0 *1 0,0 pfet
M$731 \$0$243 A\x7cA0\x7cB\x7cDOUT8\x7cQ \$0$340 VPB\x7cVPWR pfet L=0.15U
+ W=0.42U AS=0.07665P AD=0.1932P PS=0.785U PD=1.34U
* device instance $732 r0 *1 0,0 pfet
M$732 \$0$244 A\x7cA0\x7cB\x7cDOUT9\x7cQ \$0$341 VPB\x7cVPWR pfet L=0.15U
+ W=0.42U AS=0.07665P AD=0.1932P PS=0.785U PD=1.34U
* device instance $733 r0 *1 0,0 pfet
M$733 VPB\x7cVPWR \$0$224 \$0$246 VPB\x7cVPWR pfet L=0.15U W=0.42U AS=0.0567P
+ AD=0.1134P PS=0.69U PD=1.38U
* device instance $734 r0 *1 0,0 pfet
M$734 \$0$253 \$0$169 \$0$228 VPB\x7cVPWR pfet L=0.15U W=0.42U AS=0.12915P
+ AD=0.0588P PS=1.185U PD=0.7U
* device instance $735 r0 *1 0,0 pfet
M$735 \$0$254 \$0$170 \$0$230 VPB\x7cVPWR pfet L=0.15U W=0.42U AS=0.12915P
+ AD=0.0588P PS=1.185U PD=0.7U
* device instance $736 r0 *1 0,0 pfet
M$736 \$0$255 \$0$172 \$0$232 VPB\x7cVPWR pfet L=0.15U W=0.42U AS=0.12915P
+ AD=0.0588P PS=1.185U PD=0.7U
* device instance $737 r0 *1 0,0 pfet
M$737 \$0$256 \$0$173 \$0$234 VPB\x7cVPWR pfet L=0.15U W=0.42U AS=0.12915P
+ AD=0.0588P PS=1.185U PD=0.7U
* device instance $738 r0 *1 0,0 pfet
M$738 \$0$257 \$0$174 \$0$236 VPB\x7cVPWR pfet L=0.15U W=0.42U AS=0.12915P
+ AD=0.0588P PS=1.185U PD=0.7U
* device instance $739 r0 *1 0,0 pfet
M$739 \$0$249 RESET_B\x7cRST_B VPB\x7cVPWR VPB\x7cVPWR pfet L=0.15U W=0.42U
+ AS=0.0819P AD=0.0567P PS=0.81U PD=0.69U
* device instance $740 r0 *1 0,0 pfet
M$740 \$0$342 A\x7cD\x7cPH_B1\x7cQ\x7cS VPB\x7cVPWR VPB\x7cVPWR pfet L=0.15U
+ W=0.42U AS=0.14825P AD=0.0693P PS=1.34U PD=0.75U
* device instance $741 r0 *1 0,0 pfet
M$741 A\x7cA0\x7cB\x7cDOUT7\x7cQ \$0$226 VPB\x7cVPWR VPB\x7cVPWR pfet L=0.15U
+ W=1U AS=0.3012P AD=0.26P PS=2.66U PD=2.52U
* device instance $742 r0 *1 0,0 pfet
M$742 A\x7cA0\x7cB\x7cDOUT9\x7cQ \$0$227 VPB\x7cVPWR VPB\x7cVPWR pfet L=0.15U
+ W=1U AS=0.3012P AD=0.26P PS=2.66U PD=2.52U
* device instance $743 r0 *1 0,0 pfet
M$743 \$0$343 \$0$178 \$0$253 VPB\x7cVPWR pfet L=0.15U W=0.42U AS=0.0588P
+ AD=0.0567P PS=0.7U PD=0.69U
* device instance $744 r0 *1 0,0 pfet
M$744 \$0$344 \$0$179 \$0$254 VPB\x7cVPWR pfet L=0.15U W=0.42U AS=0.0588P
+ AD=0.0567P PS=0.7U PD=0.69U
* device instance $745 r0 *1 0,0 pfet
M$745 VPB\x7cVPWR \$0$238 \$0$249 VPB\x7cVPWR pfet L=0.15U W=0.42U AS=0.0567P
+ AD=0.1134P PS=0.69U PD=1.38U
* device instance $746 r0 *1 0,0 pfet
M$746 \$0$345 \$0$180 \$0$255 VPB\x7cVPWR pfet L=0.15U W=0.42U AS=0.0588P
+ AD=0.0567P PS=0.7U PD=0.69U
* device instance $747 r0 *1 0,0 pfet
M$747 \$0$346 \$0$181 \$0$256 VPB\x7cVPWR pfet L=0.15U W=0.42U AS=0.0588P
+ AD=0.0567P PS=0.7U PD=0.69U
* device instance $748 r0 *1 0,0 pfet
M$748 \$0$347 \$0$182 \$0$257 VPB\x7cVPWR pfet L=0.15U W=0.42U AS=0.0588P
+ AD=0.0567P PS=0.7U PD=0.69U
* device instance $749 r0 *1 0,0 pfet
M$749 C\x7cX \$0$248 VPB\x7cVPWR VPB\x7cVPWR pfet L=0.15U W=1U AS=0.14825P
+ AD=0.28P PS=1.34U PD=2.56U
* device instance $750 r0 *1 0,0 pfet
M$750 C\x7cPH_EOC\x7cQ \$0$240 VPB\x7cVPWR VPB\x7cVPWR pfet L=0.15U W=1U
+ AS=0.3012P AD=0.26P PS=2.66U PD=2.52U
* device instance $751 r0 *1 0,0 pfet
M$751 VPB\x7cVPWR \$0$266 \$0$343 VPB\x7cVPWR pfet L=0.15U W=0.42U AS=0.0567P
+ AD=0.0819P PS=0.69U PD=0.81U
* device instance $752 r0 *1 0,0 pfet
M$752 VPB\x7cVPWR \$0$267 \$0$344 VPB\x7cVPWR pfet L=0.15U W=0.42U AS=0.0567P
+ AD=0.0819P PS=0.69U PD=0.81U
* device instance $753 r0 *1 0,0 pfet
M$753 VPB\x7cVPWR \$0$268 \$0$345 VPB\x7cVPWR pfet L=0.15U W=0.42U AS=0.0567P
+ AD=0.0819P PS=0.69U PD=0.81U
* device instance $754 r0 *1 0,0 pfet
M$754 VPB\x7cVPWR \$0$269 \$0$346 VPB\x7cVPWR pfet L=0.15U W=0.42U AS=0.0567P
+ AD=0.0819P PS=0.69U PD=0.81U
* device instance $755 r0 *1 0,0 pfet
M$755 VPB\x7cVPWR \$0$270 \$0$347 VPB\x7cVPWR pfet L=0.15U W=0.42U AS=0.0567P
+ AD=0.0819P PS=0.69U PD=0.81U
* device instance $756 r0 *1 0,0 pfet
M$756 \$0$348 A1\x7cCOMP_OUT\x7cOUTP \$0$243 VPB\x7cVPWR pfet L=0.15U W=0.42U
+ AS=0.1932P AD=0.0441P PS=1.34U PD=0.63U
* device instance $757 r0 *1 0,0 pfet
M$757 \$0$349 A1\x7cCOMP_OUT\x7cOUTP \$0$244 VPB\x7cVPWR pfet L=0.15U W=0.42U
+ AS=0.1932P AD=0.0441P PS=1.34U PD=0.63U
* device instance $758 r0 *1 0,0 pfet
M$758 D\x7cPH_B6\x7cQ\x7cS \$0$246 VPB\x7cVPWR VPB\x7cVPWR pfet L=0.15U W=1U
+ AS=0.3012P AD=0.26P PS=2.66U PD=2.52U
* device instance $759 r0 *1 0,0 pfet
M$759 VPB\x7cVPWR \$0$271 \$0$348 VPB\x7cVPWR pfet L=0.15U W=0.42U AS=0.0441P
+ AD=0.0693P PS=0.63U PD=0.75U
* device instance $760 r0 *1 0,0 pfet
M$760 VPB\x7cVPWR \$0$272 \$0$349 VPB\x7cVPWR pfet L=0.15U W=0.42U AS=0.0441P
+ AD=0.0693P PS=0.63U PD=0.75U
* device instance $761 r0 *1 0,0 pfet
M$761 \$0$266 RESET_B\x7cRST_B VPB\x7cVPWR VPB\x7cVPWR pfet L=0.15U W=0.42U
+ AS=0.0819P AD=0.0567P PS=0.81U PD=0.69U
* device instance $762 r0 *1 0,0 pfet
M$762 \$0$267 RESET_B\x7cRST_B VPB\x7cVPWR VPB\x7cVPWR pfet L=0.15U W=0.42U
+ AS=0.0819P AD=0.0567P PS=0.81U PD=0.69U
* device instance $763 r0 *1 0,0 pfet
M$763 \$0$268 RESET_B\x7cRST_B VPB\x7cVPWR VPB\x7cVPWR pfet L=0.15U W=0.42U
+ AS=0.0819P AD=0.0567P PS=0.81U PD=0.69U
* device instance $764 r0 *1 0,0 pfet
M$764 \$0$269 RESET_B\x7cRST_B VPB\x7cVPWR VPB\x7cVPWR pfet L=0.15U W=0.42U
+ AS=0.0819P AD=0.0567P PS=0.81U PD=0.69U
* device instance $765 r0 *1 0,0 pfet
M$765 \$0$270 RESET_B\x7cRST_B VPB\x7cVPWR VPB\x7cVPWR pfet L=0.15U W=0.42U
+ AS=0.0819P AD=0.0567P PS=0.81U PD=0.69U
* device instance $766 r0 *1 0,0 pfet
M$766 B\x7cD\x7cPH_B8\x7cQ\x7cS \$0$249 VPB\x7cVPWR VPB\x7cVPWR pfet L=0.15U
+ W=1U AS=0.3012P AD=0.26P PS=2.66U PD=2.52U
* device instance $767 r0 *1 0,0 pfet
M$767 \$0$271 B\x7cD\x7cPH_B8\x7cQ\x7cS VPB\x7cVPWR VPB\x7cVPWR pfet L=0.15U
+ W=0.42U AS=0.0693P AD=0.1176P PS=0.75U PD=1.4U
* device instance $768 r0 *1 0,0 pfet
M$768 \$0$272 A\x7cA_N\x7cD\x7cPH_B9\x7cQ\x7cS VPB\x7cVPWR VPB\x7cVPWR pfet
+ L=0.15U W=0.42U AS=0.0693P AD=0.1176P PS=0.75U PD=1.4U
* device instance $769 r0 *1 0,0 pfet
M$769 VPB\x7cVPWR \$0$253 \$0$266 VPB\x7cVPWR pfet L=0.15U W=0.42U AS=0.0567P
+ AD=0.1134P PS=0.69U PD=1.38U
* device instance $770 r0 *1 0,0 pfet
M$770 VPB\x7cVPWR \$0$254 \$0$267 VPB\x7cVPWR pfet L=0.15U W=0.42U AS=0.0567P
+ AD=0.1134P PS=0.69U PD=1.38U
* device instance $771 r0 *1 0,0 pfet
M$771 VPB\x7cVPWR \$0$255 \$0$268 VPB\x7cVPWR pfet L=0.15U W=0.42U AS=0.0567P
+ AD=0.1134P PS=0.69U PD=1.38U
* device instance $772 r0 *1 0,0 pfet
M$772 VPB\x7cVPWR \$0$256 \$0$269 VPB\x7cVPWR pfet L=0.15U W=0.42U AS=0.0567P
+ AD=0.1134P PS=0.69U PD=1.38U
* device instance $773 r0 *1 0,0 pfet
M$773 VPB\x7cVPWR \$0$257 \$0$270 VPB\x7cVPWR pfet L=0.15U W=0.42U AS=0.0567P
+ AD=0.1134P PS=0.69U PD=1.38U
* device instance $774 r0 *1 0,0 pfet
M$774 C\x7cD\x7cPH_B7\x7cQ\x7cS \$0$266 VPB\x7cVPWR VPB\x7cVPWR pfet L=0.15U
+ W=1U AS=0.3012P AD=0.26P PS=2.66U PD=2.52U
* device instance $775 r0 *1 0,0 pfet
M$775 A\x7cA0\x7cB\x7cDOUT8\x7cQ \$0$267 VPB\x7cVPWR VPB\x7cVPWR pfet L=0.15U
+ W=1U AS=0.3012P AD=0.26P PS=2.66U PD=2.52U
* device instance $776 r0 *1 0,0 pfet
M$776 A\x7cA_N\x7cD\x7cPH_B9\x7cQ\x7cS \$0$268 VPB\x7cVPWR VPB\x7cVPWR pfet
+ L=0.15U W=1U AS=0.3012P AD=0.26P PS=2.66U PD=2.52U
* device instance $777 r0 *1 0,0 pfet
M$777 A\x7cA0\x7cB\x7cDOUT1\x7cQ \$0$269 VPB\x7cVPWR VPB\x7cVPWR pfet L=0.15U
+ W=1U AS=0.3012P AD=0.26P PS=2.66U PD=2.52U
* device instance $778 r0 *1 0,0 pfet
M$778 A\x7cA0\x7cB\x7cDOUT0\x7cQ \$0$270 VPB\x7cVPWR VPB\x7cVPWR pfet L=0.15U
+ W=1U AS=0.3012P AD=0.26P PS=2.66U PD=2.52U
.ENDS sar_sequencer__sar_sequencer

* cell sampling_frontend__gen_compose_0
* pin TOP_P|VINP
* pin VINP
* pin GND|VGND|VSS
* pin TOP_N|VINN
* pin VINN
* pin D|PH_SAMPLE|SAMPLE|Y
* pin VCM
* pin VDD
.SUBCKT sampling_frontend__gen_compose_0 TOP_P\x7cVINP VINP GND\x7cVGND\x7cVSS
+ TOP_N\x7cVINN VINN D\x7cPH_SAMPLE\x7cSAMPLE\x7cY VCM VDD
* device instance $1 r0 *1 0,0 nfet
M$1 VINP \$0 TOP_P\x7cVINP GND\x7cVGND\x7cVSS nfet L=0.15U W=2U AS=0.94P
+ AD=0.94P PS=4.94U PD=4.94U
* device instance $2 r0 *1 0,0 nfet
M$2 VINN \$0$1 TOP_N\x7cVINN GND\x7cVGND\x7cVSS nfet L=0.15U W=2U AS=0.94P
+ AD=0.94P PS=4.94U PD=4.94U
* device instance $3 r0 *1 0,0 nfet
M$3 \$0$3 \$0$2 GND\x7cVGND\x7cVSS GND\x7cVGND\x7cVSS nfet L=0.15U W=1U
+ AS=0.47P AD=0.47P PS=2.94U PD=2.94U
* device instance $4 r0 *1 0,0 nfet
M$4 \$0$3 D\x7cPH_SAMPLE\x7cSAMPLE\x7cY VINP GND\x7cVGND\x7cVSS nfet L=0.15U
+ W=1U AS=0.47P AD=0.47P PS=2.94U PD=2.94U
* device instance $5 r0 *1 0,0 nfet
M$5 \$0 \$0$2 GND\x7cVGND\x7cVSS GND\x7cVGND\x7cVSS nfet L=0.5U W=1U AS=0.42P
+ AD=0.42P PS=2.84U PD=2.84U
* device instance $6 r0 *1 0,0 nfet
M$6 BPREF_P D\x7cPH_SAMPLE\x7cSAMPLE\x7cY VCM GND\x7cVGND\x7cVSS nfet L=0.15U
+ W=16U AS=7.52P AD=7.52P PS=32.94U PD=32.94U
* device instance $7 r0 *1 0,0 nfet
M$7 BPREF_N D\x7cPH_SAMPLE\x7cSAMPLE\x7cY VCM GND\x7cVGND\x7cVSS nfet L=0.15U
+ W=16U AS=7.52P AD=7.52P PS=32.94U PD=32.94U
* device instance $8 r0 *1 0,0 nfet
M$8 \$0$1 \$0$2 GND\x7cVGND\x7cVSS GND\x7cVGND\x7cVSS nfet L=0.5U W=1U AS=0.42P
+ AD=0.42P PS=2.84U PD=2.84U
* device instance $9 r0 *1 0,0 nfet
M$9 \$0$4 D\x7cPH_SAMPLE\x7cSAMPLE\x7cY VINN GND\x7cVGND\x7cVSS nfet L=0.15U
+ W=1U AS=0.47P AD=0.47P PS=2.94U PD=2.94U
* device instance $10 r0 *1 0,0 nfet
M$10 \$0$4 \$0$2 GND\x7cVGND\x7cVSS GND\x7cVGND\x7cVSS nfet L=0.15U W=1U
+ AS=0.47P AD=0.47P PS=2.94U PD=2.94U
* device instance $11 r0 *1 0,0 nfet
M$11 \$0$2 D\x7cPH_SAMPLE\x7cSAMPLE\x7cY GND\x7cVGND\x7cVSS GND\x7cVGND\x7cVSS
+ nfet L=0.15U W=1U AS=0.47P AD=0.47P PS=2.94U PD=2.94U
* device instance $12 r0 *1 0,0 pfet
M$12 BOOST_P \$0 VDD BOOST_P pfet L=0.5U W=1U AS=0.42P AD=0.42P PS=2.84U
+ PD=2.84U
* device instance $13 r0 *1 0,0 pfet
M$13 \$0 \$0$2 BOOST_P BOOST_P pfet L=0.15U W=1U AS=0.47P AD=0.47P PS=2.94U
+ PD=2.94U
* device instance $14 r0 *1 0,0 pfet
M$14 \$0$3 \$0$2 VINP VDD pfet L=0.15U W=1U AS=0.47P AD=0.47P PS=2.94U PD=2.94U
* device instance $15 r0 *1 0,0 pfet
M$15 BPREF_P \$0$2 VCM VDD pfet L=0.15U W=16U AS=7.52P AD=7.52P PS=32.94U
+ PD=32.94U
* device instance $16 r0 *1 0,0 pfet
M$16 \$0$2 D\x7cPH_SAMPLE\x7cSAMPLE\x7cY VDD VDD pfet L=0.15U W=2U AS=0.94P
+ AD=0.94P PS=4.94U PD=4.94U
* device instance $17 r0 *1 0,0 pfet
M$17 BPREF_N \$0$2 VCM VDD pfet L=0.15U W=16U AS=7.52P AD=7.52P PS=32.94U
+ PD=32.94U
* device instance $18 r0 *1 0,0 pfet
M$18 \$0$4 \$0$2 VINN VDD pfet L=0.15U W=1U AS=0.47P AD=0.47P PS=2.94U PD=2.94U
* device instance $19 r0 *1 0,0 pfet
M$19 \$0$1 \$0$2 BOOST_N BOOST_N pfet L=0.15U W=1U AS=0.47P AD=0.47P PS=2.94U
+ PD=2.94U
* device instance $20 r0 *1 0,0 pfet
M$20 BOOST_N \$0$1 VDD BOOST_N pfet L=0.5U W=1U AS=0.42P AD=0.42P PS=2.84U
+ PD=2.84U
* device instance $21 r0 *1 0,0 sky130_fd_pr__model__cap_mim
C$21 \$0$3 BOOST_P 1.99528e-13
* device instance $22 r0 *1 0,0 sky130_fd_pr__model__cap_mim
C$22 \$0$4 BOOST_N 1.99528e-13
* device instance $23 r0 *1 0,0 sky130_fd_pr__model__cap_mim
C$23 BPREF_P TOP_P\x7cVINP 4.434864e-12
* device instance $24 r0 *1 0,0 sky130_fd_pr__model__cap_mim
C$24 BPREF_N TOP_N\x7cVINN 4.434864e-12
.ENDS sampling_frontend__gen_compose_0

* cell halflsb_offset__gen_compose_0
* pin VCM
* pin A|HALF_LSB_EN|X
* pin GND|VGND|VSS
* pin VREFP
* pin VDD
* pin HALF_LSB_ENN|Y
* pin VPB|VPWR
* pin TOP_N|VINN
* pin TOP_P|VINP
.SUBCKT halflsb_offset__gen_compose_0 VCM A\x7cHALF_LSB_EN\x7cX
+ GND\x7cVGND\x7cVSS VREFP VDD HALF_LSB_ENN\x7cY VPB\x7cVPWR TOP_N\x7cVINN
+ TOP_P\x7cVINP
* device instance $1 r0 *1 0,0 nfet
M$1 BOT_OFF_N A\x7cHALF_LSB_EN\x7cX VCM GND\x7cVGND\x7cVSS nfet L=0.15U W=1U
+ AS=0.47P AD=0.47P PS=2.94U PD=2.94U
* device instance $2 r0 *1 0,0 nfet
M$2 BOT_OFF_P GND\x7cVGND\x7cVSS VCM GND\x7cVGND\x7cVSS nfet L=0.15U W=1U
+ AS=0.47P AD=0.47P PS=2.94U PD=2.94U
* device instance $3 r0 *1 0,0 pfet
M$3 BOT_OFF_N A\x7cHALF_LSB_EN\x7cX VREFP VDD pfet L=0.15U W=2U AS=0.94P
+ AD=0.94P PS=4.94U PD=4.94U
* device instance $4 r0 *1 0,0 pfet
M$4 BOT_OFF_N HALF_LSB_ENN\x7cY VCM VDD pfet L=0.15U W=2U AS=0.94P AD=0.94P
+ PS=4.94U PD=4.94U
* device instance $5 r0 *1 0,0 pfet
M$5 BOT_OFF_P GND\x7cVGND\x7cVSS VREFP VDD pfet L=0.15U W=2U AS=0.94P AD=0.94P
+ PS=4.94U PD=4.94U
* device instance $6 r0 *1 0,0 pfet
M$6 BOT_OFF_P VPB\x7cVPWR VCM VDD pfet L=0.15U W=2U AS=0.94P AD=0.94P PS=4.94U
+ PD=4.94U
* device instance $7 r0 *1 0,0 sky130_fd_pr__model__cap_mim
C$7 BOT_OFF_N TOP_N\x7cVINN 8.664e-15
* device instance $8 r0 *1 0,0 sky130_fd_pr__model__cap_mim
C$8 BOT_OFF_P TOP_P\x7cVINP 8.664e-15
.ENDS halflsb_offset__gen_compose_0

* cell comparator__gen_compose_0
* pin GND|VGND|VSS
* pin CLK|CLKN|Y
* pin TOP_N|VINN
* pin TOP_P|VINP
* pin A|A1|OUTN|OUTN_NC
* pin A1|COMP_OUT|OUTP
* pin VDD
.SUBCKT comparator__gen_compose_0 GND\x7cVGND\x7cVSS CLK\x7cCLKN\x7cY
+ TOP_N\x7cVINN TOP_P\x7cVINP A\x7cA1\x7cOUTN\x7cOUTN_NC A1\x7cCOMP_OUT\x7cOUTP
+ VDD
* device instance $1 r0 *1 0,0 nfet
M$1 \$0 CLK\x7cCLKN\x7cY GND\x7cVGND\x7cVSS GND\x7cVGND\x7cVSS nfet L=0.5U W=8U
+ AS=3.36P AD=3.36P PS=16.84U PD=16.84U
* device instance $2 r0 *1 0,0 nfet
M$2 \$0$1 TOP_N\x7cVINN \$0 GND\x7cVGND\x7cVSS nfet L=0.5U W=2U AS=0.84P
+ AD=0.84P PS=4.84U PD=4.84U
* device instance $3 r0 *1 0,0 nfet
M$3 \$0$2 TOP_P\x7cVINP \$0 GND\x7cVGND\x7cVSS nfet L=0.5U W=2U AS=0.84P
+ AD=0.84P PS=4.84U PD=4.84U
* device instance $4 r0 *1 0,0 nfet
M$4 \$0$2 TOP_P\x7cVINP \$0 GND\x7cVGND\x7cVSS nfet L=0.5U W=2U AS=0.84P
+ AD=0.84P PS=4.84U PD=4.84U
* device instance $5 r0 *1 0,0 nfet
M$5 \$0$1 TOP_N\x7cVINN \$0 GND\x7cVGND\x7cVSS nfet L=0.5U W=2U AS=0.84P
+ AD=0.84P PS=4.84U PD=4.84U
* device instance $6 r0 *1 0,0 nfet
M$6 A1\x7cCOMP_OUT\x7cOUTP A\x7cA1\x7cOUTN\x7cOUTN_NC \$0$1 GND\x7cVGND\x7cVSS
+ nfet L=0.5U W=4U AS=1.68P AD=1.68P PS=8.84U PD=8.84U
* device instance $7 r0 *1 0,0 nfet
M$7 A\x7cA1\x7cOUTN\x7cOUTN_NC A1\x7cCOMP_OUT\x7cOUTP \$0$2 GND\x7cVGND\x7cVSS
+ nfet L=0.5U W=4U AS=1.68P AD=1.68P PS=8.84U PD=8.84U
* device instance $8 r0 *1 0,0 pfet
M$8 A1\x7cCOMP_OUT\x7cOUTP A\x7cA1\x7cOUTN\x7cOUTN_NC VDD VDD pfet L=0.5U W=8U
+ AS=3.36P AD=3.36P PS=16.84U PD=16.84U
* device instance $9 r0 *1 0,0 pfet
M$9 A\x7cA1\x7cOUTN\x7cOUTN_NC A1\x7cCOMP_OUT\x7cOUTP VDD VDD pfet L=0.5U W=8U
+ AS=3.36P AD=3.36P PS=16.84U PD=16.84U
* device instance $10 r0 *1 0,0 pfet
M$10 A1\x7cCOMP_OUT\x7cOUTP CLK\x7cCLKN\x7cY VDD VDD pfet L=0.5U W=16U AS=6.72P
+ AD=6.72P PS=32.84U PD=32.84U
* device instance $11 r0 *1 0,0 pfet
M$11 A\x7cA1\x7cOUTN\x7cOUTN_NC CLK\x7cCLKN\x7cY VDD VDD pfet L=0.5U W=16U
+ AS=6.72P AD=6.72P PS=32.84U PD=32.84U
* device instance $12 r0 *1 0,0 pfet
M$12 \$0$1 CLK\x7cCLKN\x7cY VDD VDD pfet L=0.5U W=4U AS=1.68P AD=1.68P PS=8.84U
+ PD=8.84U
* device instance $13 r0 *1 0,0 pfet
M$13 \$0$2 CLK\x7cCLKN\x7cY VDD VDD pfet L=0.5U W=4U AS=1.68P AD=1.68P PS=8.84U
+ PD=8.84U
.ENDS comparator__gen_compose_0

* cell cdac_array__cdac_array
* pin VREFN
* pin SELp0|X
* pin GND|VGND|VSS
* pin SELp1|X
* pin SELp2|X
* pin SELp3|X
* pin SELp4|X
* pin SELp5|X
* pin SELp6|X
* pin SELp7|X
* pin SELp8|X
* pin SELn0|X
* pin SELn1|X
* pin SELn2|X
* pin SELn3|X
* pin SELn4|X
* pin SELn5|X
* pin SELn6|X
* pin SELn7|X
* pin SELn8|X
* pin VREFP
* pin VDD
* pin TOP_P|VINP
* pin TOP_N|VINN
.SUBCKT cdac_array__cdac_array VREFN SELp0\x7cX GND\x7cVGND\x7cVSS SELp1\x7cX
+ SELp2\x7cX SELp3\x7cX SELp4\x7cX SELp5\x7cX SELp6\x7cX SELp7\x7cX SELp8\x7cX
+ SELn0\x7cX SELn1\x7cX SELn2\x7cX SELn3\x7cX SELn4\x7cX SELn5\x7cX SELn6\x7cX
+ SELn7\x7cX SELn8\x7cX VREFP VDD TOP_P\x7cVINP TOP_N\x7cVINN
* device instance $1 r0 *1 0,0 nfet
M$1 \$0 SELp0\x7cX VREFN GND\x7cVGND\x7cVSS nfet L=0.15U W=1U AS=0.47P AD=0.47P
+ PS=2.94U PD=2.94U
* device instance $2 r0 *1 0,0 nfet
M$2 \$0$1 SELp1\x7cX VREFN GND\x7cVGND\x7cVSS nfet L=0.15U W=1U AS=0.47P
+ AD=0.47P PS=2.94U PD=2.94U
* device instance $3 r0 *1 0,0 nfet
M$3 \$0$2 SELp2\x7cX VREFN GND\x7cVGND\x7cVSS nfet L=0.15U W=1U AS=0.47P
+ AD=0.47P PS=2.94U PD=2.94U
* device instance $4 r0 *1 0,0 nfet
M$4 \$0$3 SELp3\x7cX VREFN GND\x7cVGND\x7cVSS nfet L=0.15U W=1U AS=0.47P
+ AD=0.47P PS=2.94U PD=2.94U
* device instance $5 r0 *1 0,0 nfet
M$5 \$0$4 SELp4\x7cX VREFN GND\x7cVGND\x7cVSS nfet L=0.15U W=1U AS=0.47P
+ AD=0.47P PS=2.94U PD=2.94U
* device instance $6 r0 *1 0,0 nfet
M$6 \$0$5 SELp5\x7cX VREFN GND\x7cVGND\x7cVSS nfet L=0.15U W=1U AS=0.47P
+ AD=0.47P PS=2.94U PD=2.94U
* device instance $7 r0 *1 0,0 nfet
M$7 \$0$6 SELp6\x7cX VREFN GND\x7cVGND\x7cVSS nfet L=0.15U W=1U AS=0.47P
+ AD=0.47P PS=2.94U PD=2.94U
* device instance $8 r0 *1 0,0 nfet
M$8 \$0$7 SELp7\x7cX VREFN GND\x7cVGND\x7cVSS nfet L=0.15U W=1U AS=0.47P
+ AD=0.47P PS=2.94U PD=2.94U
* device instance $9 r0 *1 0,0 nfet
M$9 \$0$8 SELp8\x7cX VREFN GND\x7cVGND\x7cVSS nfet L=0.15U W=1U AS=0.47P
+ AD=0.47P PS=2.94U PD=2.94U
* device instance $10 r0 *1 0,0 nfet
M$10 \$0$9 SELn0\x7cX VREFN GND\x7cVGND\x7cVSS nfet L=0.15U W=1U AS=0.47P
+ AD=0.47P PS=2.94U PD=2.94U
* device instance $11 r0 *1 0,0 nfet
M$11 \$0$10 SELn1\x7cX VREFN GND\x7cVGND\x7cVSS nfet L=0.15U W=1U AS=0.47P
+ AD=0.47P PS=2.94U PD=2.94U
* device instance $12 r0 *1 0,0 nfet
M$12 \$0$11 SELn2\x7cX VREFN GND\x7cVGND\x7cVSS nfet L=0.15U W=1U AS=0.47P
+ AD=0.47P PS=2.94U PD=2.94U
* device instance $13 r0 *1 0,0 nfet
M$13 \$0$12 SELn3\x7cX VREFN GND\x7cVGND\x7cVSS nfet L=0.15U W=1U AS=0.47P
+ AD=0.47P PS=2.94U PD=2.94U
* device instance $14 r0 *1 0,0 nfet
M$14 \$0$13 SELn4\x7cX VREFN GND\x7cVGND\x7cVSS nfet L=0.15U W=1U AS=0.47P
+ AD=0.47P PS=2.94U PD=2.94U
* device instance $15 r0 *1 0,0 nfet
M$15 \$0$14 SELn5\x7cX VREFN GND\x7cVGND\x7cVSS nfet L=0.15U W=1U AS=0.47P
+ AD=0.47P PS=2.94U PD=2.94U
* device instance $16 r0 *1 0,0 nfet
M$16 \$0$15 SELn6\x7cX VREFN GND\x7cVGND\x7cVSS nfet L=0.15U W=1U AS=0.47P
+ AD=0.47P PS=2.94U PD=2.94U
* device instance $17 r0 *1 0,0 nfet
M$17 \$0$16 SELn7\x7cX VREFN GND\x7cVGND\x7cVSS nfet L=0.15U W=1U AS=0.47P
+ AD=0.47P PS=2.94U PD=2.94U
* device instance $18 r0 *1 0,0 nfet
M$18 \$0$17 SELn8\x7cX VREFN GND\x7cVGND\x7cVSS nfet L=0.15U W=1U AS=0.47P
+ AD=0.47P PS=2.94U PD=2.94U
* device instance $19 r0 *1 0,0 pfet
M$19 \$0 SELp0\x7cX VREFP VDD pfet L=0.15U W=2U AS=0.94P AD=0.94P PS=4.94U
+ PD=4.94U
* device instance $20 r0 *1 0,0 pfet
M$20 \$0$1 SELp1\x7cX VREFP VDD pfet L=0.15U W=2U AS=0.94P AD=0.94P PS=4.94U
+ PD=4.94U
* device instance $21 r0 *1 0,0 pfet
M$21 \$0$2 SELp2\x7cX VREFP VDD pfet L=0.15U W=2U AS=0.94P AD=0.94P PS=4.94U
+ PD=4.94U
* device instance $22 r0 *1 0,0 pfet
M$22 \$0$3 SELp3\x7cX VREFP VDD pfet L=0.15U W=2U AS=0.94P AD=0.94P PS=4.94U
+ PD=4.94U
* device instance $23 r0 *1 0,0 pfet
M$23 \$0$4 SELp4\x7cX VREFP VDD pfet L=0.15U W=2U AS=0.94P AD=0.94P PS=4.94U
+ PD=4.94U
* device instance $24 r0 *1 0,0 pfet
M$24 \$0$5 SELp5\x7cX VREFP VDD pfet L=0.15U W=2U AS=0.94P AD=0.94P PS=4.94U
+ PD=4.94U
* device instance $25 r0 *1 0,0 pfet
M$25 \$0$6 SELp6\x7cX VREFP VDD pfet L=0.15U W=2U AS=0.94P AD=0.94P PS=4.94U
+ PD=4.94U
* device instance $26 r0 *1 0,0 pfet
M$26 \$0$7 SELp7\x7cX VREFP VDD pfet L=0.15U W=2U AS=0.94P AD=0.94P PS=4.94U
+ PD=4.94U
* device instance $27 r0 *1 0,0 pfet
M$27 \$0$8 SELp8\x7cX VREFP VDD pfet L=0.15U W=2U AS=0.94P AD=0.94P PS=4.94U
+ PD=4.94U
* device instance $28 r0 *1 0,0 pfet
M$28 \$0$9 SELn0\x7cX VREFP VDD pfet L=0.15U W=2U AS=0.94P AD=0.94P PS=4.94U
+ PD=4.94U
* device instance $29 r0 *1 0,0 pfet
M$29 \$0$10 SELn1\x7cX VREFP VDD pfet L=0.15U W=2U AS=0.94P AD=0.94P PS=4.94U
+ PD=4.94U
* device instance $30 r0 *1 0,0 pfet
M$30 \$0$11 SELn2\x7cX VREFP VDD pfet L=0.15U W=2U AS=0.94P AD=0.94P PS=4.94U
+ PD=4.94U
* device instance $31 r0 *1 0,0 pfet
M$31 \$0$12 SELn3\x7cX VREFP VDD pfet L=0.15U W=2U AS=0.94P AD=0.94P PS=4.94U
+ PD=4.94U
* device instance $32 r0 *1 0,0 pfet
M$32 \$0$13 SELn4\x7cX VREFP VDD pfet L=0.15U W=2U AS=0.94P AD=0.94P PS=4.94U
+ PD=4.94U
* device instance $33 r0 *1 0,0 pfet
M$33 \$0$14 SELn5\x7cX VREFP VDD pfet L=0.15U W=2U AS=0.94P AD=0.94P PS=4.94U
+ PD=4.94U
* device instance $34 r0 *1 0,0 pfet
M$34 \$0$15 SELn6\x7cX VREFP VDD pfet L=0.15U W=2U AS=0.94P AD=0.94P PS=4.94U
+ PD=4.94U
* device instance $35 r0 *1 0,0 pfet
M$35 \$0$16 SELn7\x7cX VREFP VDD pfet L=0.15U W=2U AS=0.94P AD=0.94P PS=4.94U
+ PD=4.94U
* device instance $36 r0 *1 0,0 pfet
M$36 \$0$17 SELn8\x7cX VREFP VDD pfet L=0.15U W=2U AS=0.94P AD=0.94P PS=4.94U
+ PD=4.94U
* device instance $37 r0 *1 0,0 sky130_fd_pr__model__cap_mim
C$37 \$0$8 TOP_P\x7cVINP 8.664e-15
* device instance $38 r0 *1 0,0 sky130_fd_pr__model__cap_mim
C$38 \$0$17 TOP_N\x7cVINN 8.664e-15
* device instance $39 r0 *1 0,0 sky130_fd_pr__model__cap_mim
C$39 \$0$8 TOP_P\x7cVINP 8.664e-15
* device instance $40 r0 *1 0,0 sky130_fd_pr__model__cap_mim
C$40 \$0$17 TOP_N\x7cVINN 8.664e-15
* device instance $41 r0 *1 0,0 sky130_fd_pr__model__cap_mim
C$41 \$0$8 TOP_P\x7cVINP 8.664e-15
* device instance $42 r0 *1 0,0 sky130_fd_pr__model__cap_mim
C$42 \$0$17 TOP_N\x7cVINN 8.664e-15
* device instance $43 r0 *1 0,0 sky130_fd_pr__model__cap_mim
C$43 \$0$8 TOP_P\x7cVINP 8.664e-15
* device instance $44 r0 *1 0,0 sky130_fd_pr__model__cap_mim
C$44 \$0$17 TOP_N\x7cVINN 8.664e-15
* device instance $45 r0 *1 0,0 sky130_fd_pr__model__cap_mim
C$45 \$0$17 TOP_N\x7cVINN 8.664e-15
* device instance $46 r0 *1 0,0 sky130_fd_pr__model__cap_mim
C$46 \$0$8 TOP_P\x7cVINP 8.664e-15
* device instance $47 r0 *1 0,0 sky130_fd_pr__model__cap_mim
C$47 \$0$17 TOP_N\x7cVINN 8.664e-15
* device instance $48 r0 *1 0,0 sky130_fd_pr__model__cap_mim
C$48 \$0$8 TOP_P\x7cVINP 8.664e-15
* device instance $49 r0 *1 0,0 sky130_fd_pr__model__cap_mim
C$49 \$0$17 TOP_N\x7cVINN 8.664e-15
* device instance $50 r0 *1 0,0 sky130_fd_pr__model__cap_mim
C$50 \$0$8 TOP_P\x7cVINP 8.664e-15
* device instance $51 r0 *1 0,0 sky130_fd_pr__model__cap_mim
C$51 \$0$17 TOP_N\x7cVINN 8.664e-15
* device instance $52 r0 *1 0,0 sky130_fd_pr__model__cap_mim
C$52 \$0$8 TOP_P\x7cVINP 8.664e-15
* device instance $53 r0 *1 0,0 sky130_fd_pr__model__cap_mim
C$53 \$0$7 TOP_P\x7cVINP 8.664e-15
* device instance $54 r0 *1 0,0 sky130_fd_pr__model__cap_mim
C$54 \$0$16 TOP_N\x7cVINN 8.664e-15
* device instance $55 r0 *1 0,0 sky130_fd_pr__model__cap_mim
C$55 \$0$7 TOP_P\x7cVINP 8.664e-15
* device instance $56 r0 *1 0,0 sky130_fd_pr__model__cap_mim
C$56 \$0$16 TOP_N\x7cVINN 8.664e-15
* device instance $57 r0 *1 0,0 sky130_fd_pr__model__cap_mim
C$57 \$0$7 TOP_P\x7cVINP 8.664e-15
* device instance $58 r0 *1 0,0 sky130_fd_pr__model__cap_mim
C$58 \$0$16 TOP_N\x7cVINN 8.664e-15
* device instance $59 r0 *1 0,0 sky130_fd_pr__model__cap_mim
C$59 \$0$7 TOP_P\x7cVINP 8.664e-15
* device instance $60 r0 *1 0,0 sky130_fd_pr__model__cap_mim
C$60 \$0$16 TOP_N\x7cVINN 8.664e-15
* device instance $61 r0 *1 0,0 sky130_fd_pr__model__cap_mim
C$61 \$0$16 TOP_N\x7cVINN 8.664e-15
* device instance $62 r0 *1 0,0 sky130_fd_pr__model__cap_mim
C$62 \$0$7 TOP_P\x7cVINP 8.664e-15
* device instance $63 r0 *1 0,0 sky130_fd_pr__model__cap_mim
C$63 \$0$16 TOP_N\x7cVINN 8.664e-15
* device instance $64 r0 *1 0,0 sky130_fd_pr__model__cap_mim
C$64 \$0$7 TOP_P\x7cVINP 8.664e-15
* device instance $65 r0 *1 0,0 sky130_fd_pr__model__cap_mim
C$65 \$0$16 TOP_N\x7cVINN 8.664e-15
* device instance $66 r0 *1 0,0 sky130_fd_pr__model__cap_mim
C$66 \$0$7 TOP_P\x7cVINP 8.664e-15
* device instance $67 r0 *1 0,0 sky130_fd_pr__model__cap_mim
C$67 \$0$16 TOP_N\x7cVINN 8.664e-15
* device instance $68 r0 *1 0,0 sky130_fd_pr__model__cap_mim
C$68 \$0$7 TOP_P\x7cVINP 8.664e-15
* device instance $69 r0 *1 0,0 sky130_fd_pr__model__cap_mim
C$69 \$0$8 TOP_P\x7cVINP 8.664e-15
* device instance $70 r0 *1 0,0 sky130_fd_pr__model__cap_mim
C$70 \$0$17 TOP_N\x7cVINN 8.664e-15
* device instance $71 r0 *1 0,0 sky130_fd_pr__model__cap_mim
C$71 \$0$8 TOP_P\x7cVINP 8.664e-15
* device instance $72 r0 *1 0,0 sky130_fd_pr__model__cap_mim
C$72 \$0$17 TOP_N\x7cVINN 8.664e-15
* device instance $73 r0 *1 0,0 sky130_fd_pr__model__cap_mim
C$73 \$0$8 TOP_P\x7cVINP 8.664e-15
* device instance $74 r0 *1 0,0 sky130_fd_pr__model__cap_mim
C$74 \$0$17 TOP_N\x7cVINN 8.664e-15
* device instance $75 r0 *1 0,0 sky130_fd_pr__model__cap_mim
C$75 \$0$8 TOP_P\x7cVINP 8.664e-15
* device instance $76 r0 *1 0,0 sky130_fd_pr__model__cap_mim
C$76 \$0$17 TOP_N\x7cVINN 8.664e-15
* device instance $77 r0 *1 0,0 sky130_fd_pr__model__cap_mim
C$77 \$0$17 TOP_N\x7cVINN 8.664e-15
* device instance $78 r0 *1 0,0 sky130_fd_pr__model__cap_mim
C$78 \$0$8 TOP_P\x7cVINP 8.664e-15
* device instance $79 r0 *1 0,0 sky130_fd_pr__model__cap_mim
C$79 \$0$17 TOP_N\x7cVINN 8.664e-15
* device instance $80 r0 *1 0,0 sky130_fd_pr__model__cap_mim
C$80 \$0$8 TOP_P\x7cVINP 8.664e-15
* device instance $81 r0 *1 0,0 sky130_fd_pr__model__cap_mim
C$81 \$0$17 TOP_N\x7cVINN 8.664e-15
* device instance $82 r0 *1 0,0 sky130_fd_pr__model__cap_mim
C$82 \$0$8 TOP_P\x7cVINP 8.664e-15
* device instance $83 r0 *1 0,0 sky130_fd_pr__model__cap_mim
C$83 \$0$17 TOP_N\x7cVINN 8.664e-15
* device instance $84 r0 *1 0,0 sky130_fd_pr__model__cap_mim
C$84 \$0$8 TOP_P\x7cVINP 8.664e-15
* device instance $85 r0 *1 0,0 sky130_fd_pr__model__cap_mim
C$85 \$0$6 TOP_P\x7cVINP 8.664e-15
* device instance $86 r0 *1 0,0 sky130_fd_pr__model__cap_mim
C$86 \$0$15 TOP_N\x7cVINN 8.664e-15
* device instance $87 r0 *1 0,0 sky130_fd_pr__model__cap_mim
C$87 \$0$6 TOP_P\x7cVINP 8.664e-15
* device instance $88 r0 *1 0,0 sky130_fd_pr__model__cap_mim
C$88 \$0$15 TOP_N\x7cVINN 8.664e-15
* device instance $89 r0 *1 0,0 sky130_fd_pr__model__cap_mim
C$89 \$0$6 TOP_P\x7cVINP 8.664e-15
* device instance $90 r0 *1 0,0 sky130_fd_pr__model__cap_mim
C$90 \$0$15 TOP_N\x7cVINN 8.664e-15
* device instance $91 r0 *1 0,0 sky130_fd_pr__model__cap_mim
C$91 \$0$6 TOP_P\x7cVINP 8.664e-15
* device instance $92 r0 *1 0,0 sky130_fd_pr__model__cap_mim
C$92 \$0$15 TOP_N\x7cVINN 8.664e-15
* device instance $93 r0 *1 0,0 sky130_fd_pr__model__cap_mim
C$93 \$0$15 TOP_N\x7cVINN 8.664e-15
* device instance $94 r0 *1 0,0 sky130_fd_pr__model__cap_mim
C$94 \$0$6 TOP_P\x7cVINP 8.664e-15
* device instance $95 r0 *1 0,0 sky130_fd_pr__model__cap_mim
C$95 \$0$15 TOP_N\x7cVINN 8.664e-15
* device instance $96 r0 *1 0,0 sky130_fd_pr__model__cap_mim
C$96 \$0$6 TOP_P\x7cVINP 8.664e-15
* device instance $97 r0 *1 0,0 sky130_fd_pr__model__cap_mim
C$97 \$0$15 TOP_N\x7cVINN 8.664e-15
* device instance $98 r0 *1 0,0 sky130_fd_pr__model__cap_mim
C$98 \$0$6 TOP_P\x7cVINP 8.664e-15
* device instance $99 r0 *1 0,0 sky130_fd_pr__model__cap_mim
C$99 \$0$15 TOP_N\x7cVINN 8.664e-15
* device instance $100 r0 *1 0,0 sky130_fd_pr__model__cap_mim
C$100 \$0$6 TOP_P\x7cVINP 8.664e-15
* device instance $101 r0 *1 0,0 sky130_fd_pr__model__cap_mim
C$101 \$0$8 TOP_P\x7cVINP 8.664e-15
* device instance $102 r0 *1 0,0 sky130_fd_pr__model__cap_mim
C$102 \$0$17 TOP_N\x7cVINN 8.664e-15
* device instance $103 r0 *1 0,0 sky130_fd_pr__model__cap_mim
C$103 \$0$8 TOP_P\x7cVINP 8.664e-15
* device instance $104 r0 *1 0,0 sky130_fd_pr__model__cap_mim
C$104 \$0$17 TOP_N\x7cVINN 8.664e-15
* device instance $105 r0 *1 0,0 sky130_fd_pr__model__cap_mim
C$105 \$0$8 TOP_P\x7cVINP 8.664e-15
* device instance $106 r0 *1 0,0 sky130_fd_pr__model__cap_mim
C$106 \$0$17 TOP_N\x7cVINN 8.664e-15
* device instance $107 r0 *1 0,0 sky130_fd_pr__model__cap_mim
C$107 \$0$8 TOP_P\x7cVINP 8.664e-15
* device instance $108 r0 *1 0,0 sky130_fd_pr__model__cap_mim
C$108 \$0$17 TOP_N\x7cVINN 8.664e-15
* device instance $109 r0 *1 0,0 sky130_fd_pr__model__cap_mim
C$109 \$0$17 TOP_N\x7cVINN 8.664e-15
* device instance $110 r0 *1 0,0 sky130_fd_pr__model__cap_mim
C$110 \$0$8 TOP_P\x7cVINP 8.664e-15
* device instance $111 r0 *1 0,0 sky130_fd_pr__model__cap_mim
C$111 \$0$17 TOP_N\x7cVINN 8.664e-15
* device instance $112 r0 *1 0,0 sky130_fd_pr__model__cap_mim
C$112 \$0$8 TOP_P\x7cVINP 8.664e-15
* device instance $113 r0 *1 0,0 sky130_fd_pr__model__cap_mim
C$113 \$0$17 TOP_N\x7cVINN 8.664e-15
* device instance $114 r0 *1 0,0 sky130_fd_pr__model__cap_mim
C$114 \$0$8 TOP_P\x7cVINP 8.664e-15
* device instance $115 r0 *1 0,0 sky130_fd_pr__model__cap_mim
C$115 \$0$17 TOP_N\x7cVINN 8.664e-15
* device instance $116 r0 *1 0,0 sky130_fd_pr__model__cap_mim
C$116 \$0$8 TOP_P\x7cVINP 8.664e-15
* device instance $117 r0 *1 0,0 sky130_fd_pr__model__cap_mim
C$117 \$0$7 TOP_P\x7cVINP 8.664e-15
* device instance $118 r0 *1 0,0 sky130_fd_pr__model__cap_mim
C$118 \$0$16 TOP_N\x7cVINN 8.664e-15
* device instance $119 r0 *1 0,0 sky130_fd_pr__model__cap_mim
C$119 \$0$7 TOP_P\x7cVINP 8.664e-15
* device instance $120 r0 *1 0,0 sky130_fd_pr__model__cap_mim
C$120 \$0$16 TOP_N\x7cVINN 8.664e-15
* device instance $121 r0 *1 0,0 sky130_fd_pr__model__cap_mim
C$121 \$0$7 TOP_P\x7cVINP 8.664e-15
* device instance $122 r0 *1 0,0 sky130_fd_pr__model__cap_mim
C$122 \$0$16 TOP_N\x7cVINN 8.664e-15
* device instance $123 r0 *1 0,0 sky130_fd_pr__model__cap_mim
C$123 \$0$7 TOP_P\x7cVINP 8.664e-15
* device instance $124 r0 *1 0,0 sky130_fd_pr__model__cap_mim
C$124 \$0$16 TOP_N\x7cVINN 8.664e-15
* device instance $125 r0 *1 0,0 sky130_fd_pr__model__cap_mim
C$125 \$0$16 TOP_N\x7cVINN 8.664e-15
* device instance $126 r0 *1 0,0 sky130_fd_pr__model__cap_mim
C$126 \$0$7 TOP_P\x7cVINP 8.664e-15
* device instance $127 r0 *1 0,0 sky130_fd_pr__model__cap_mim
C$127 \$0$16 TOP_N\x7cVINN 8.664e-15
* device instance $128 r0 *1 0,0 sky130_fd_pr__model__cap_mim
C$128 \$0$7 TOP_P\x7cVINP 8.664e-15
* device instance $129 r0 *1 0,0 sky130_fd_pr__model__cap_mim
C$129 \$0$16 TOP_N\x7cVINN 8.664e-15
* device instance $130 r0 *1 0,0 sky130_fd_pr__model__cap_mim
C$130 \$0$7 TOP_P\x7cVINP 8.664e-15
* device instance $131 r0 *1 0,0 sky130_fd_pr__model__cap_mim
C$131 \$0$16 TOP_N\x7cVINN 8.664e-15
* device instance $132 r0 *1 0,0 sky130_fd_pr__model__cap_mim
C$132 \$0$7 TOP_P\x7cVINP 8.664e-15
* device instance $133 r0 *1 0,0 sky130_fd_pr__model__cap_mim
C$133 \$0$8 TOP_P\x7cVINP 8.664e-15
* device instance $134 r0 *1 0,0 sky130_fd_pr__model__cap_mim
C$134 \$0$17 TOP_N\x7cVINN 8.664e-15
* device instance $135 r0 *1 0,0 sky130_fd_pr__model__cap_mim
C$135 \$0$8 TOP_P\x7cVINP 8.664e-15
* device instance $136 r0 *1 0,0 sky130_fd_pr__model__cap_mim
C$136 \$0$17 TOP_N\x7cVINN 8.664e-15
* device instance $137 r0 *1 0,0 sky130_fd_pr__model__cap_mim
C$137 \$0$8 TOP_P\x7cVINP 8.664e-15
* device instance $138 r0 *1 0,0 sky130_fd_pr__model__cap_mim
C$138 \$0$17 TOP_N\x7cVINN 8.664e-15
* device instance $139 r0 *1 0,0 sky130_fd_pr__model__cap_mim
C$139 \$0$8 TOP_P\x7cVINP 8.664e-15
* device instance $140 r0 *1 0,0 sky130_fd_pr__model__cap_mim
C$140 \$0$17 TOP_N\x7cVINN 8.664e-15
* device instance $141 r0 *1 0,0 sky130_fd_pr__model__cap_mim
C$141 \$0$17 TOP_N\x7cVINN 8.664e-15
* device instance $142 r0 *1 0,0 sky130_fd_pr__model__cap_mim
C$142 \$0$8 TOP_P\x7cVINP 8.664e-15
* device instance $143 r0 *1 0,0 sky130_fd_pr__model__cap_mim
C$143 \$0$17 TOP_N\x7cVINN 8.664e-15
* device instance $144 r0 *1 0,0 sky130_fd_pr__model__cap_mim
C$144 \$0$8 TOP_P\x7cVINP 8.664e-15
* device instance $145 r0 *1 0,0 sky130_fd_pr__model__cap_mim
C$145 \$0$17 TOP_N\x7cVINN 8.664e-15
* device instance $146 r0 *1 0,0 sky130_fd_pr__model__cap_mim
C$146 \$0$8 TOP_P\x7cVINP 8.664e-15
* device instance $147 r0 *1 0,0 sky130_fd_pr__model__cap_mim
C$147 \$0$17 TOP_N\x7cVINN 8.664e-15
* device instance $148 r0 *1 0,0 sky130_fd_pr__model__cap_mim
C$148 \$0$8 TOP_P\x7cVINP 8.664e-15
* device instance $149 r0 *1 0,0 sky130_fd_pr__model__cap_mim
C$149 \$0$5 TOP_P\x7cVINP 8.664e-15
* device instance $150 r0 *1 0,0 sky130_fd_pr__model__cap_mim
C$150 \$0$14 TOP_N\x7cVINN 8.664e-15
* device instance $151 r0 *1 0,0 sky130_fd_pr__model__cap_mim
C$151 \$0$5 TOP_P\x7cVINP 8.664e-15
* device instance $152 r0 *1 0,0 sky130_fd_pr__model__cap_mim
C$152 \$0$14 TOP_N\x7cVINN 8.664e-15
* device instance $153 r0 *1 0,0 sky130_fd_pr__model__cap_mim
C$153 \$0$5 TOP_P\x7cVINP 8.664e-15
* device instance $154 r0 *1 0,0 sky130_fd_pr__model__cap_mim
C$154 \$0$14 TOP_N\x7cVINN 8.664e-15
* device instance $155 r0 *1 0,0 sky130_fd_pr__model__cap_mim
C$155 \$0$5 TOP_P\x7cVINP 8.664e-15
* device instance $156 r0 *1 0,0 sky130_fd_pr__model__cap_mim
C$156 \$0$14 TOP_N\x7cVINN 8.664e-15
* device instance $157 r0 *1 0,0 sky130_fd_pr__model__cap_mim
C$157 \$0$14 TOP_N\x7cVINN 8.664e-15
* device instance $158 r0 *1 0,0 sky130_fd_pr__model__cap_mim
C$158 \$0$5 TOP_P\x7cVINP 8.664e-15
* device instance $159 r0 *1 0,0 sky130_fd_pr__model__cap_mim
C$159 \$0$14 TOP_N\x7cVINN 8.664e-15
* device instance $160 r0 *1 0,0 sky130_fd_pr__model__cap_mim
C$160 \$0$5 TOP_P\x7cVINP 8.664e-15
* device instance $161 r0 *1 0,0 sky130_fd_pr__model__cap_mim
C$161 \$0$14 TOP_N\x7cVINN 8.664e-15
* device instance $162 r0 *1 0,0 sky130_fd_pr__model__cap_mim
C$162 \$0$5 TOP_P\x7cVINP 8.664e-15
* device instance $163 r0 *1 0,0 sky130_fd_pr__model__cap_mim
C$163 \$0$14 TOP_N\x7cVINN 8.664e-15
* device instance $164 r0 *1 0,0 sky130_fd_pr__model__cap_mim
C$164 \$0$5 TOP_P\x7cVINP 8.664e-15
* device instance $165 r0 *1 0,0 sky130_fd_pr__model__cap_mim
C$165 \$0$8 TOP_P\x7cVINP 8.664e-15
* device instance $166 r0 *1 0,0 sky130_fd_pr__model__cap_mim
C$166 \$0$17 TOP_N\x7cVINN 8.664e-15
* device instance $167 r0 *1 0,0 sky130_fd_pr__model__cap_mim
C$167 \$0$8 TOP_P\x7cVINP 8.664e-15
* device instance $168 r0 *1 0,0 sky130_fd_pr__model__cap_mim
C$168 \$0$17 TOP_N\x7cVINN 8.664e-15
* device instance $169 r0 *1 0,0 sky130_fd_pr__model__cap_mim
C$169 \$0$8 TOP_P\x7cVINP 8.664e-15
* device instance $170 r0 *1 0,0 sky130_fd_pr__model__cap_mim
C$170 \$0$17 TOP_N\x7cVINN 8.664e-15
* device instance $171 r0 *1 0,0 sky130_fd_pr__model__cap_mim
C$171 \$0$8 TOP_P\x7cVINP 8.664e-15
* device instance $172 r0 *1 0,0 sky130_fd_pr__model__cap_mim
C$172 \$0$17 TOP_N\x7cVINN 8.664e-15
* device instance $173 r0 *1 0,0 sky130_fd_pr__model__cap_mim
C$173 \$0$17 TOP_N\x7cVINN 8.664e-15
* device instance $174 r0 *1 0,0 sky130_fd_pr__model__cap_mim
C$174 \$0$8 TOP_P\x7cVINP 8.664e-15
* device instance $175 r0 *1 0,0 sky130_fd_pr__model__cap_mim
C$175 \$0$17 TOP_N\x7cVINN 8.664e-15
* device instance $176 r0 *1 0,0 sky130_fd_pr__model__cap_mim
C$176 \$0$8 TOP_P\x7cVINP 8.664e-15
* device instance $177 r0 *1 0,0 sky130_fd_pr__model__cap_mim
C$177 \$0$17 TOP_N\x7cVINN 8.664e-15
* device instance $178 r0 *1 0,0 sky130_fd_pr__model__cap_mim
C$178 \$0$8 TOP_P\x7cVINP 8.664e-15
* device instance $179 r0 *1 0,0 sky130_fd_pr__model__cap_mim
C$179 \$0$17 TOP_N\x7cVINN 8.664e-15
* device instance $180 r0 *1 0,0 sky130_fd_pr__model__cap_mim
C$180 \$0$8 TOP_P\x7cVINP 8.664e-15
* device instance $181 r0 *1 0,0 sky130_fd_pr__model__cap_mim
C$181 \$0$7 TOP_P\x7cVINP 8.664e-15
* device instance $182 r0 *1 0,0 sky130_fd_pr__model__cap_mim
C$182 \$0$16 TOP_N\x7cVINN 8.664e-15
* device instance $183 r0 *1 0,0 sky130_fd_pr__model__cap_mim
C$183 \$0$7 TOP_P\x7cVINP 8.664e-15
* device instance $184 r0 *1 0,0 sky130_fd_pr__model__cap_mim
C$184 \$0$16 TOP_N\x7cVINN 8.664e-15
* device instance $185 r0 *1 0,0 sky130_fd_pr__model__cap_mim
C$185 \$0$7 TOP_P\x7cVINP 8.664e-15
* device instance $186 r0 *1 0,0 sky130_fd_pr__model__cap_mim
C$186 \$0$16 TOP_N\x7cVINN 8.664e-15
* device instance $187 r0 *1 0,0 sky130_fd_pr__model__cap_mim
C$187 \$0$7 TOP_P\x7cVINP 8.664e-15
* device instance $188 r0 *1 0,0 sky130_fd_pr__model__cap_mim
C$188 \$0$16 TOP_N\x7cVINN 8.664e-15
* device instance $189 r0 *1 0,0 sky130_fd_pr__model__cap_mim
C$189 \$0$16 TOP_N\x7cVINN 8.664e-15
* device instance $190 r0 *1 0,0 sky130_fd_pr__model__cap_mim
C$190 \$0$7 TOP_P\x7cVINP 8.664e-15
* device instance $191 r0 *1 0,0 sky130_fd_pr__model__cap_mim
C$191 \$0$16 TOP_N\x7cVINN 8.664e-15
* device instance $192 r0 *1 0,0 sky130_fd_pr__model__cap_mim
C$192 \$0$7 TOP_P\x7cVINP 8.664e-15
* device instance $193 r0 *1 0,0 sky130_fd_pr__model__cap_mim
C$193 \$0$16 TOP_N\x7cVINN 8.664e-15
* device instance $194 r0 *1 0,0 sky130_fd_pr__model__cap_mim
C$194 \$0$7 TOP_P\x7cVINP 8.664e-15
* device instance $195 r0 *1 0,0 sky130_fd_pr__model__cap_mim
C$195 \$0$16 TOP_N\x7cVINN 8.664e-15
* device instance $196 r0 *1 0,0 sky130_fd_pr__model__cap_mim
C$196 \$0$7 TOP_P\x7cVINP 8.664e-15
* device instance $197 r0 *1 0,0 sky130_fd_pr__model__cap_mim
C$197 \$0$8 TOP_P\x7cVINP 8.664e-15
* device instance $198 r0 *1 0,0 sky130_fd_pr__model__cap_mim
C$198 \$0$17 TOP_N\x7cVINN 8.664e-15
* device instance $199 r0 *1 0,0 sky130_fd_pr__model__cap_mim
C$199 \$0$8 TOP_P\x7cVINP 8.664e-15
* device instance $200 r0 *1 0,0 sky130_fd_pr__model__cap_mim
C$200 \$0$17 TOP_N\x7cVINN 8.664e-15
* device instance $201 r0 *1 0,0 sky130_fd_pr__model__cap_mim
C$201 \$0$8 TOP_P\x7cVINP 8.664e-15
* device instance $202 r0 *1 0,0 sky130_fd_pr__model__cap_mim
C$202 \$0$17 TOP_N\x7cVINN 8.664e-15
* device instance $203 r0 *1 0,0 sky130_fd_pr__model__cap_mim
C$203 \$0$8 TOP_P\x7cVINP 8.664e-15
* device instance $204 r0 *1 0,0 sky130_fd_pr__model__cap_mim
C$204 \$0$17 TOP_N\x7cVINN 8.664e-15
* device instance $205 r0 *1 0,0 sky130_fd_pr__model__cap_mim
C$205 \$0$17 TOP_N\x7cVINN 8.664e-15
* device instance $206 r0 *1 0,0 sky130_fd_pr__model__cap_mim
C$206 \$0$8 TOP_P\x7cVINP 8.664e-15
* device instance $207 r0 *1 0,0 sky130_fd_pr__model__cap_mim
C$207 \$0$17 TOP_N\x7cVINN 8.664e-15
* device instance $208 r0 *1 0,0 sky130_fd_pr__model__cap_mim
C$208 \$0$8 TOP_P\x7cVINP 8.664e-15
* device instance $209 r0 *1 0,0 sky130_fd_pr__model__cap_mim
C$209 \$0$17 TOP_N\x7cVINN 8.664e-15
* device instance $210 r0 *1 0,0 sky130_fd_pr__model__cap_mim
C$210 \$0$8 TOP_P\x7cVINP 8.664e-15
* device instance $211 r0 *1 0,0 sky130_fd_pr__model__cap_mim
C$211 \$0$17 TOP_N\x7cVINN 8.664e-15
* device instance $212 r0 *1 0,0 sky130_fd_pr__model__cap_mim
C$212 \$0$8 TOP_P\x7cVINP 8.664e-15
* device instance $213 r0 *1 0,0 sky130_fd_pr__model__cap_mim
C$213 \$0$6 TOP_P\x7cVINP 8.664e-15
* device instance $214 r0 *1 0,0 sky130_fd_pr__model__cap_mim
C$214 \$0$15 TOP_N\x7cVINN 8.664e-15
* device instance $215 r0 *1 0,0 sky130_fd_pr__model__cap_mim
C$215 \$0$6 TOP_P\x7cVINP 8.664e-15
* device instance $216 r0 *1 0,0 sky130_fd_pr__model__cap_mim
C$216 \$0$15 TOP_N\x7cVINN 8.664e-15
* device instance $217 r0 *1 0,0 sky130_fd_pr__model__cap_mim
C$217 \$0$6 TOP_P\x7cVINP 8.664e-15
* device instance $218 r0 *1 0,0 sky130_fd_pr__model__cap_mim
C$218 \$0$15 TOP_N\x7cVINN 8.664e-15
* device instance $219 r0 *1 0,0 sky130_fd_pr__model__cap_mim
C$219 \$0$6 TOP_P\x7cVINP 8.664e-15
* device instance $220 r0 *1 0,0 sky130_fd_pr__model__cap_mim
C$220 \$0$15 TOP_N\x7cVINN 8.664e-15
* device instance $221 r0 *1 0,0 sky130_fd_pr__model__cap_mim
C$221 \$0$15 TOP_N\x7cVINN 8.664e-15
* device instance $222 r0 *1 0,0 sky130_fd_pr__model__cap_mim
C$222 \$0$6 TOP_P\x7cVINP 8.664e-15
* device instance $223 r0 *1 0,0 sky130_fd_pr__model__cap_mim
C$223 \$0$15 TOP_N\x7cVINN 8.664e-15
* device instance $224 r0 *1 0,0 sky130_fd_pr__model__cap_mim
C$224 \$0$6 TOP_P\x7cVINP 8.664e-15
* device instance $225 r0 *1 0,0 sky130_fd_pr__model__cap_mim
C$225 \$0$15 TOP_N\x7cVINN 8.664e-15
* device instance $226 r0 *1 0,0 sky130_fd_pr__model__cap_mim
C$226 \$0$6 TOP_P\x7cVINP 8.664e-15
* device instance $227 r0 *1 0,0 sky130_fd_pr__model__cap_mim
C$227 \$0$15 TOP_N\x7cVINN 8.664e-15
* device instance $228 r0 *1 0,0 sky130_fd_pr__model__cap_mim
C$228 \$0$6 TOP_P\x7cVINP 8.664e-15
* device instance $229 r0 *1 0,0 sky130_fd_pr__model__cap_mim
C$229 \$0$8 TOP_P\x7cVINP 8.664e-15
* device instance $230 r0 *1 0,0 sky130_fd_pr__model__cap_mim
C$230 \$0$17 TOP_N\x7cVINN 8.664e-15
* device instance $231 r0 *1 0,0 sky130_fd_pr__model__cap_mim
C$231 \$0$8 TOP_P\x7cVINP 8.664e-15
* device instance $232 r0 *1 0,0 sky130_fd_pr__model__cap_mim
C$232 \$0$17 TOP_N\x7cVINN 8.664e-15
* device instance $233 r0 *1 0,0 sky130_fd_pr__model__cap_mim
C$233 \$0$8 TOP_P\x7cVINP 8.664e-15
* device instance $234 r0 *1 0,0 sky130_fd_pr__model__cap_mim
C$234 \$0$17 TOP_N\x7cVINN 8.664e-15
* device instance $235 r0 *1 0,0 sky130_fd_pr__model__cap_mim
C$235 \$0$8 TOP_P\x7cVINP 8.664e-15
* device instance $236 r0 *1 0,0 sky130_fd_pr__model__cap_mim
C$236 \$0$17 TOP_N\x7cVINN 8.664e-15
* device instance $237 r0 *1 0,0 sky130_fd_pr__model__cap_mim
C$237 \$0$17 TOP_N\x7cVINN 8.664e-15
* device instance $238 r0 *1 0,0 sky130_fd_pr__model__cap_mim
C$238 \$0$8 TOP_P\x7cVINP 8.664e-15
* device instance $239 r0 *1 0,0 sky130_fd_pr__model__cap_mim
C$239 \$0$17 TOP_N\x7cVINN 8.664e-15
* device instance $240 r0 *1 0,0 sky130_fd_pr__model__cap_mim
C$240 \$0$8 TOP_P\x7cVINP 8.664e-15
* device instance $241 r0 *1 0,0 sky130_fd_pr__model__cap_mim
C$241 \$0$17 TOP_N\x7cVINN 8.664e-15
* device instance $242 r0 *1 0,0 sky130_fd_pr__model__cap_mim
C$242 \$0$8 TOP_P\x7cVINP 8.664e-15
* device instance $243 r0 *1 0,0 sky130_fd_pr__model__cap_mim
C$243 \$0$17 TOP_N\x7cVINN 8.664e-15
* device instance $244 r0 *1 0,0 sky130_fd_pr__model__cap_mim
C$244 \$0$8 TOP_P\x7cVINP 8.664e-15
* device instance $245 r0 *1 0,0 sky130_fd_pr__model__cap_mim
C$245 \$0$7 TOP_P\x7cVINP 8.664e-15
* device instance $246 r0 *1 0,0 sky130_fd_pr__model__cap_mim
C$246 \$0$16 TOP_N\x7cVINN 8.664e-15
* device instance $247 r0 *1 0,0 sky130_fd_pr__model__cap_mim
C$247 \$0$7 TOP_P\x7cVINP 8.664e-15
* device instance $248 r0 *1 0,0 sky130_fd_pr__model__cap_mim
C$248 \$0$16 TOP_N\x7cVINN 8.664e-15
* device instance $249 r0 *1 0,0 sky130_fd_pr__model__cap_mim
C$249 \$0$7 TOP_P\x7cVINP 8.664e-15
* device instance $250 r0 *1 0,0 sky130_fd_pr__model__cap_mim
C$250 \$0$16 TOP_N\x7cVINN 8.664e-15
* device instance $251 r0 *1 0,0 sky130_fd_pr__model__cap_mim
C$251 \$0$7 TOP_P\x7cVINP 8.664e-15
* device instance $252 r0 *1 0,0 sky130_fd_pr__model__cap_mim
C$252 \$0$16 TOP_N\x7cVINN 8.664e-15
* device instance $253 r0 *1 0,0 sky130_fd_pr__model__cap_mim
C$253 \$0$16 TOP_N\x7cVINN 8.664e-15
* device instance $254 r0 *1 0,0 sky130_fd_pr__model__cap_mim
C$254 \$0$7 TOP_P\x7cVINP 8.664e-15
* device instance $255 r0 *1 0,0 sky130_fd_pr__model__cap_mim
C$255 \$0$16 TOP_N\x7cVINN 8.664e-15
* device instance $256 r0 *1 0,0 sky130_fd_pr__model__cap_mim
C$256 \$0$7 TOP_P\x7cVINP 8.664e-15
* device instance $257 r0 *1 0,0 sky130_fd_pr__model__cap_mim
C$257 \$0$16 TOP_N\x7cVINN 8.664e-15
* device instance $258 r0 *1 0,0 sky130_fd_pr__model__cap_mim
C$258 \$0$7 TOP_P\x7cVINP 8.664e-15
* device instance $259 r0 *1 0,0 sky130_fd_pr__model__cap_mim
C$259 \$0$16 TOP_N\x7cVINN 8.664e-15
* device instance $260 r0 *1 0,0 sky130_fd_pr__model__cap_mim
C$260 \$0$7 TOP_P\x7cVINP 8.664e-15
* device instance $261 r0 *1 0,0 sky130_fd_pr__model__cap_mim
C$261 \$0$8 TOP_P\x7cVINP 8.664e-15
* device instance $262 r0 *1 0,0 sky130_fd_pr__model__cap_mim
C$262 \$0$17 TOP_N\x7cVINN 8.664e-15
* device instance $263 r0 *1 0,0 sky130_fd_pr__model__cap_mim
C$263 \$0$8 TOP_P\x7cVINP 8.664e-15
* device instance $264 r0 *1 0,0 sky130_fd_pr__model__cap_mim
C$264 \$0$17 TOP_N\x7cVINN 8.664e-15
* device instance $265 r0 *1 0,0 sky130_fd_pr__model__cap_mim
C$265 \$0$8 TOP_P\x7cVINP 8.664e-15
* device instance $266 r0 *1 0,0 sky130_fd_pr__model__cap_mim
C$266 \$0$17 TOP_N\x7cVINN 8.664e-15
* device instance $267 r0 *1 0,0 sky130_fd_pr__model__cap_mim
C$267 \$0$8 TOP_P\x7cVINP 8.664e-15
* device instance $268 r0 *1 0,0 sky130_fd_pr__model__cap_mim
C$268 \$0$17 TOP_N\x7cVINN 8.664e-15
* device instance $269 r0 *1 0,0 sky130_fd_pr__model__cap_mim
C$269 \$0$17 TOP_N\x7cVINN 8.664e-15
* device instance $270 r0 *1 0,0 sky130_fd_pr__model__cap_mim
C$270 \$0$8 TOP_P\x7cVINP 8.664e-15
* device instance $271 r0 *1 0,0 sky130_fd_pr__model__cap_mim
C$271 \$0$17 TOP_N\x7cVINN 8.664e-15
* device instance $272 r0 *1 0,0 sky130_fd_pr__model__cap_mim
C$272 \$0$8 TOP_P\x7cVINP 8.664e-15
* device instance $273 r0 *1 0,0 sky130_fd_pr__model__cap_mim
C$273 \$0$17 TOP_N\x7cVINN 8.664e-15
* device instance $274 r0 *1 0,0 sky130_fd_pr__model__cap_mim
C$274 \$0$8 TOP_P\x7cVINP 8.664e-15
* device instance $275 r0 *1 0,0 sky130_fd_pr__model__cap_mim
C$275 \$0$17 TOP_N\x7cVINN 8.664e-15
* device instance $276 r0 *1 0,0 sky130_fd_pr__model__cap_mim
C$276 \$0$8 TOP_P\x7cVINP 8.664e-15
* device instance $277 r0 *1 0,0 sky130_fd_pr__model__cap_mim
C$277 \$0$4 TOP_P\x7cVINP 8.664e-15
* device instance $278 r0 *1 0,0 sky130_fd_pr__model__cap_mim
C$278 \$0$13 TOP_N\x7cVINN 8.664e-15
* device instance $279 r0 *1 0,0 sky130_fd_pr__model__cap_mim
C$279 \$0$4 TOP_P\x7cVINP 8.664e-15
* device instance $280 r0 *1 0,0 sky130_fd_pr__model__cap_mim
C$280 \$0$13 TOP_N\x7cVINN 8.664e-15
* device instance $281 r0 *1 0,0 sky130_fd_pr__model__cap_mim
C$281 \$0$4 TOP_P\x7cVINP 8.664e-15
* device instance $282 r0 *1 0,0 sky130_fd_pr__model__cap_mim
C$282 \$0$13 TOP_N\x7cVINN 8.664e-15
* device instance $283 r0 *1 0,0 sky130_fd_pr__model__cap_mim
C$283 \$0$4 TOP_P\x7cVINP 8.664e-15
* device instance $284 r0 *1 0,0 sky130_fd_pr__model__cap_mim
C$284 \$0$13 TOP_N\x7cVINN 8.664e-15
* device instance $285 r0 *1 0,0 sky130_fd_pr__model__cap_mim
C$285 \$0$13 TOP_N\x7cVINN 8.664e-15
* device instance $286 r0 *1 0,0 sky130_fd_pr__model__cap_mim
C$286 \$0$4 TOP_P\x7cVINP 8.664e-15
* device instance $287 r0 *1 0,0 sky130_fd_pr__model__cap_mim
C$287 \$0$13 TOP_N\x7cVINN 8.664e-15
* device instance $288 r0 *1 0,0 sky130_fd_pr__model__cap_mim
C$288 \$0$4 TOP_P\x7cVINP 8.664e-15
* device instance $289 r0 *1 0,0 sky130_fd_pr__model__cap_mim
C$289 \$0$13 TOP_N\x7cVINN 8.664e-15
* device instance $290 r0 *1 0,0 sky130_fd_pr__model__cap_mim
C$290 \$0$4 TOP_P\x7cVINP 8.664e-15
* device instance $291 r0 *1 0,0 sky130_fd_pr__model__cap_mim
C$291 \$0$13 TOP_N\x7cVINN 8.664e-15
* device instance $292 r0 *1 0,0 sky130_fd_pr__model__cap_mim
C$292 \$0$4 TOP_P\x7cVINP 8.664e-15
* device instance $293 r0 *1 0,0 sky130_fd_pr__model__cap_mim
C$293 \$0$8 TOP_P\x7cVINP 8.664e-15
* device instance $294 r0 *1 0,0 sky130_fd_pr__model__cap_mim
C$294 \$0$17 TOP_N\x7cVINN 8.664e-15
* device instance $295 r0 *1 0,0 sky130_fd_pr__model__cap_mim
C$295 \$0$8 TOP_P\x7cVINP 8.664e-15
* device instance $296 r0 *1 0,0 sky130_fd_pr__model__cap_mim
C$296 \$0$17 TOP_N\x7cVINN 8.664e-15
* device instance $297 r0 *1 0,0 sky130_fd_pr__model__cap_mim
C$297 \$0$8 TOP_P\x7cVINP 8.664e-15
* device instance $298 r0 *1 0,0 sky130_fd_pr__model__cap_mim
C$298 \$0$17 TOP_N\x7cVINN 8.664e-15
* device instance $299 r0 *1 0,0 sky130_fd_pr__model__cap_mim
C$299 \$0$8 TOP_P\x7cVINP 8.664e-15
* device instance $300 r0 *1 0,0 sky130_fd_pr__model__cap_mim
C$300 \$0$17 TOP_N\x7cVINN 8.664e-15
* device instance $301 r0 *1 0,0 sky130_fd_pr__model__cap_mim
C$301 \$0$17 TOP_N\x7cVINN 8.664e-15
* device instance $302 r0 *1 0,0 sky130_fd_pr__model__cap_mim
C$302 \$0$8 TOP_P\x7cVINP 8.664e-15
* device instance $303 r0 *1 0,0 sky130_fd_pr__model__cap_mim
C$303 \$0$17 TOP_N\x7cVINN 8.664e-15
* device instance $304 r0 *1 0,0 sky130_fd_pr__model__cap_mim
C$304 \$0$8 TOP_P\x7cVINP 8.664e-15
* device instance $305 r0 *1 0,0 sky130_fd_pr__model__cap_mim
C$305 \$0$17 TOP_N\x7cVINN 8.664e-15
* device instance $306 r0 *1 0,0 sky130_fd_pr__model__cap_mim
C$306 \$0$8 TOP_P\x7cVINP 8.664e-15
* device instance $307 r0 *1 0,0 sky130_fd_pr__model__cap_mim
C$307 \$0$17 TOP_N\x7cVINN 8.664e-15
* device instance $308 r0 *1 0,0 sky130_fd_pr__model__cap_mim
C$308 \$0$8 TOP_P\x7cVINP 8.664e-15
* device instance $309 r0 *1 0,0 sky130_fd_pr__model__cap_mim
C$309 \$0$7 TOP_P\x7cVINP 8.664e-15
* device instance $310 r0 *1 0,0 sky130_fd_pr__model__cap_mim
C$310 \$0$16 TOP_N\x7cVINN 8.664e-15
* device instance $311 r0 *1 0,0 sky130_fd_pr__model__cap_mim
C$311 \$0$7 TOP_P\x7cVINP 8.664e-15
* device instance $312 r0 *1 0,0 sky130_fd_pr__model__cap_mim
C$312 \$0$16 TOP_N\x7cVINN 8.664e-15
* device instance $313 r0 *1 0,0 sky130_fd_pr__model__cap_mim
C$313 \$0$7 TOP_P\x7cVINP 8.664e-15
* device instance $314 r0 *1 0,0 sky130_fd_pr__model__cap_mim
C$314 \$0$16 TOP_N\x7cVINN 8.664e-15
* device instance $315 r0 *1 0,0 sky130_fd_pr__model__cap_mim
C$315 \$0$7 TOP_P\x7cVINP 8.664e-15
* device instance $316 r0 *1 0,0 sky130_fd_pr__model__cap_mim
C$316 \$0$16 TOP_N\x7cVINN 8.664e-15
* device instance $317 r0 *1 0,0 sky130_fd_pr__model__cap_mim
C$317 \$0$16 TOP_N\x7cVINN 8.664e-15
* device instance $318 r0 *1 0,0 sky130_fd_pr__model__cap_mim
C$318 \$0$7 TOP_P\x7cVINP 8.664e-15
* device instance $319 r0 *1 0,0 sky130_fd_pr__model__cap_mim
C$319 \$0$16 TOP_N\x7cVINN 8.664e-15
* device instance $320 r0 *1 0,0 sky130_fd_pr__model__cap_mim
C$320 \$0$7 TOP_P\x7cVINP 8.664e-15
* device instance $321 r0 *1 0,0 sky130_fd_pr__model__cap_mim
C$321 \$0$16 TOP_N\x7cVINN 8.664e-15
* device instance $322 r0 *1 0,0 sky130_fd_pr__model__cap_mim
C$322 \$0$7 TOP_P\x7cVINP 8.664e-15
* device instance $323 r0 *1 0,0 sky130_fd_pr__model__cap_mim
C$323 \$0$16 TOP_N\x7cVINN 8.664e-15
* device instance $324 r0 *1 0,0 sky130_fd_pr__model__cap_mim
C$324 \$0$7 TOP_P\x7cVINP 8.664e-15
* device instance $325 r0 *1 0,0 sky130_fd_pr__model__cap_mim
C$325 \$0$8 TOP_P\x7cVINP 8.664e-15
* device instance $326 r0 *1 0,0 sky130_fd_pr__model__cap_mim
C$326 \$0$17 TOP_N\x7cVINN 8.664e-15
* device instance $327 r0 *1 0,0 sky130_fd_pr__model__cap_mim
C$327 \$0$8 TOP_P\x7cVINP 8.664e-15
* device instance $328 r0 *1 0,0 sky130_fd_pr__model__cap_mim
C$328 \$0$17 TOP_N\x7cVINN 8.664e-15
* device instance $329 r0 *1 0,0 sky130_fd_pr__model__cap_mim
C$329 \$0$8 TOP_P\x7cVINP 8.664e-15
* device instance $330 r0 *1 0,0 sky130_fd_pr__model__cap_mim
C$330 \$0$17 TOP_N\x7cVINN 8.664e-15
* device instance $331 r0 *1 0,0 sky130_fd_pr__model__cap_mim
C$331 \$0$8 TOP_P\x7cVINP 8.664e-15
* device instance $332 r0 *1 0,0 sky130_fd_pr__model__cap_mim
C$332 \$0$17 TOP_N\x7cVINN 8.664e-15
* device instance $333 r0 *1 0,0 sky130_fd_pr__model__cap_mim
C$333 \$0$17 TOP_N\x7cVINN 8.664e-15
* device instance $334 r0 *1 0,0 sky130_fd_pr__model__cap_mim
C$334 \$0$8 TOP_P\x7cVINP 8.664e-15
* device instance $335 r0 *1 0,0 sky130_fd_pr__model__cap_mim
C$335 \$0$17 TOP_N\x7cVINN 8.664e-15
* device instance $336 r0 *1 0,0 sky130_fd_pr__model__cap_mim
C$336 \$0$8 TOP_P\x7cVINP 8.664e-15
* device instance $337 r0 *1 0,0 sky130_fd_pr__model__cap_mim
C$337 \$0$17 TOP_N\x7cVINN 8.664e-15
* device instance $338 r0 *1 0,0 sky130_fd_pr__model__cap_mim
C$338 \$0$8 TOP_P\x7cVINP 8.664e-15
* device instance $339 r0 *1 0,0 sky130_fd_pr__model__cap_mim
C$339 \$0$17 TOP_N\x7cVINN 8.664e-15
* device instance $340 r0 *1 0,0 sky130_fd_pr__model__cap_mim
C$340 \$0$8 TOP_P\x7cVINP 8.664e-15
* device instance $341 r0 *1 0,0 sky130_fd_pr__model__cap_mim
C$341 \$0$6 TOP_P\x7cVINP 8.664e-15
* device instance $342 r0 *1 0,0 sky130_fd_pr__model__cap_mim
C$342 \$0$15 TOP_N\x7cVINN 8.664e-15
* device instance $343 r0 *1 0,0 sky130_fd_pr__model__cap_mim
C$343 \$0$6 TOP_P\x7cVINP 8.664e-15
* device instance $344 r0 *1 0,0 sky130_fd_pr__model__cap_mim
C$344 \$0$15 TOP_N\x7cVINN 8.664e-15
* device instance $345 r0 *1 0,0 sky130_fd_pr__model__cap_mim
C$345 \$0$6 TOP_P\x7cVINP 8.664e-15
* device instance $346 r0 *1 0,0 sky130_fd_pr__model__cap_mim
C$346 \$0$15 TOP_N\x7cVINN 8.664e-15
* device instance $347 r0 *1 0,0 sky130_fd_pr__model__cap_mim
C$347 \$0$6 TOP_P\x7cVINP 8.664e-15
* device instance $348 r0 *1 0,0 sky130_fd_pr__model__cap_mim
C$348 \$0$15 TOP_N\x7cVINN 8.664e-15
* device instance $349 r0 *1 0,0 sky130_fd_pr__model__cap_mim
C$349 \$0$15 TOP_N\x7cVINN 8.664e-15
* device instance $350 r0 *1 0,0 sky130_fd_pr__model__cap_mim
C$350 \$0$6 TOP_P\x7cVINP 8.664e-15
* device instance $351 r0 *1 0,0 sky130_fd_pr__model__cap_mim
C$351 \$0$15 TOP_N\x7cVINN 8.664e-15
* device instance $352 r0 *1 0,0 sky130_fd_pr__model__cap_mim
C$352 \$0$6 TOP_P\x7cVINP 8.664e-15
* device instance $353 r0 *1 0,0 sky130_fd_pr__model__cap_mim
C$353 \$0$15 TOP_N\x7cVINN 8.664e-15
* device instance $354 r0 *1 0,0 sky130_fd_pr__model__cap_mim
C$354 \$0$6 TOP_P\x7cVINP 8.664e-15
* device instance $355 r0 *1 0,0 sky130_fd_pr__model__cap_mim
C$355 \$0$15 TOP_N\x7cVINN 8.664e-15
* device instance $356 r0 *1 0,0 sky130_fd_pr__model__cap_mim
C$356 \$0$6 TOP_P\x7cVINP 8.664e-15
* device instance $357 r0 *1 0,0 sky130_fd_pr__model__cap_mim
C$357 \$0$8 TOP_P\x7cVINP 8.664e-15
* device instance $358 r0 *1 0,0 sky130_fd_pr__model__cap_mim
C$358 \$0$17 TOP_N\x7cVINN 8.664e-15
* device instance $359 r0 *1 0,0 sky130_fd_pr__model__cap_mim
C$359 \$0$8 TOP_P\x7cVINP 8.664e-15
* device instance $360 r0 *1 0,0 sky130_fd_pr__model__cap_mim
C$360 \$0$17 TOP_N\x7cVINN 8.664e-15
* device instance $361 r0 *1 0,0 sky130_fd_pr__model__cap_mim
C$361 \$0$8 TOP_P\x7cVINP 8.664e-15
* device instance $362 r0 *1 0,0 sky130_fd_pr__model__cap_mim
C$362 \$0$17 TOP_N\x7cVINN 8.664e-15
* device instance $363 r0 *1 0,0 sky130_fd_pr__model__cap_mim
C$363 \$0$8 TOP_P\x7cVINP 8.664e-15
* device instance $364 r0 *1 0,0 sky130_fd_pr__model__cap_mim
C$364 \$0$17 TOP_N\x7cVINN 8.664e-15
* device instance $365 r0 *1 0,0 sky130_fd_pr__model__cap_mim
C$365 \$0$17 TOP_N\x7cVINN 8.664e-15
* device instance $366 r0 *1 0,0 sky130_fd_pr__model__cap_mim
C$366 \$0$8 TOP_P\x7cVINP 8.664e-15
* device instance $367 r0 *1 0,0 sky130_fd_pr__model__cap_mim
C$367 \$0$17 TOP_N\x7cVINN 8.664e-15
* device instance $368 r0 *1 0,0 sky130_fd_pr__model__cap_mim
C$368 \$0$8 TOP_P\x7cVINP 8.664e-15
* device instance $369 r0 *1 0,0 sky130_fd_pr__model__cap_mim
C$369 \$0$17 TOP_N\x7cVINN 8.664e-15
* device instance $370 r0 *1 0,0 sky130_fd_pr__model__cap_mim
C$370 \$0$8 TOP_P\x7cVINP 8.664e-15
* device instance $371 r0 *1 0,0 sky130_fd_pr__model__cap_mim
C$371 \$0$17 TOP_N\x7cVINN 8.664e-15
* device instance $372 r0 *1 0,0 sky130_fd_pr__model__cap_mim
C$372 \$0$8 TOP_P\x7cVINP 8.664e-15
* device instance $373 r0 *1 0,0 sky130_fd_pr__model__cap_mim
C$373 \$0$7 TOP_P\x7cVINP 8.664e-15
* device instance $374 r0 *1 0,0 sky130_fd_pr__model__cap_mim
C$374 \$0$16 TOP_N\x7cVINN 8.664e-15
* device instance $375 r0 *1 0,0 sky130_fd_pr__model__cap_mim
C$375 \$0$7 TOP_P\x7cVINP 8.664e-15
* device instance $376 r0 *1 0,0 sky130_fd_pr__model__cap_mim
C$376 \$0$16 TOP_N\x7cVINN 8.664e-15
* device instance $377 r0 *1 0,0 sky130_fd_pr__model__cap_mim
C$377 \$0$7 TOP_P\x7cVINP 8.664e-15
* device instance $378 r0 *1 0,0 sky130_fd_pr__model__cap_mim
C$378 \$0$16 TOP_N\x7cVINN 8.664e-15
* device instance $379 r0 *1 0,0 sky130_fd_pr__model__cap_mim
C$379 \$0$7 TOP_P\x7cVINP 8.664e-15
* device instance $380 r0 *1 0,0 sky130_fd_pr__model__cap_mim
C$380 \$0$16 TOP_N\x7cVINN 8.664e-15
* device instance $381 r0 *1 0,0 sky130_fd_pr__model__cap_mim
C$381 \$0$16 TOP_N\x7cVINN 8.664e-15
* device instance $382 r0 *1 0,0 sky130_fd_pr__model__cap_mim
C$382 \$0$7 TOP_P\x7cVINP 8.664e-15
* device instance $383 r0 *1 0,0 sky130_fd_pr__model__cap_mim
C$383 \$0$16 TOP_N\x7cVINN 8.664e-15
* device instance $384 r0 *1 0,0 sky130_fd_pr__model__cap_mim
C$384 \$0$7 TOP_P\x7cVINP 8.664e-15
* device instance $385 r0 *1 0,0 sky130_fd_pr__model__cap_mim
C$385 \$0$16 TOP_N\x7cVINN 8.664e-15
* device instance $386 r0 *1 0,0 sky130_fd_pr__model__cap_mim
C$386 \$0$7 TOP_P\x7cVINP 8.664e-15
* device instance $387 r0 *1 0,0 sky130_fd_pr__model__cap_mim
C$387 \$0$16 TOP_N\x7cVINN 8.664e-15
* device instance $388 r0 *1 0,0 sky130_fd_pr__model__cap_mim
C$388 \$0$7 TOP_P\x7cVINP 8.664e-15
* device instance $389 r0 *1 0,0 sky130_fd_pr__model__cap_mim
C$389 \$0$8 TOP_P\x7cVINP 8.664e-15
* device instance $390 r0 *1 0,0 sky130_fd_pr__model__cap_mim
C$390 \$0$17 TOP_N\x7cVINN 8.664e-15
* device instance $391 r0 *1 0,0 sky130_fd_pr__model__cap_mim
C$391 \$0$8 TOP_P\x7cVINP 8.664e-15
* device instance $392 r0 *1 0,0 sky130_fd_pr__model__cap_mim
C$392 \$0$17 TOP_N\x7cVINN 8.664e-15
* device instance $393 r0 *1 0,0 sky130_fd_pr__model__cap_mim
C$393 \$0$8 TOP_P\x7cVINP 8.664e-15
* device instance $394 r0 *1 0,0 sky130_fd_pr__model__cap_mim
C$394 \$0$17 TOP_N\x7cVINN 8.664e-15
* device instance $395 r0 *1 0,0 sky130_fd_pr__model__cap_mim
C$395 \$0$8 TOP_P\x7cVINP 8.664e-15
* device instance $396 r0 *1 0,0 sky130_fd_pr__model__cap_mim
C$396 \$0$17 TOP_N\x7cVINN 8.664e-15
* device instance $397 r0 *1 0,0 sky130_fd_pr__model__cap_mim
C$397 \$0$17 TOP_N\x7cVINN 8.664e-15
* device instance $398 r0 *1 0,0 sky130_fd_pr__model__cap_mim
C$398 \$0$8 TOP_P\x7cVINP 8.664e-15
* device instance $399 r0 *1 0,0 sky130_fd_pr__model__cap_mim
C$399 \$0$17 TOP_N\x7cVINN 8.664e-15
* device instance $400 r0 *1 0,0 sky130_fd_pr__model__cap_mim
C$400 \$0$8 TOP_P\x7cVINP 8.664e-15
* device instance $401 r0 *1 0,0 sky130_fd_pr__model__cap_mim
C$401 \$0$17 TOP_N\x7cVINN 8.664e-15
* device instance $402 r0 *1 0,0 sky130_fd_pr__model__cap_mim
C$402 \$0$8 TOP_P\x7cVINP 8.664e-15
* device instance $403 r0 *1 0,0 sky130_fd_pr__model__cap_mim
C$403 \$0$17 TOP_N\x7cVINN 8.664e-15
* device instance $404 r0 *1 0,0 sky130_fd_pr__model__cap_mim
C$404 \$0$8 TOP_P\x7cVINP 8.664e-15
* device instance $405 r0 *1 0,0 sky130_fd_pr__model__cap_mim
C$405 \$0$5 TOP_P\x7cVINP 8.664e-15
* device instance $406 r0 *1 0,0 sky130_fd_pr__model__cap_mim
C$406 \$0$14 TOP_N\x7cVINN 8.664e-15
* device instance $407 r0 *1 0,0 sky130_fd_pr__model__cap_mim
C$407 \$0$5 TOP_P\x7cVINP 8.664e-15
* device instance $408 r0 *1 0,0 sky130_fd_pr__model__cap_mim
C$408 \$0$14 TOP_N\x7cVINN 8.664e-15
* device instance $409 r0 *1 0,0 sky130_fd_pr__model__cap_mim
C$409 \$0$5 TOP_P\x7cVINP 8.664e-15
* device instance $410 r0 *1 0,0 sky130_fd_pr__model__cap_mim
C$410 \$0$14 TOP_N\x7cVINN 8.664e-15
* device instance $411 r0 *1 0,0 sky130_fd_pr__model__cap_mim
C$411 \$0$5 TOP_P\x7cVINP 8.664e-15
* device instance $412 r0 *1 0,0 sky130_fd_pr__model__cap_mim
C$412 \$0$14 TOP_N\x7cVINN 8.664e-15
* device instance $413 r0 *1 0,0 sky130_fd_pr__model__cap_mim
C$413 \$0$14 TOP_N\x7cVINN 8.664e-15
* device instance $414 r0 *1 0,0 sky130_fd_pr__model__cap_mim
C$414 \$0$5 TOP_P\x7cVINP 8.664e-15
* device instance $415 r0 *1 0,0 sky130_fd_pr__model__cap_mim
C$415 \$0$14 TOP_N\x7cVINN 8.664e-15
* device instance $416 r0 *1 0,0 sky130_fd_pr__model__cap_mim
C$416 \$0$5 TOP_P\x7cVINP 8.664e-15
* device instance $417 r0 *1 0,0 sky130_fd_pr__model__cap_mim
C$417 \$0$14 TOP_N\x7cVINN 8.664e-15
* device instance $418 r0 *1 0,0 sky130_fd_pr__model__cap_mim
C$418 \$0$5 TOP_P\x7cVINP 8.664e-15
* device instance $419 r0 *1 0,0 sky130_fd_pr__model__cap_mim
C$419 \$0$14 TOP_N\x7cVINN 8.664e-15
* device instance $420 r0 *1 0,0 sky130_fd_pr__model__cap_mim
C$420 \$0$5 TOP_P\x7cVINP 8.664e-15
* device instance $421 r0 *1 0,0 sky130_fd_pr__model__cap_mim
C$421 \$0$8 TOP_P\x7cVINP 8.664e-15
* device instance $422 r0 *1 0,0 sky130_fd_pr__model__cap_mim
C$422 \$0$17 TOP_N\x7cVINN 8.664e-15
* device instance $423 r0 *1 0,0 sky130_fd_pr__model__cap_mim
C$423 \$0$8 TOP_P\x7cVINP 8.664e-15
* device instance $424 r0 *1 0,0 sky130_fd_pr__model__cap_mim
C$424 \$0$17 TOP_N\x7cVINN 8.664e-15
* device instance $425 r0 *1 0,0 sky130_fd_pr__model__cap_mim
C$425 \$0$8 TOP_P\x7cVINP 8.664e-15
* device instance $426 r0 *1 0,0 sky130_fd_pr__model__cap_mim
C$426 \$0$17 TOP_N\x7cVINN 8.664e-15
* device instance $427 r0 *1 0,0 sky130_fd_pr__model__cap_mim
C$427 \$0$8 TOP_P\x7cVINP 8.664e-15
* device instance $428 r0 *1 0,0 sky130_fd_pr__model__cap_mim
C$428 \$0$17 TOP_N\x7cVINN 8.664e-15
* device instance $429 r0 *1 0,0 sky130_fd_pr__model__cap_mim
C$429 \$0$17 TOP_N\x7cVINN 8.664e-15
* device instance $430 r0 *1 0,0 sky130_fd_pr__model__cap_mim
C$430 \$0$8 TOP_P\x7cVINP 8.664e-15
* device instance $431 r0 *1 0,0 sky130_fd_pr__model__cap_mim
C$431 \$0$17 TOP_N\x7cVINN 8.664e-15
* device instance $432 r0 *1 0,0 sky130_fd_pr__model__cap_mim
C$432 \$0$8 TOP_P\x7cVINP 8.664e-15
* device instance $433 r0 *1 0,0 sky130_fd_pr__model__cap_mim
C$433 \$0$17 TOP_N\x7cVINN 8.664e-15
* device instance $434 r0 *1 0,0 sky130_fd_pr__model__cap_mim
C$434 \$0$8 TOP_P\x7cVINP 8.664e-15
* device instance $435 r0 *1 0,0 sky130_fd_pr__model__cap_mim
C$435 \$0$17 TOP_N\x7cVINN 8.664e-15
* device instance $436 r0 *1 0,0 sky130_fd_pr__model__cap_mim
C$436 \$0$8 TOP_P\x7cVINP 8.664e-15
* device instance $437 r0 *1 0,0 sky130_fd_pr__model__cap_mim
C$437 \$0$7 TOP_P\x7cVINP 8.664e-15
* device instance $438 r0 *1 0,0 sky130_fd_pr__model__cap_mim
C$438 \$0$16 TOP_N\x7cVINN 8.664e-15
* device instance $439 r0 *1 0,0 sky130_fd_pr__model__cap_mim
C$439 \$0$7 TOP_P\x7cVINP 8.664e-15
* device instance $440 r0 *1 0,0 sky130_fd_pr__model__cap_mim
C$440 \$0$16 TOP_N\x7cVINN 8.664e-15
* device instance $441 r0 *1 0,0 sky130_fd_pr__model__cap_mim
C$441 \$0$7 TOP_P\x7cVINP 8.664e-15
* device instance $442 r0 *1 0,0 sky130_fd_pr__model__cap_mim
C$442 \$0$16 TOP_N\x7cVINN 8.664e-15
* device instance $443 r0 *1 0,0 sky130_fd_pr__model__cap_mim
C$443 \$0$7 TOP_P\x7cVINP 8.664e-15
* device instance $444 r0 *1 0,0 sky130_fd_pr__model__cap_mim
C$444 \$0$16 TOP_N\x7cVINN 8.664e-15
* device instance $445 r0 *1 0,0 sky130_fd_pr__model__cap_mim
C$445 \$0$16 TOP_N\x7cVINN 8.664e-15
* device instance $446 r0 *1 0,0 sky130_fd_pr__model__cap_mim
C$446 \$0$7 TOP_P\x7cVINP 8.664e-15
* device instance $447 r0 *1 0,0 sky130_fd_pr__model__cap_mim
C$447 \$0$16 TOP_N\x7cVINN 8.664e-15
* device instance $448 r0 *1 0,0 sky130_fd_pr__model__cap_mim
C$448 \$0$7 TOP_P\x7cVINP 8.664e-15
* device instance $449 r0 *1 0,0 sky130_fd_pr__model__cap_mim
C$449 \$0$16 TOP_N\x7cVINN 8.664e-15
* device instance $450 r0 *1 0,0 sky130_fd_pr__model__cap_mim
C$450 \$0$7 TOP_P\x7cVINP 8.664e-15
* device instance $451 r0 *1 0,0 sky130_fd_pr__model__cap_mim
C$451 \$0$16 TOP_N\x7cVINN 8.664e-15
* device instance $452 r0 *1 0,0 sky130_fd_pr__model__cap_mim
C$452 \$0$7 TOP_P\x7cVINP 8.664e-15
* device instance $453 r0 *1 0,0 sky130_fd_pr__model__cap_mim
C$453 \$0$8 TOP_P\x7cVINP 8.664e-15
* device instance $454 r0 *1 0,0 sky130_fd_pr__model__cap_mim
C$454 \$0$17 TOP_N\x7cVINN 8.664e-15
* device instance $455 r0 *1 0,0 sky130_fd_pr__model__cap_mim
C$455 \$0$8 TOP_P\x7cVINP 8.664e-15
* device instance $456 r0 *1 0,0 sky130_fd_pr__model__cap_mim
C$456 \$0$17 TOP_N\x7cVINN 8.664e-15
* device instance $457 r0 *1 0,0 sky130_fd_pr__model__cap_mim
C$457 \$0$8 TOP_P\x7cVINP 8.664e-15
* device instance $458 r0 *1 0,0 sky130_fd_pr__model__cap_mim
C$458 \$0$17 TOP_N\x7cVINN 8.664e-15
* device instance $459 r0 *1 0,0 sky130_fd_pr__model__cap_mim
C$459 \$0$8 TOP_P\x7cVINP 8.664e-15
* device instance $460 r0 *1 0,0 sky130_fd_pr__model__cap_mim
C$460 \$0$17 TOP_N\x7cVINN 8.664e-15
* device instance $461 r0 *1 0,0 sky130_fd_pr__model__cap_mim
C$461 \$0$17 TOP_N\x7cVINN 8.664e-15
* device instance $462 r0 *1 0,0 sky130_fd_pr__model__cap_mim
C$462 \$0$8 TOP_P\x7cVINP 8.664e-15
* device instance $463 r0 *1 0,0 sky130_fd_pr__model__cap_mim
C$463 \$0$17 TOP_N\x7cVINN 8.664e-15
* device instance $464 r0 *1 0,0 sky130_fd_pr__model__cap_mim
C$464 \$0$8 TOP_P\x7cVINP 8.664e-15
* device instance $465 r0 *1 0,0 sky130_fd_pr__model__cap_mim
C$465 \$0$17 TOP_N\x7cVINN 8.664e-15
* device instance $466 r0 *1 0,0 sky130_fd_pr__model__cap_mim
C$466 \$0$8 TOP_P\x7cVINP 8.664e-15
* device instance $467 r0 *1 0,0 sky130_fd_pr__model__cap_mim
C$467 \$0$17 TOP_N\x7cVINN 8.664e-15
* device instance $468 r0 *1 0,0 sky130_fd_pr__model__cap_mim
C$468 \$0$8 TOP_P\x7cVINP 8.664e-15
* device instance $469 r0 *1 0,0 sky130_fd_pr__model__cap_mim
C$469 \$0$6 TOP_P\x7cVINP 8.664e-15
* device instance $470 r0 *1 0,0 sky130_fd_pr__model__cap_mim
C$470 \$0$15 TOP_N\x7cVINN 8.664e-15
* device instance $471 r0 *1 0,0 sky130_fd_pr__model__cap_mim
C$471 \$0$6 TOP_P\x7cVINP 8.664e-15
* device instance $472 r0 *1 0,0 sky130_fd_pr__model__cap_mim
C$472 \$0$15 TOP_N\x7cVINN 8.664e-15
* device instance $473 r0 *1 0,0 sky130_fd_pr__model__cap_mim
C$473 \$0$6 TOP_P\x7cVINP 8.664e-15
* device instance $474 r0 *1 0,0 sky130_fd_pr__model__cap_mim
C$474 \$0$15 TOP_N\x7cVINN 8.664e-15
* device instance $475 r0 *1 0,0 sky130_fd_pr__model__cap_mim
C$475 \$0$6 TOP_P\x7cVINP 8.664e-15
* device instance $476 r0 *1 0,0 sky130_fd_pr__model__cap_mim
C$476 \$0$15 TOP_N\x7cVINN 8.664e-15
* device instance $477 r0 *1 0,0 sky130_fd_pr__model__cap_mim
C$477 \$0$15 TOP_N\x7cVINN 8.664e-15
* device instance $478 r0 *1 0,0 sky130_fd_pr__model__cap_mim
C$478 \$0$6 TOP_P\x7cVINP 8.664e-15
* device instance $479 r0 *1 0,0 sky130_fd_pr__model__cap_mim
C$479 \$0$15 TOP_N\x7cVINN 8.664e-15
* device instance $480 r0 *1 0,0 sky130_fd_pr__model__cap_mim
C$480 \$0$6 TOP_P\x7cVINP 8.664e-15
* device instance $481 r0 *1 0,0 sky130_fd_pr__model__cap_mim
C$481 \$0$15 TOP_N\x7cVINN 8.664e-15
* device instance $482 r0 *1 0,0 sky130_fd_pr__model__cap_mim
C$482 \$0$6 TOP_P\x7cVINP 8.664e-15
* device instance $483 r0 *1 0,0 sky130_fd_pr__model__cap_mim
C$483 \$0$15 TOP_N\x7cVINN 8.664e-15
* device instance $484 r0 *1 0,0 sky130_fd_pr__model__cap_mim
C$484 \$0$6 TOP_P\x7cVINP 8.664e-15
* device instance $485 r0 *1 0,0 sky130_fd_pr__model__cap_mim
C$485 \$0$8 TOP_P\x7cVINP 8.664e-15
* device instance $486 r0 *1 0,0 sky130_fd_pr__model__cap_mim
C$486 \$0$17 TOP_N\x7cVINN 8.664e-15
* device instance $487 r0 *1 0,0 sky130_fd_pr__model__cap_mim
C$487 \$0$8 TOP_P\x7cVINP 8.664e-15
* device instance $488 r0 *1 0,0 sky130_fd_pr__model__cap_mim
C$488 \$0$17 TOP_N\x7cVINN 8.664e-15
* device instance $489 r0 *1 0,0 sky130_fd_pr__model__cap_mim
C$489 \$0$8 TOP_P\x7cVINP 8.664e-15
* device instance $490 r0 *1 0,0 sky130_fd_pr__model__cap_mim
C$490 \$0$17 TOP_N\x7cVINN 8.664e-15
* device instance $491 r0 *1 0,0 sky130_fd_pr__model__cap_mim
C$491 \$0$8 TOP_P\x7cVINP 8.664e-15
* device instance $492 r0 *1 0,0 sky130_fd_pr__model__cap_mim
C$492 \$0$17 TOP_N\x7cVINN 8.664e-15
* device instance $493 r0 *1 0,0 sky130_fd_pr__model__cap_mim
C$493 \$0$17 TOP_N\x7cVINN 8.664e-15
* device instance $494 r0 *1 0,0 sky130_fd_pr__model__cap_mim
C$494 \$0$8 TOP_P\x7cVINP 8.664e-15
* device instance $495 r0 *1 0,0 sky130_fd_pr__model__cap_mim
C$495 \$0$17 TOP_N\x7cVINN 8.664e-15
* device instance $496 r0 *1 0,0 sky130_fd_pr__model__cap_mim
C$496 \$0$8 TOP_P\x7cVINP 8.664e-15
* device instance $497 r0 *1 0,0 sky130_fd_pr__model__cap_mim
C$497 \$0$17 TOP_N\x7cVINN 8.664e-15
* device instance $498 r0 *1 0,0 sky130_fd_pr__model__cap_mim
C$498 \$0$8 TOP_P\x7cVINP 8.664e-15
* device instance $499 r0 *1 0,0 sky130_fd_pr__model__cap_mim
C$499 \$0$17 TOP_N\x7cVINN 8.664e-15
* device instance $500 r0 *1 0,0 sky130_fd_pr__model__cap_mim
C$500 \$0$8 TOP_P\x7cVINP 8.664e-15
* device instance $501 r0 *1 0,0 sky130_fd_pr__model__cap_mim
C$501 \$0$7 TOP_P\x7cVINP 8.664e-15
* device instance $502 r0 *1 0,0 sky130_fd_pr__model__cap_mim
C$502 \$0$16 TOP_N\x7cVINN 8.664e-15
* device instance $503 r0 *1 0,0 sky130_fd_pr__model__cap_mim
C$503 \$0$7 TOP_P\x7cVINP 8.664e-15
* device instance $504 r0 *1 0,0 sky130_fd_pr__model__cap_mim
C$504 \$0$16 TOP_N\x7cVINN 8.664e-15
* device instance $505 r0 *1 0,0 sky130_fd_pr__model__cap_mim
C$505 \$0$7 TOP_P\x7cVINP 8.664e-15
* device instance $506 r0 *1 0,0 sky130_fd_pr__model__cap_mim
C$506 \$0$16 TOP_N\x7cVINN 8.664e-15
* device instance $507 r0 *1 0,0 sky130_fd_pr__model__cap_mim
C$507 \$0$7 TOP_P\x7cVINP 8.664e-15
* device instance $508 r0 *1 0,0 sky130_fd_pr__model__cap_mim
C$508 \$0$16 TOP_N\x7cVINN 8.664e-15
* device instance $509 r0 *1 0,0 sky130_fd_pr__model__cap_mim
C$509 \$0$16 TOP_N\x7cVINN 8.664e-15
* device instance $510 r0 *1 0,0 sky130_fd_pr__model__cap_mim
C$510 \$0$7 TOP_P\x7cVINP 8.664e-15
* device instance $511 r0 *1 0,0 sky130_fd_pr__model__cap_mim
C$511 \$0$16 TOP_N\x7cVINN 8.664e-15
* device instance $512 r0 *1 0,0 sky130_fd_pr__model__cap_mim
C$512 \$0$7 TOP_P\x7cVINP 8.664e-15
* device instance $513 r0 *1 0,0 sky130_fd_pr__model__cap_mim
C$513 \$0$16 TOP_N\x7cVINN 8.664e-15
* device instance $514 r0 *1 0,0 sky130_fd_pr__model__cap_mim
C$514 \$0$7 TOP_P\x7cVINP 8.664e-15
* device instance $515 r0 *1 0,0 sky130_fd_pr__model__cap_mim
C$515 \$0$16 TOP_N\x7cVINN 8.664e-15
* device instance $516 r0 *1 0,0 sky130_fd_pr__model__cap_mim
C$516 \$0$7 TOP_P\x7cVINP 8.664e-15
* device instance $517 r0 *1 0,0 sky130_fd_pr__model__cap_mim
C$517 \$0$8 TOP_P\x7cVINP 8.664e-15
* device instance $518 r0 *1 0,0 sky130_fd_pr__model__cap_mim
C$518 \$0$17 TOP_N\x7cVINN 8.664e-15
* device instance $519 r0 *1 0,0 sky130_fd_pr__model__cap_mim
C$519 \$0$8 TOP_P\x7cVINP 8.664e-15
* device instance $520 r0 *1 0,0 sky130_fd_pr__model__cap_mim
C$520 \$0$17 TOP_N\x7cVINN 8.664e-15
* device instance $521 r0 *1 0,0 sky130_fd_pr__model__cap_mim
C$521 \$0$8 TOP_P\x7cVINP 8.664e-15
* device instance $522 r0 *1 0,0 sky130_fd_pr__model__cap_mim
C$522 \$0$17 TOP_N\x7cVINN 8.664e-15
* device instance $523 r0 *1 0,0 sky130_fd_pr__model__cap_mim
C$523 \$0$8 TOP_P\x7cVINP 8.664e-15
* device instance $524 r0 *1 0,0 sky130_fd_pr__model__cap_mim
C$524 \$0$17 TOP_N\x7cVINN 8.664e-15
* device instance $525 r0 *1 0,0 sky130_fd_pr__model__cap_mim
C$525 \$0$17 TOP_N\x7cVINN 8.664e-15
* device instance $526 r0 *1 0,0 sky130_fd_pr__model__cap_mim
C$526 \$0$8 TOP_P\x7cVINP 8.664e-15
* device instance $527 r0 *1 0,0 sky130_fd_pr__model__cap_mim
C$527 \$0$17 TOP_N\x7cVINN 8.664e-15
* device instance $528 r0 *1 0,0 sky130_fd_pr__model__cap_mim
C$528 \$0$8 TOP_P\x7cVINP 8.664e-15
* device instance $529 r0 *1 0,0 sky130_fd_pr__model__cap_mim
C$529 \$0$17 TOP_N\x7cVINN 8.664e-15
* device instance $530 r0 *1 0,0 sky130_fd_pr__model__cap_mim
C$530 \$0$8 TOP_P\x7cVINP 8.664e-15
* device instance $531 r0 *1 0,0 sky130_fd_pr__model__cap_mim
C$531 \$0$17 TOP_N\x7cVINN 8.664e-15
* device instance $532 r0 *1 0,0 sky130_fd_pr__model__cap_mim
C$532 \$0$8 TOP_P\x7cVINP 8.664e-15
* device instance $533 r0 *1 0,0 sky130_fd_pr__model__cap_mim
C$533 \$0$3 TOP_P\x7cVINP 8.664e-15
* device instance $534 r0 *1 0,0 sky130_fd_pr__model__cap_mim
C$534 \$0$12 TOP_N\x7cVINN 8.664e-15
* device instance $535 r0 *1 0,0 sky130_fd_pr__model__cap_mim
C$535 \$0$3 TOP_P\x7cVINP 8.664e-15
* device instance $536 r0 *1 0,0 sky130_fd_pr__model__cap_mim
C$536 \$0$12 TOP_N\x7cVINN 8.664e-15
* device instance $537 r0 *1 0,0 sky130_fd_pr__model__cap_mim
C$537 \$0$3 TOP_P\x7cVINP 8.664e-15
* device instance $538 r0 *1 0,0 sky130_fd_pr__model__cap_mim
C$538 \$0$12 TOP_N\x7cVINN 8.664e-15
* device instance $539 r0 *1 0,0 sky130_fd_pr__model__cap_mim
C$539 \$0$3 TOP_P\x7cVINP 8.664e-15
* device instance $540 r0 *1 0,0 sky130_fd_pr__model__cap_mim
C$540 \$0$12 TOP_N\x7cVINN 8.664e-15
* device instance $541 r0 *1 0,0 sky130_fd_pr__model__cap_mim
C$541 \$0$12 TOP_N\x7cVINN 8.664e-15
* device instance $542 r0 *1 0,0 sky130_fd_pr__model__cap_mim
C$542 \$0$3 TOP_P\x7cVINP 8.664e-15
* device instance $543 r0 *1 0,0 sky130_fd_pr__model__cap_mim
C$543 \$0$12 TOP_N\x7cVINN 8.664e-15
* device instance $544 r0 *1 0,0 sky130_fd_pr__model__cap_mim
C$544 \$0$3 TOP_P\x7cVINP 8.664e-15
* device instance $545 r0 *1 0,0 sky130_fd_pr__model__cap_mim
C$545 \$0$12 TOP_N\x7cVINN 8.664e-15
* device instance $546 r0 *1 0,0 sky130_fd_pr__model__cap_mim
C$546 \$0$3 TOP_P\x7cVINP 8.664e-15
* device instance $547 r0 *1 0,0 sky130_fd_pr__model__cap_mim
C$547 \$0$12 TOP_N\x7cVINN 8.664e-15
* device instance $548 r0 *1 0,0 sky130_fd_pr__model__cap_mim
C$548 \$0$3 TOP_P\x7cVINP 8.664e-15
* device instance $549 r0 *1 0,0 sky130_fd_pr__model__cap_mim
C$549 \$0 TOP_P\x7cVINP 8.664e-15
* device instance $550 r0 *1 0,0 sky130_fd_pr__model__cap_mim
C$550 \$0$9 TOP_N\x7cVINN 8.664e-15
* device instance $551 r0 *1 0,0 sky130_fd_pr__model__cap_mim
C$551 \$0$2 TOP_P\x7cVINP 8.664e-15
* device instance $552 r0 *1 0,0 sky130_fd_pr__model__cap_mim
C$552 \$0$11 TOP_N\x7cVINN 8.664e-15
* device instance $553 r0 *1 0,0 sky130_fd_pr__model__cap_mim
C$553 \$0$1 TOP_P\x7cVINP 8.664e-15
* device instance $554 r0 *1 0,0 sky130_fd_pr__model__cap_mim
C$554 \$0$10 TOP_N\x7cVINN 8.664e-15
* device instance $555 r0 *1 0,0 sky130_fd_pr__model__cap_mim
C$555 \$0$2 TOP_P\x7cVINP 8.664e-15
* device instance $556 r0 *1 0,0 sky130_fd_pr__model__cap_mim
C$556 \$0$11 TOP_N\x7cVINN 8.664e-15
* device instance $557 r0 *1 0,0 sky130_fd_pr__model__cap_mim
C$557 \$0$11 TOP_N\x7cVINN 8.664e-15
* device instance $558 r0 *1 0,0 sky130_fd_pr__model__cap_mim
C$558 \$0$2 TOP_P\x7cVINP 8.664e-15
* device instance $559 r0 *1 0,0 sky130_fd_pr__model__cap_mim
C$559 \$0$10 TOP_N\x7cVINN 8.664e-15
* device instance $560 r0 *1 0,0 sky130_fd_pr__model__cap_mim
C$560 \$0$1 TOP_P\x7cVINP 8.664e-15
* device instance $561 r0 *1 0,0 sky130_fd_pr__model__cap_mim
C$561 \$0$11 TOP_N\x7cVINN 8.664e-15
* device instance $562 r0 *1 0,0 sky130_fd_pr__model__cap_mim
C$562 \$0$2 TOP_P\x7cVINP 8.664e-15
* device instance $563 r0 *1 0,0 sky130_fd_pr__model__cap_mim
C$563 VREFN TOP_N\x7cVINN 8.664e-15
* device instance $564 r0 *1 0,0 sky130_fd_pr__model__cap_mim
C$564 VREFN TOP_P\x7cVINP 8.664e-15
* device instance $565 r0 *1 0,0 sky130_fd_pr__model__cap_mim
C$565 \$0$8 TOP_P\x7cVINP 8.664e-15
* device instance $566 r0 *1 0,0 sky130_fd_pr__model__cap_mim
C$566 \$0$17 TOP_N\x7cVINN 8.664e-15
* device instance $567 r0 *1 0,0 sky130_fd_pr__model__cap_mim
C$567 \$0$8 TOP_P\x7cVINP 8.664e-15
* device instance $568 r0 *1 0,0 sky130_fd_pr__model__cap_mim
C$568 \$0$17 TOP_N\x7cVINN 8.664e-15
* device instance $569 r0 *1 0,0 sky130_fd_pr__model__cap_mim
C$569 \$0$8 TOP_P\x7cVINP 8.664e-15
* device instance $570 r0 *1 0,0 sky130_fd_pr__model__cap_mim
C$570 \$0$17 TOP_N\x7cVINN 8.664e-15
* device instance $571 r0 *1 0,0 sky130_fd_pr__model__cap_mim
C$571 \$0$8 TOP_P\x7cVINP 8.664e-15
* device instance $572 r0 *1 0,0 sky130_fd_pr__model__cap_mim
C$572 \$0$17 TOP_N\x7cVINN 8.664e-15
* device instance $573 r0 *1 0,0 sky130_fd_pr__model__cap_mim
C$573 \$0$17 TOP_N\x7cVINN 8.664e-15
* device instance $574 r0 *1 0,0 sky130_fd_pr__model__cap_mim
C$574 \$0$8 TOP_P\x7cVINP 8.664e-15
* device instance $575 r0 *1 0,0 sky130_fd_pr__model__cap_mim
C$575 \$0$17 TOP_N\x7cVINN 8.664e-15
* device instance $576 r0 *1 0,0 sky130_fd_pr__model__cap_mim
C$576 \$0$8 TOP_P\x7cVINP 8.664e-15
* device instance $577 r0 *1 0,0 sky130_fd_pr__model__cap_mim
C$577 \$0$17 TOP_N\x7cVINN 8.664e-15
* device instance $578 r0 *1 0,0 sky130_fd_pr__model__cap_mim
C$578 \$0$8 TOP_P\x7cVINP 8.664e-15
* device instance $579 r0 *1 0,0 sky130_fd_pr__model__cap_mim
C$579 \$0$17 TOP_N\x7cVINN 8.664e-15
* device instance $580 r0 *1 0,0 sky130_fd_pr__model__cap_mim
C$580 \$0$8 TOP_P\x7cVINP 8.664e-15
* device instance $581 r0 *1 0,0 sky130_fd_pr__model__cap_mim
C$581 \$0$7 TOP_P\x7cVINP 8.664e-15
* device instance $582 r0 *1 0,0 sky130_fd_pr__model__cap_mim
C$582 \$0$16 TOP_N\x7cVINN 8.664e-15
* device instance $583 r0 *1 0,0 sky130_fd_pr__model__cap_mim
C$583 \$0$7 TOP_P\x7cVINP 8.664e-15
* device instance $584 r0 *1 0,0 sky130_fd_pr__model__cap_mim
C$584 \$0$16 TOP_N\x7cVINN 8.664e-15
* device instance $585 r0 *1 0,0 sky130_fd_pr__model__cap_mim
C$585 \$0$7 TOP_P\x7cVINP 8.664e-15
* device instance $586 r0 *1 0,0 sky130_fd_pr__model__cap_mim
C$586 \$0$16 TOP_N\x7cVINN 8.664e-15
* device instance $587 r0 *1 0,0 sky130_fd_pr__model__cap_mim
C$587 \$0$7 TOP_P\x7cVINP 8.664e-15
* device instance $588 r0 *1 0,0 sky130_fd_pr__model__cap_mim
C$588 \$0$16 TOP_N\x7cVINN 8.664e-15
* device instance $589 r0 *1 0,0 sky130_fd_pr__model__cap_mim
C$589 \$0$16 TOP_N\x7cVINN 8.664e-15
* device instance $590 r0 *1 0,0 sky130_fd_pr__model__cap_mim
C$590 \$0$7 TOP_P\x7cVINP 8.664e-15
* device instance $591 r0 *1 0,0 sky130_fd_pr__model__cap_mim
C$591 \$0$16 TOP_N\x7cVINN 8.664e-15
* device instance $592 r0 *1 0,0 sky130_fd_pr__model__cap_mim
C$592 \$0$7 TOP_P\x7cVINP 8.664e-15
* device instance $593 r0 *1 0,0 sky130_fd_pr__model__cap_mim
C$593 \$0$16 TOP_N\x7cVINN 8.664e-15
* device instance $594 r0 *1 0,0 sky130_fd_pr__model__cap_mim
C$594 \$0$7 TOP_P\x7cVINP 8.664e-15
* device instance $595 r0 *1 0,0 sky130_fd_pr__model__cap_mim
C$595 \$0$16 TOP_N\x7cVINN 8.664e-15
* device instance $596 r0 *1 0,0 sky130_fd_pr__model__cap_mim
C$596 \$0$7 TOP_P\x7cVINP 8.664e-15
* device instance $597 r0 *1 0,0 sky130_fd_pr__model__cap_mim
C$597 \$0$8 TOP_P\x7cVINP 8.664e-15
* device instance $598 r0 *1 0,0 sky130_fd_pr__model__cap_mim
C$598 \$0$17 TOP_N\x7cVINN 8.664e-15
* device instance $599 r0 *1 0,0 sky130_fd_pr__model__cap_mim
C$599 \$0$8 TOP_P\x7cVINP 8.664e-15
* device instance $600 r0 *1 0,0 sky130_fd_pr__model__cap_mim
C$600 \$0$17 TOP_N\x7cVINN 8.664e-15
* device instance $601 r0 *1 0,0 sky130_fd_pr__model__cap_mim
C$601 \$0$8 TOP_P\x7cVINP 8.664e-15
* device instance $602 r0 *1 0,0 sky130_fd_pr__model__cap_mim
C$602 \$0$17 TOP_N\x7cVINN 8.664e-15
* device instance $603 r0 *1 0,0 sky130_fd_pr__model__cap_mim
C$603 \$0$8 TOP_P\x7cVINP 8.664e-15
* device instance $604 r0 *1 0,0 sky130_fd_pr__model__cap_mim
C$604 \$0$17 TOP_N\x7cVINN 8.664e-15
* device instance $605 r0 *1 0,0 sky130_fd_pr__model__cap_mim
C$605 \$0$17 TOP_N\x7cVINN 8.664e-15
* device instance $606 r0 *1 0,0 sky130_fd_pr__model__cap_mim
C$606 \$0$8 TOP_P\x7cVINP 8.664e-15
* device instance $607 r0 *1 0,0 sky130_fd_pr__model__cap_mim
C$607 \$0$17 TOP_N\x7cVINN 8.664e-15
* device instance $608 r0 *1 0,0 sky130_fd_pr__model__cap_mim
C$608 \$0$8 TOP_P\x7cVINP 8.664e-15
* device instance $609 r0 *1 0,0 sky130_fd_pr__model__cap_mim
C$609 \$0$17 TOP_N\x7cVINN 8.664e-15
* device instance $610 r0 *1 0,0 sky130_fd_pr__model__cap_mim
C$610 \$0$8 TOP_P\x7cVINP 8.664e-15
* device instance $611 r0 *1 0,0 sky130_fd_pr__model__cap_mim
C$611 \$0$17 TOP_N\x7cVINN 8.664e-15
* device instance $612 r0 *1 0,0 sky130_fd_pr__model__cap_mim
C$612 \$0$8 TOP_P\x7cVINP 8.664e-15
* device instance $613 r0 *1 0,0 sky130_fd_pr__model__cap_mim
C$613 \$0$6 TOP_P\x7cVINP 8.664e-15
* device instance $614 r0 *1 0,0 sky130_fd_pr__model__cap_mim
C$614 \$0$15 TOP_N\x7cVINN 8.664e-15
* device instance $615 r0 *1 0,0 sky130_fd_pr__model__cap_mim
C$615 \$0$6 TOP_P\x7cVINP 8.664e-15
* device instance $616 r0 *1 0,0 sky130_fd_pr__model__cap_mim
C$616 \$0$15 TOP_N\x7cVINN 8.664e-15
* device instance $617 r0 *1 0,0 sky130_fd_pr__model__cap_mim
C$617 \$0$6 TOP_P\x7cVINP 8.664e-15
* device instance $618 r0 *1 0,0 sky130_fd_pr__model__cap_mim
C$618 \$0$15 TOP_N\x7cVINN 8.664e-15
* device instance $619 r0 *1 0,0 sky130_fd_pr__model__cap_mim
C$619 \$0$6 TOP_P\x7cVINP 8.664e-15
* device instance $620 r0 *1 0,0 sky130_fd_pr__model__cap_mim
C$620 \$0$15 TOP_N\x7cVINN 8.664e-15
* device instance $621 r0 *1 0,0 sky130_fd_pr__model__cap_mim
C$621 \$0$15 TOP_N\x7cVINN 8.664e-15
* device instance $622 r0 *1 0,0 sky130_fd_pr__model__cap_mim
C$622 \$0$6 TOP_P\x7cVINP 8.664e-15
* device instance $623 r0 *1 0,0 sky130_fd_pr__model__cap_mim
C$623 \$0$15 TOP_N\x7cVINN 8.664e-15
* device instance $624 r0 *1 0,0 sky130_fd_pr__model__cap_mim
C$624 \$0$6 TOP_P\x7cVINP 8.664e-15
* device instance $625 r0 *1 0,0 sky130_fd_pr__model__cap_mim
C$625 \$0$15 TOP_N\x7cVINN 8.664e-15
* device instance $626 r0 *1 0,0 sky130_fd_pr__model__cap_mim
C$626 \$0$6 TOP_P\x7cVINP 8.664e-15
* device instance $627 r0 *1 0,0 sky130_fd_pr__model__cap_mim
C$627 \$0$15 TOP_N\x7cVINN 8.664e-15
* device instance $628 r0 *1 0,0 sky130_fd_pr__model__cap_mim
C$628 \$0$6 TOP_P\x7cVINP 8.664e-15
* device instance $629 r0 *1 0,0 sky130_fd_pr__model__cap_mim
C$629 \$0$8 TOP_P\x7cVINP 8.664e-15
* device instance $630 r0 *1 0,0 sky130_fd_pr__model__cap_mim
C$630 \$0$17 TOP_N\x7cVINN 8.664e-15
* device instance $631 r0 *1 0,0 sky130_fd_pr__model__cap_mim
C$631 \$0$8 TOP_P\x7cVINP 8.664e-15
* device instance $632 r0 *1 0,0 sky130_fd_pr__model__cap_mim
C$632 \$0$17 TOP_N\x7cVINN 8.664e-15
* device instance $633 r0 *1 0,0 sky130_fd_pr__model__cap_mim
C$633 \$0$8 TOP_P\x7cVINP 8.664e-15
* device instance $634 r0 *1 0,0 sky130_fd_pr__model__cap_mim
C$634 \$0$17 TOP_N\x7cVINN 8.664e-15
* device instance $635 r0 *1 0,0 sky130_fd_pr__model__cap_mim
C$635 \$0$8 TOP_P\x7cVINP 8.664e-15
* device instance $636 r0 *1 0,0 sky130_fd_pr__model__cap_mim
C$636 \$0$17 TOP_N\x7cVINN 8.664e-15
* device instance $637 r0 *1 0,0 sky130_fd_pr__model__cap_mim
C$637 \$0$17 TOP_N\x7cVINN 8.664e-15
* device instance $638 r0 *1 0,0 sky130_fd_pr__model__cap_mim
C$638 \$0$8 TOP_P\x7cVINP 8.664e-15
* device instance $639 r0 *1 0,0 sky130_fd_pr__model__cap_mim
C$639 \$0$17 TOP_N\x7cVINN 8.664e-15
* device instance $640 r0 *1 0,0 sky130_fd_pr__model__cap_mim
C$640 \$0$8 TOP_P\x7cVINP 8.664e-15
* device instance $641 r0 *1 0,0 sky130_fd_pr__model__cap_mim
C$641 \$0$17 TOP_N\x7cVINN 8.664e-15
* device instance $642 r0 *1 0,0 sky130_fd_pr__model__cap_mim
C$642 \$0$8 TOP_P\x7cVINP 8.664e-15
* device instance $643 r0 *1 0,0 sky130_fd_pr__model__cap_mim
C$643 \$0$17 TOP_N\x7cVINN 8.664e-15
* device instance $644 r0 *1 0,0 sky130_fd_pr__model__cap_mim
C$644 \$0$8 TOP_P\x7cVINP 8.664e-15
* device instance $645 r0 *1 0,0 sky130_fd_pr__model__cap_mim
C$645 \$0$7 TOP_P\x7cVINP 8.664e-15
* device instance $646 r0 *1 0,0 sky130_fd_pr__model__cap_mim
C$646 \$0$16 TOP_N\x7cVINN 8.664e-15
* device instance $647 r0 *1 0,0 sky130_fd_pr__model__cap_mim
C$647 \$0$7 TOP_P\x7cVINP 8.664e-15
* device instance $648 r0 *1 0,0 sky130_fd_pr__model__cap_mim
C$648 \$0$16 TOP_N\x7cVINN 8.664e-15
* device instance $649 r0 *1 0,0 sky130_fd_pr__model__cap_mim
C$649 \$0$7 TOP_P\x7cVINP 8.664e-15
* device instance $650 r0 *1 0,0 sky130_fd_pr__model__cap_mim
C$650 \$0$16 TOP_N\x7cVINN 8.664e-15
* device instance $651 r0 *1 0,0 sky130_fd_pr__model__cap_mim
C$651 \$0$7 TOP_P\x7cVINP 8.664e-15
* device instance $652 r0 *1 0,0 sky130_fd_pr__model__cap_mim
C$652 \$0$16 TOP_N\x7cVINN 8.664e-15
* device instance $653 r0 *1 0,0 sky130_fd_pr__model__cap_mim
C$653 \$0$16 TOP_N\x7cVINN 8.664e-15
* device instance $654 r0 *1 0,0 sky130_fd_pr__model__cap_mim
C$654 \$0$7 TOP_P\x7cVINP 8.664e-15
* device instance $655 r0 *1 0,0 sky130_fd_pr__model__cap_mim
C$655 \$0$16 TOP_N\x7cVINN 8.664e-15
* device instance $656 r0 *1 0,0 sky130_fd_pr__model__cap_mim
C$656 \$0$7 TOP_P\x7cVINP 8.664e-15
* device instance $657 r0 *1 0,0 sky130_fd_pr__model__cap_mim
C$657 \$0$16 TOP_N\x7cVINN 8.664e-15
* device instance $658 r0 *1 0,0 sky130_fd_pr__model__cap_mim
C$658 \$0$7 TOP_P\x7cVINP 8.664e-15
* device instance $659 r0 *1 0,0 sky130_fd_pr__model__cap_mim
C$659 \$0$16 TOP_N\x7cVINN 8.664e-15
* device instance $660 r0 *1 0,0 sky130_fd_pr__model__cap_mim
C$660 \$0$7 TOP_P\x7cVINP 8.664e-15
* device instance $661 r0 *1 0,0 sky130_fd_pr__model__cap_mim
C$661 \$0$8 TOP_P\x7cVINP 8.664e-15
* device instance $662 r0 *1 0,0 sky130_fd_pr__model__cap_mim
C$662 \$0$17 TOP_N\x7cVINN 8.664e-15
* device instance $663 r0 *1 0,0 sky130_fd_pr__model__cap_mim
C$663 \$0$8 TOP_P\x7cVINP 8.664e-15
* device instance $664 r0 *1 0,0 sky130_fd_pr__model__cap_mim
C$664 \$0$17 TOP_N\x7cVINN 8.664e-15
* device instance $665 r0 *1 0,0 sky130_fd_pr__model__cap_mim
C$665 \$0$8 TOP_P\x7cVINP 8.664e-15
* device instance $666 r0 *1 0,0 sky130_fd_pr__model__cap_mim
C$666 \$0$17 TOP_N\x7cVINN 8.664e-15
* device instance $667 r0 *1 0,0 sky130_fd_pr__model__cap_mim
C$667 \$0$8 TOP_P\x7cVINP 8.664e-15
* device instance $668 r0 *1 0,0 sky130_fd_pr__model__cap_mim
C$668 \$0$17 TOP_N\x7cVINN 8.664e-15
* device instance $669 r0 *1 0,0 sky130_fd_pr__model__cap_mim
C$669 \$0$17 TOP_N\x7cVINN 8.664e-15
* device instance $670 r0 *1 0,0 sky130_fd_pr__model__cap_mim
C$670 \$0$8 TOP_P\x7cVINP 8.664e-15
* device instance $671 r0 *1 0,0 sky130_fd_pr__model__cap_mim
C$671 \$0$17 TOP_N\x7cVINN 8.664e-15
* device instance $672 r0 *1 0,0 sky130_fd_pr__model__cap_mim
C$672 \$0$8 TOP_P\x7cVINP 8.664e-15
* device instance $673 r0 *1 0,0 sky130_fd_pr__model__cap_mim
C$673 \$0$17 TOP_N\x7cVINN 8.664e-15
* device instance $674 r0 *1 0,0 sky130_fd_pr__model__cap_mim
C$674 \$0$8 TOP_P\x7cVINP 8.664e-15
* device instance $675 r0 *1 0,0 sky130_fd_pr__model__cap_mim
C$675 \$0$17 TOP_N\x7cVINN 8.664e-15
* device instance $676 r0 *1 0,0 sky130_fd_pr__model__cap_mim
C$676 \$0$8 TOP_P\x7cVINP 8.664e-15
* device instance $677 r0 *1 0,0 sky130_fd_pr__model__cap_mim
C$677 \$0$5 TOP_P\x7cVINP 8.664e-15
* device instance $678 r0 *1 0,0 sky130_fd_pr__model__cap_mim
C$678 \$0$14 TOP_N\x7cVINN 8.664e-15
* device instance $679 r0 *1 0,0 sky130_fd_pr__model__cap_mim
C$679 \$0$5 TOP_P\x7cVINP 8.664e-15
* device instance $680 r0 *1 0,0 sky130_fd_pr__model__cap_mim
C$680 \$0$14 TOP_N\x7cVINN 8.664e-15
* device instance $681 r0 *1 0,0 sky130_fd_pr__model__cap_mim
C$681 \$0$5 TOP_P\x7cVINP 8.664e-15
* device instance $682 r0 *1 0,0 sky130_fd_pr__model__cap_mim
C$682 \$0$14 TOP_N\x7cVINN 8.664e-15
* device instance $683 r0 *1 0,0 sky130_fd_pr__model__cap_mim
C$683 \$0$5 TOP_P\x7cVINP 8.664e-15
* device instance $684 r0 *1 0,0 sky130_fd_pr__model__cap_mim
C$684 \$0$14 TOP_N\x7cVINN 8.664e-15
* device instance $685 r0 *1 0,0 sky130_fd_pr__model__cap_mim
C$685 \$0$14 TOP_N\x7cVINN 8.664e-15
* device instance $686 r0 *1 0,0 sky130_fd_pr__model__cap_mim
C$686 \$0$5 TOP_P\x7cVINP 8.664e-15
* device instance $687 r0 *1 0,0 sky130_fd_pr__model__cap_mim
C$687 \$0$14 TOP_N\x7cVINN 8.664e-15
* device instance $688 r0 *1 0,0 sky130_fd_pr__model__cap_mim
C$688 \$0$5 TOP_P\x7cVINP 8.664e-15
* device instance $689 r0 *1 0,0 sky130_fd_pr__model__cap_mim
C$689 \$0$14 TOP_N\x7cVINN 8.664e-15
* device instance $690 r0 *1 0,0 sky130_fd_pr__model__cap_mim
C$690 \$0$5 TOP_P\x7cVINP 8.664e-15
* device instance $691 r0 *1 0,0 sky130_fd_pr__model__cap_mim
C$691 \$0$14 TOP_N\x7cVINN 8.664e-15
* device instance $692 r0 *1 0,0 sky130_fd_pr__model__cap_mim
C$692 \$0$5 TOP_P\x7cVINP 8.664e-15
* device instance $693 r0 *1 0,0 sky130_fd_pr__model__cap_mim
C$693 \$0$8 TOP_P\x7cVINP 8.664e-15
* device instance $694 r0 *1 0,0 sky130_fd_pr__model__cap_mim
C$694 \$0$17 TOP_N\x7cVINN 8.664e-15
* device instance $695 r0 *1 0,0 sky130_fd_pr__model__cap_mim
C$695 \$0$8 TOP_P\x7cVINP 8.664e-15
* device instance $696 r0 *1 0,0 sky130_fd_pr__model__cap_mim
C$696 \$0$17 TOP_N\x7cVINN 8.664e-15
* device instance $697 r0 *1 0,0 sky130_fd_pr__model__cap_mim
C$697 \$0$8 TOP_P\x7cVINP 8.664e-15
* device instance $698 r0 *1 0,0 sky130_fd_pr__model__cap_mim
C$698 \$0$17 TOP_N\x7cVINN 8.664e-15
* device instance $699 r0 *1 0,0 sky130_fd_pr__model__cap_mim
C$699 \$0$8 TOP_P\x7cVINP 8.664e-15
* device instance $700 r0 *1 0,0 sky130_fd_pr__model__cap_mim
C$700 \$0$17 TOP_N\x7cVINN 8.664e-15
* device instance $701 r0 *1 0,0 sky130_fd_pr__model__cap_mim
C$701 \$0$17 TOP_N\x7cVINN 8.664e-15
* device instance $702 r0 *1 0,0 sky130_fd_pr__model__cap_mim
C$702 \$0$8 TOP_P\x7cVINP 8.664e-15
* device instance $703 r0 *1 0,0 sky130_fd_pr__model__cap_mim
C$703 \$0$17 TOP_N\x7cVINN 8.664e-15
* device instance $704 r0 *1 0,0 sky130_fd_pr__model__cap_mim
C$704 \$0$8 TOP_P\x7cVINP 8.664e-15
* device instance $705 r0 *1 0,0 sky130_fd_pr__model__cap_mim
C$705 \$0$17 TOP_N\x7cVINN 8.664e-15
* device instance $706 r0 *1 0,0 sky130_fd_pr__model__cap_mim
C$706 \$0$8 TOP_P\x7cVINP 8.664e-15
* device instance $707 r0 *1 0,0 sky130_fd_pr__model__cap_mim
C$707 \$0$17 TOP_N\x7cVINN 8.664e-15
* device instance $708 r0 *1 0,0 sky130_fd_pr__model__cap_mim
C$708 \$0$8 TOP_P\x7cVINP 8.664e-15
* device instance $709 r0 *1 0,0 sky130_fd_pr__model__cap_mim
C$709 \$0$7 TOP_P\x7cVINP 8.664e-15
* device instance $710 r0 *1 0,0 sky130_fd_pr__model__cap_mim
C$710 \$0$16 TOP_N\x7cVINN 8.664e-15
* device instance $711 r0 *1 0,0 sky130_fd_pr__model__cap_mim
C$711 \$0$7 TOP_P\x7cVINP 8.664e-15
* device instance $712 r0 *1 0,0 sky130_fd_pr__model__cap_mim
C$712 \$0$16 TOP_N\x7cVINN 8.664e-15
* device instance $713 r0 *1 0,0 sky130_fd_pr__model__cap_mim
C$713 \$0$7 TOP_P\x7cVINP 8.664e-15
* device instance $714 r0 *1 0,0 sky130_fd_pr__model__cap_mim
C$714 \$0$16 TOP_N\x7cVINN 8.664e-15
* device instance $715 r0 *1 0,0 sky130_fd_pr__model__cap_mim
C$715 \$0$7 TOP_P\x7cVINP 8.664e-15
* device instance $716 r0 *1 0,0 sky130_fd_pr__model__cap_mim
C$716 \$0$16 TOP_N\x7cVINN 8.664e-15
* device instance $717 r0 *1 0,0 sky130_fd_pr__model__cap_mim
C$717 \$0$16 TOP_N\x7cVINN 8.664e-15
* device instance $718 r0 *1 0,0 sky130_fd_pr__model__cap_mim
C$718 \$0$7 TOP_P\x7cVINP 8.664e-15
* device instance $719 r0 *1 0,0 sky130_fd_pr__model__cap_mim
C$719 \$0$16 TOP_N\x7cVINN 8.664e-15
* device instance $720 r0 *1 0,0 sky130_fd_pr__model__cap_mim
C$720 \$0$7 TOP_P\x7cVINP 8.664e-15
* device instance $721 r0 *1 0,0 sky130_fd_pr__model__cap_mim
C$721 \$0$16 TOP_N\x7cVINN 8.664e-15
* device instance $722 r0 *1 0,0 sky130_fd_pr__model__cap_mim
C$722 \$0$7 TOP_P\x7cVINP 8.664e-15
* device instance $723 r0 *1 0,0 sky130_fd_pr__model__cap_mim
C$723 \$0$16 TOP_N\x7cVINN 8.664e-15
* device instance $724 r0 *1 0,0 sky130_fd_pr__model__cap_mim
C$724 \$0$7 TOP_P\x7cVINP 8.664e-15
* device instance $725 r0 *1 0,0 sky130_fd_pr__model__cap_mim
C$725 \$0$8 TOP_P\x7cVINP 8.664e-15
* device instance $726 r0 *1 0,0 sky130_fd_pr__model__cap_mim
C$726 \$0$17 TOP_N\x7cVINN 8.664e-15
* device instance $727 r0 *1 0,0 sky130_fd_pr__model__cap_mim
C$727 \$0$8 TOP_P\x7cVINP 8.664e-15
* device instance $728 r0 *1 0,0 sky130_fd_pr__model__cap_mim
C$728 \$0$17 TOP_N\x7cVINN 8.664e-15
* device instance $729 r0 *1 0,0 sky130_fd_pr__model__cap_mim
C$729 \$0$8 TOP_P\x7cVINP 8.664e-15
* device instance $730 r0 *1 0,0 sky130_fd_pr__model__cap_mim
C$730 \$0$17 TOP_N\x7cVINN 8.664e-15
* device instance $731 r0 *1 0,0 sky130_fd_pr__model__cap_mim
C$731 \$0$8 TOP_P\x7cVINP 8.664e-15
* device instance $732 r0 *1 0,0 sky130_fd_pr__model__cap_mim
C$732 \$0$17 TOP_N\x7cVINN 8.664e-15
* device instance $733 r0 *1 0,0 sky130_fd_pr__model__cap_mim
C$733 \$0$17 TOP_N\x7cVINN 8.664e-15
* device instance $734 r0 *1 0,0 sky130_fd_pr__model__cap_mim
C$734 \$0$8 TOP_P\x7cVINP 8.664e-15
* device instance $735 r0 *1 0,0 sky130_fd_pr__model__cap_mim
C$735 \$0$17 TOP_N\x7cVINN 8.664e-15
* device instance $736 r0 *1 0,0 sky130_fd_pr__model__cap_mim
C$736 \$0$8 TOP_P\x7cVINP 8.664e-15
* device instance $737 r0 *1 0,0 sky130_fd_pr__model__cap_mim
C$737 \$0$17 TOP_N\x7cVINN 8.664e-15
* device instance $738 r0 *1 0,0 sky130_fd_pr__model__cap_mim
C$738 \$0$8 TOP_P\x7cVINP 8.664e-15
* device instance $739 r0 *1 0,0 sky130_fd_pr__model__cap_mim
C$739 \$0$17 TOP_N\x7cVINN 8.664e-15
* device instance $740 r0 *1 0,0 sky130_fd_pr__model__cap_mim
C$740 \$0$8 TOP_P\x7cVINP 8.664e-15
* device instance $741 r0 *1 0,0 sky130_fd_pr__model__cap_mim
C$741 \$0$6 TOP_P\x7cVINP 8.664e-15
* device instance $742 r0 *1 0,0 sky130_fd_pr__model__cap_mim
C$742 \$0$15 TOP_N\x7cVINN 8.664e-15
* device instance $743 r0 *1 0,0 sky130_fd_pr__model__cap_mim
C$743 \$0$6 TOP_P\x7cVINP 8.664e-15
* device instance $744 r0 *1 0,0 sky130_fd_pr__model__cap_mim
C$744 \$0$15 TOP_N\x7cVINN 8.664e-15
* device instance $745 r0 *1 0,0 sky130_fd_pr__model__cap_mim
C$745 \$0$6 TOP_P\x7cVINP 8.664e-15
* device instance $746 r0 *1 0,0 sky130_fd_pr__model__cap_mim
C$746 \$0$15 TOP_N\x7cVINN 8.664e-15
* device instance $747 r0 *1 0,0 sky130_fd_pr__model__cap_mim
C$747 \$0$6 TOP_P\x7cVINP 8.664e-15
* device instance $748 r0 *1 0,0 sky130_fd_pr__model__cap_mim
C$748 \$0$15 TOP_N\x7cVINN 8.664e-15
* device instance $749 r0 *1 0,0 sky130_fd_pr__model__cap_mim
C$749 \$0$15 TOP_N\x7cVINN 8.664e-15
* device instance $750 r0 *1 0,0 sky130_fd_pr__model__cap_mim
C$750 \$0$6 TOP_P\x7cVINP 8.664e-15
* device instance $751 r0 *1 0,0 sky130_fd_pr__model__cap_mim
C$751 \$0$15 TOP_N\x7cVINN 8.664e-15
* device instance $752 r0 *1 0,0 sky130_fd_pr__model__cap_mim
C$752 \$0$6 TOP_P\x7cVINP 8.664e-15
* device instance $753 r0 *1 0,0 sky130_fd_pr__model__cap_mim
C$753 \$0$15 TOP_N\x7cVINN 8.664e-15
* device instance $754 r0 *1 0,0 sky130_fd_pr__model__cap_mim
C$754 \$0$6 TOP_P\x7cVINP 8.664e-15
* device instance $755 r0 *1 0,0 sky130_fd_pr__model__cap_mim
C$755 \$0$15 TOP_N\x7cVINN 8.664e-15
* device instance $756 r0 *1 0,0 sky130_fd_pr__model__cap_mim
C$756 \$0$6 TOP_P\x7cVINP 8.664e-15
* device instance $757 r0 *1 0,0 sky130_fd_pr__model__cap_mim
C$757 \$0$8 TOP_P\x7cVINP 8.664e-15
* device instance $758 r0 *1 0,0 sky130_fd_pr__model__cap_mim
C$758 \$0$17 TOP_N\x7cVINN 8.664e-15
* device instance $759 r0 *1 0,0 sky130_fd_pr__model__cap_mim
C$759 \$0$8 TOP_P\x7cVINP 8.664e-15
* device instance $760 r0 *1 0,0 sky130_fd_pr__model__cap_mim
C$760 \$0$17 TOP_N\x7cVINN 8.664e-15
* device instance $761 r0 *1 0,0 sky130_fd_pr__model__cap_mim
C$761 \$0$8 TOP_P\x7cVINP 8.664e-15
* device instance $762 r0 *1 0,0 sky130_fd_pr__model__cap_mim
C$762 \$0$17 TOP_N\x7cVINN 8.664e-15
* device instance $763 r0 *1 0,0 sky130_fd_pr__model__cap_mim
C$763 \$0$8 TOP_P\x7cVINP 8.664e-15
* device instance $764 r0 *1 0,0 sky130_fd_pr__model__cap_mim
C$764 \$0$17 TOP_N\x7cVINN 8.664e-15
* device instance $765 r0 *1 0,0 sky130_fd_pr__model__cap_mim
C$765 \$0$17 TOP_N\x7cVINN 8.664e-15
* device instance $766 r0 *1 0,0 sky130_fd_pr__model__cap_mim
C$766 \$0$8 TOP_P\x7cVINP 8.664e-15
* device instance $767 r0 *1 0,0 sky130_fd_pr__model__cap_mim
C$767 \$0$17 TOP_N\x7cVINN 8.664e-15
* device instance $768 r0 *1 0,0 sky130_fd_pr__model__cap_mim
C$768 \$0$8 TOP_P\x7cVINP 8.664e-15
* device instance $769 r0 *1 0,0 sky130_fd_pr__model__cap_mim
C$769 \$0$17 TOP_N\x7cVINN 8.664e-15
* device instance $770 r0 *1 0,0 sky130_fd_pr__model__cap_mim
C$770 \$0$8 TOP_P\x7cVINP 8.664e-15
* device instance $771 r0 *1 0,0 sky130_fd_pr__model__cap_mim
C$771 \$0$17 TOP_N\x7cVINN 8.664e-15
* device instance $772 r0 *1 0,0 sky130_fd_pr__model__cap_mim
C$772 \$0$8 TOP_P\x7cVINP 8.664e-15
* device instance $773 r0 *1 0,0 sky130_fd_pr__model__cap_mim
C$773 \$0$7 TOP_P\x7cVINP 8.664e-15
* device instance $774 r0 *1 0,0 sky130_fd_pr__model__cap_mim
C$774 \$0$16 TOP_N\x7cVINN 8.664e-15
* device instance $775 r0 *1 0,0 sky130_fd_pr__model__cap_mim
C$775 \$0$7 TOP_P\x7cVINP 8.664e-15
* device instance $776 r0 *1 0,0 sky130_fd_pr__model__cap_mim
C$776 \$0$16 TOP_N\x7cVINN 8.664e-15
* device instance $777 r0 *1 0,0 sky130_fd_pr__model__cap_mim
C$777 \$0$7 TOP_P\x7cVINP 8.664e-15
* device instance $778 r0 *1 0,0 sky130_fd_pr__model__cap_mim
C$778 \$0$16 TOP_N\x7cVINN 8.664e-15
* device instance $779 r0 *1 0,0 sky130_fd_pr__model__cap_mim
C$779 \$0$7 TOP_P\x7cVINP 8.664e-15
* device instance $780 r0 *1 0,0 sky130_fd_pr__model__cap_mim
C$780 \$0$16 TOP_N\x7cVINN 8.664e-15
* device instance $781 r0 *1 0,0 sky130_fd_pr__model__cap_mim
C$781 \$0$16 TOP_N\x7cVINN 8.664e-15
* device instance $782 r0 *1 0,0 sky130_fd_pr__model__cap_mim
C$782 \$0$7 TOP_P\x7cVINP 8.664e-15
* device instance $783 r0 *1 0,0 sky130_fd_pr__model__cap_mim
C$783 \$0$16 TOP_N\x7cVINN 8.664e-15
* device instance $784 r0 *1 0,0 sky130_fd_pr__model__cap_mim
C$784 \$0$7 TOP_P\x7cVINP 8.664e-15
* device instance $785 r0 *1 0,0 sky130_fd_pr__model__cap_mim
C$785 \$0$16 TOP_N\x7cVINN 8.664e-15
* device instance $786 r0 *1 0,0 sky130_fd_pr__model__cap_mim
C$786 \$0$7 TOP_P\x7cVINP 8.664e-15
* device instance $787 r0 *1 0,0 sky130_fd_pr__model__cap_mim
C$787 \$0$16 TOP_N\x7cVINN 8.664e-15
* device instance $788 r0 *1 0,0 sky130_fd_pr__model__cap_mim
C$788 \$0$7 TOP_P\x7cVINP 8.664e-15
* device instance $789 r0 *1 0,0 sky130_fd_pr__model__cap_mim
C$789 \$0$8 TOP_P\x7cVINP 8.664e-15
* device instance $790 r0 *1 0,0 sky130_fd_pr__model__cap_mim
C$790 \$0$17 TOP_N\x7cVINN 8.664e-15
* device instance $791 r0 *1 0,0 sky130_fd_pr__model__cap_mim
C$791 \$0$8 TOP_P\x7cVINP 8.664e-15
* device instance $792 r0 *1 0,0 sky130_fd_pr__model__cap_mim
C$792 \$0$17 TOP_N\x7cVINN 8.664e-15
* device instance $793 r0 *1 0,0 sky130_fd_pr__model__cap_mim
C$793 \$0$8 TOP_P\x7cVINP 8.664e-15
* device instance $794 r0 *1 0,0 sky130_fd_pr__model__cap_mim
C$794 \$0$17 TOP_N\x7cVINN 8.664e-15
* device instance $795 r0 *1 0,0 sky130_fd_pr__model__cap_mim
C$795 \$0$8 TOP_P\x7cVINP 8.664e-15
* device instance $796 r0 *1 0,0 sky130_fd_pr__model__cap_mim
C$796 \$0$17 TOP_N\x7cVINN 8.664e-15
* device instance $797 r0 *1 0,0 sky130_fd_pr__model__cap_mim
C$797 \$0$17 TOP_N\x7cVINN 8.664e-15
* device instance $798 r0 *1 0,0 sky130_fd_pr__model__cap_mim
C$798 \$0$8 TOP_P\x7cVINP 8.664e-15
* device instance $799 r0 *1 0,0 sky130_fd_pr__model__cap_mim
C$799 \$0$17 TOP_N\x7cVINN 8.664e-15
* device instance $800 r0 *1 0,0 sky130_fd_pr__model__cap_mim
C$800 \$0$8 TOP_P\x7cVINP 8.664e-15
* device instance $801 r0 *1 0,0 sky130_fd_pr__model__cap_mim
C$801 \$0$17 TOP_N\x7cVINN 8.664e-15
* device instance $802 r0 *1 0,0 sky130_fd_pr__model__cap_mim
C$802 \$0$8 TOP_P\x7cVINP 8.664e-15
* device instance $803 r0 *1 0,0 sky130_fd_pr__model__cap_mim
C$803 \$0$17 TOP_N\x7cVINN 8.664e-15
* device instance $804 r0 *1 0,0 sky130_fd_pr__model__cap_mim
C$804 \$0$8 TOP_P\x7cVINP 8.664e-15
* device instance $805 r0 *1 0,0 sky130_fd_pr__model__cap_mim
C$805 \$0$4 TOP_P\x7cVINP 8.664e-15
* device instance $806 r0 *1 0,0 sky130_fd_pr__model__cap_mim
C$806 \$0$13 TOP_N\x7cVINN 8.664e-15
* device instance $807 r0 *1 0,0 sky130_fd_pr__model__cap_mim
C$807 \$0$4 TOP_P\x7cVINP 8.664e-15
* device instance $808 r0 *1 0,0 sky130_fd_pr__model__cap_mim
C$808 \$0$13 TOP_N\x7cVINN 8.664e-15
* device instance $809 r0 *1 0,0 sky130_fd_pr__model__cap_mim
C$809 \$0$4 TOP_P\x7cVINP 8.664e-15
* device instance $810 r0 *1 0,0 sky130_fd_pr__model__cap_mim
C$810 \$0$13 TOP_N\x7cVINN 8.664e-15
* device instance $811 r0 *1 0,0 sky130_fd_pr__model__cap_mim
C$811 \$0$4 TOP_P\x7cVINP 8.664e-15
* device instance $812 r0 *1 0,0 sky130_fd_pr__model__cap_mim
C$812 \$0$13 TOP_N\x7cVINN 8.664e-15
* device instance $813 r0 *1 0,0 sky130_fd_pr__model__cap_mim
C$813 \$0$13 TOP_N\x7cVINN 8.664e-15
* device instance $814 r0 *1 0,0 sky130_fd_pr__model__cap_mim
C$814 \$0$4 TOP_P\x7cVINP 8.664e-15
* device instance $815 r0 *1 0,0 sky130_fd_pr__model__cap_mim
C$815 \$0$13 TOP_N\x7cVINN 8.664e-15
* device instance $816 r0 *1 0,0 sky130_fd_pr__model__cap_mim
C$816 \$0$4 TOP_P\x7cVINP 8.664e-15
* device instance $817 r0 *1 0,0 sky130_fd_pr__model__cap_mim
C$817 \$0$13 TOP_N\x7cVINN 8.664e-15
* device instance $818 r0 *1 0,0 sky130_fd_pr__model__cap_mim
C$818 \$0$4 TOP_P\x7cVINP 8.664e-15
* device instance $819 r0 *1 0,0 sky130_fd_pr__model__cap_mim
C$819 \$0$13 TOP_N\x7cVINN 8.664e-15
* device instance $820 r0 *1 0,0 sky130_fd_pr__model__cap_mim
C$820 \$0$4 TOP_P\x7cVINP 8.664e-15
* device instance $821 r0 *1 0,0 sky130_fd_pr__model__cap_mim
C$821 \$0$8 TOP_P\x7cVINP 8.664e-15
* device instance $822 r0 *1 0,0 sky130_fd_pr__model__cap_mim
C$822 \$0$17 TOP_N\x7cVINN 8.664e-15
* device instance $823 r0 *1 0,0 sky130_fd_pr__model__cap_mim
C$823 \$0$8 TOP_P\x7cVINP 8.664e-15
* device instance $824 r0 *1 0,0 sky130_fd_pr__model__cap_mim
C$824 \$0$17 TOP_N\x7cVINN 8.664e-15
* device instance $825 r0 *1 0,0 sky130_fd_pr__model__cap_mim
C$825 \$0$8 TOP_P\x7cVINP 8.664e-15
* device instance $826 r0 *1 0,0 sky130_fd_pr__model__cap_mim
C$826 \$0$17 TOP_N\x7cVINN 8.664e-15
* device instance $827 r0 *1 0,0 sky130_fd_pr__model__cap_mim
C$827 \$0$8 TOP_P\x7cVINP 8.664e-15
* device instance $828 r0 *1 0,0 sky130_fd_pr__model__cap_mim
C$828 \$0$17 TOP_N\x7cVINN 8.664e-15
* device instance $829 r0 *1 0,0 sky130_fd_pr__model__cap_mim
C$829 \$0$17 TOP_N\x7cVINN 8.664e-15
* device instance $830 r0 *1 0,0 sky130_fd_pr__model__cap_mim
C$830 \$0$8 TOP_P\x7cVINP 8.664e-15
* device instance $831 r0 *1 0,0 sky130_fd_pr__model__cap_mim
C$831 \$0$17 TOP_N\x7cVINN 8.664e-15
* device instance $832 r0 *1 0,0 sky130_fd_pr__model__cap_mim
C$832 \$0$8 TOP_P\x7cVINP 8.664e-15
* device instance $833 r0 *1 0,0 sky130_fd_pr__model__cap_mim
C$833 \$0$17 TOP_N\x7cVINN 8.664e-15
* device instance $834 r0 *1 0,0 sky130_fd_pr__model__cap_mim
C$834 \$0$8 TOP_P\x7cVINP 8.664e-15
* device instance $835 r0 *1 0,0 sky130_fd_pr__model__cap_mim
C$835 \$0$17 TOP_N\x7cVINN 8.664e-15
* device instance $836 r0 *1 0,0 sky130_fd_pr__model__cap_mim
C$836 \$0$8 TOP_P\x7cVINP 8.664e-15
* device instance $837 r0 *1 0,0 sky130_fd_pr__model__cap_mim
C$837 \$0$7 TOP_P\x7cVINP 8.664e-15
* device instance $838 r0 *1 0,0 sky130_fd_pr__model__cap_mim
C$838 \$0$16 TOP_N\x7cVINN 8.664e-15
* device instance $839 r0 *1 0,0 sky130_fd_pr__model__cap_mim
C$839 \$0$7 TOP_P\x7cVINP 8.664e-15
* device instance $840 r0 *1 0,0 sky130_fd_pr__model__cap_mim
C$840 \$0$16 TOP_N\x7cVINN 8.664e-15
* device instance $841 r0 *1 0,0 sky130_fd_pr__model__cap_mim
C$841 \$0$7 TOP_P\x7cVINP 8.664e-15
* device instance $842 r0 *1 0,0 sky130_fd_pr__model__cap_mim
C$842 \$0$16 TOP_N\x7cVINN 8.664e-15
* device instance $843 r0 *1 0,0 sky130_fd_pr__model__cap_mim
C$843 \$0$7 TOP_P\x7cVINP 8.664e-15
* device instance $844 r0 *1 0,0 sky130_fd_pr__model__cap_mim
C$844 \$0$16 TOP_N\x7cVINN 8.664e-15
* device instance $845 r0 *1 0,0 sky130_fd_pr__model__cap_mim
C$845 \$0$16 TOP_N\x7cVINN 8.664e-15
* device instance $846 r0 *1 0,0 sky130_fd_pr__model__cap_mim
C$846 \$0$7 TOP_P\x7cVINP 8.664e-15
* device instance $847 r0 *1 0,0 sky130_fd_pr__model__cap_mim
C$847 \$0$16 TOP_N\x7cVINN 8.664e-15
* device instance $848 r0 *1 0,0 sky130_fd_pr__model__cap_mim
C$848 \$0$7 TOP_P\x7cVINP 8.664e-15
* device instance $849 r0 *1 0,0 sky130_fd_pr__model__cap_mim
C$849 \$0$16 TOP_N\x7cVINN 8.664e-15
* device instance $850 r0 *1 0,0 sky130_fd_pr__model__cap_mim
C$850 \$0$7 TOP_P\x7cVINP 8.664e-15
* device instance $851 r0 *1 0,0 sky130_fd_pr__model__cap_mim
C$851 \$0$16 TOP_N\x7cVINN 8.664e-15
* device instance $852 r0 *1 0,0 sky130_fd_pr__model__cap_mim
C$852 \$0$7 TOP_P\x7cVINP 8.664e-15
* device instance $853 r0 *1 0,0 sky130_fd_pr__model__cap_mim
C$853 \$0$8 TOP_P\x7cVINP 8.664e-15
* device instance $854 r0 *1 0,0 sky130_fd_pr__model__cap_mim
C$854 \$0$17 TOP_N\x7cVINN 8.664e-15
* device instance $855 r0 *1 0,0 sky130_fd_pr__model__cap_mim
C$855 \$0$8 TOP_P\x7cVINP 8.664e-15
* device instance $856 r0 *1 0,0 sky130_fd_pr__model__cap_mim
C$856 \$0$17 TOP_N\x7cVINN 8.664e-15
* device instance $857 r0 *1 0,0 sky130_fd_pr__model__cap_mim
C$857 \$0$8 TOP_P\x7cVINP 8.664e-15
* device instance $858 r0 *1 0,0 sky130_fd_pr__model__cap_mim
C$858 \$0$17 TOP_N\x7cVINN 8.664e-15
* device instance $859 r0 *1 0,0 sky130_fd_pr__model__cap_mim
C$859 \$0$8 TOP_P\x7cVINP 8.664e-15
* device instance $860 r0 *1 0,0 sky130_fd_pr__model__cap_mim
C$860 \$0$17 TOP_N\x7cVINN 8.664e-15
* device instance $861 r0 *1 0,0 sky130_fd_pr__model__cap_mim
C$861 \$0$17 TOP_N\x7cVINN 8.664e-15
* device instance $862 r0 *1 0,0 sky130_fd_pr__model__cap_mim
C$862 \$0$8 TOP_P\x7cVINP 8.664e-15
* device instance $863 r0 *1 0,0 sky130_fd_pr__model__cap_mim
C$863 \$0$17 TOP_N\x7cVINN 8.664e-15
* device instance $864 r0 *1 0,0 sky130_fd_pr__model__cap_mim
C$864 \$0$8 TOP_P\x7cVINP 8.664e-15
* device instance $865 r0 *1 0,0 sky130_fd_pr__model__cap_mim
C$865 \$0$17 TOP_N\x7cVINN 8.664e-15
* device instance $866 r0 *1 0,0 sky130_fd_pr__model__cap_mim
C$866 \$0$8 TOP_P\x7cVINP 8.664e-15
* device instance $867 r0 *1 0,0 sky130_fd_pr__model__cap_mim
C$867 \$0$17 TOP_N\x7cVINN 8.664e-15
* device instance $868 r0 *1 0,0 sky130_fd_pr__model__cap_mim
C$868 \$0$8 TOP_P\x7cVINP 8.664e-15
* device instance $869 r0 *1 0,0 sky130_fd_pr__model__cap_mim
C$869 \$0$6 TOP_P\x7cVINP 8.664e-15
* device instance $870 r0 *1 0,0 sky130_fd_pr__model__cap_mim
C$870 \$0$15 TOP_N\x7cVINN 8.664e-15
* device instance $871 r0 *1 0,0 sky130_fd_pr__model__cap_mim
C$871 \$0$6 TOP_P\x7cVINP 8.664e-15
* device instance $872 r0 *1 0,0 sky130_fd_pr__model__cap_mim
C$872 \$0$15 TOP_N\x7cVINN 8.664e-15
* device instance $873 r0 *1 0,0 sky130_fd_pr__model__cap_mim
C$873 \$0$6 TOP_P\x7cVINP 8.664e-15
* device instance $874 r0 *1 0,0 sky130_fd_pr__model__cap_mim
C$874 \$0$15 TOP_N\x7cVINN 8.664e-15
* device instance $875 r0 *1 0,0 sky130_fd_pr__model__cap_mim
C$875 \$0$6 TOP_P\x7cVINP 8.664e-15
* device instance $876 r0 *1 0,0 sky130_fd_pr__model__cap_mim
C$876 \$0$15 TOP_N\x7cVINN 8.664e-15
* device instance $877 r0 *1 0,0 sky130_fd_pr__model__cap_mim
C$877 \$0$15 TOP_N\x7cVINN 8.664e-15
* device instance $878 r0 *1 0,0 sky130_fd_pr__model__cap_mim
C$878 \$0$6 TOP_P\x7cVINP 8.664e-15
* device instance $879 r0 *1 0,0 sky130_fd_pr__model__cap_mim
C$879 \$0$15 TOP_N\x7cVINN 8.664e-15
* device instance $880 r0 *1 0,0 sky130_fd_pr__model__cap_mim
C$880 \$0$6 TOP_P\x7cVINP 8.664e-15
* device instance $881 r0 *1 0,0 sky130_fd_pr__model__cap_mim
C$881 \$0$15 TOP_N\x7cVINN 8.664e-15
* device instance $882 r0 *1 0,0 sky130_fd_pr__model__cap_mim
C$882 \$0$6 TOP_P\x7cVINP 8.664e-15
* device instance $883 r0 *1 0,0 sky130_fd_pr__model__cap_mim
C$883 \$0$15 TOP_N\x7cVINN 8.664e-15
* device instance $884 r0 *1 0,0 sky130_fd_pr__model__cap_mim
C$884 \$0$6 TOP_P\x7cVINP 8.664e-15
* device instance $885 r0 *1 0,0 sky130_fd_pr__model__cap_mim
C$885 \$0$8 TOP_P\x7cVINP 8.664e-15
* device instance $886 r0 *1 0,0 sky130_fd_pr__model__cap_mim
C$886 \$0$17 TOP_N\x7cVINN 8.664e-15
* device instance $887 r0 *1 0,0 sky130_fd_pr__model__cap_mim
C$887 \$0$8 TOP_P\x7cVINP 8.664e-15
* device instance $888 r0 *1 0,0 sky130_fd_pr__model__cap_mim
C$888 \$0$17 TOP_N\x7cVINN 8.664e-15
* device instance $889 r0 *1 0,0 sky130_fd_pr__model__cap_mim
C$889 \$0$8 TOP_P\x7cVINP 8.664e-15
* device instance $890 r0 *1 0,0 sky130_fd_pr__model__cap_mim
C$890 \$0$17 TOP_N\x7cVINN 8.664e-15
* device instance $891 r0 *1 0,0 sky130_fd_pr__model__cap_mim
C$891 \$0$8 TOP_P\x7cVINP 8.664e-15
* device instance $892 r0 *1 0,0 sky130_fd_pr__model__cap_mim
C$892 \$0$17 TOP_N\x7cVINN 8.664e-15
* device instance $893 r0 *1 0,0 sky130_fd_pr__model__cap_mim
C$893 \$0$17 TOP_N\x7cVINN 8.664e-15
* device instance $894 r0 *1 0,0 sky130_fd_pr__model__cap_mim
C$894 \$0$8 TOP_P\x7cVINP 8.664e-15
* device instance $895 r0 *1 0,0 sky130_fd_pr__model__cap_mim
C$895 \$0$17 TOP_N\x7cVINN 8.664e-15
* device instance $896 r0 *1 0,0 sky130_fd_pr__model__cap_mim
C$896 \$0$8 TOP_P\x7cVINP 8.664e-15
* device instance $897 r0 *1 0,0 sky130_fd_pr__model__cap_mim
C$897 \$0$17 TOP_N\x7cVINN 8.664e-15
* device instance $898 r0 *1 0,0 sky130_fd_pr__model__cap_mim
C$898 \$0$8 TOP_P\x7cVINP 8.664e-15
* device instance $899 r0 *1 0,0 sky130_fd_pr__model__cap_mim
C$899 \$0$17 TOP_N\x7cVINN 8.664e-15
* device instance $900 r0 *1 0,0 sky130_fd_pr__model__cap_mim
C$900 \$0$8 TOP_P\x7cVINP 8.664e-15
* device instance $901 r0 *1 0,0 sky130_fd_pr__model__cap_mim
C$901 \$0$7 TOP_P\x7cVINP 8.664e-15
* device instance $902 r0 *1 0,0 sky130_fd_pr__model__cap_mim
C$902 \$0$16 TOP_N\x7cVINN 8.664e-15
* device instance $903 r0 *1 0,0 sky130_fd_pr__model__cap_mim
C$903 \$0$7 TOP_P\x7cVINP 8.664e-15
* device instance $904 r0 *1 0,0 sky130_fd_pr__model__cap_mim
C$904 \$0$16 TOP_N\x7cVINN 8.664e-15
* device instance $905 r0 *1 0,0 sky130_fd_pr__model__cap_mim
C$905 \$0$7 TOP_P\x7cVINP 8.664e-15
* device instance $906 r0 *1 0,0 sky130_fd_pr__model__cap_mim
C$906 \$0$16 TOP_N\x7cVINN 8.664e-15
* device instance $907 r0 *1 0,0 sky130_fd_pr__model__cap_mim
C$907 \$0$7 TOP_P\x7cVINP 8.664e-15
* device instance $908 r0 *1 0,0 sky130_fd_pr__model__cap_mim
C$908 \$0$16 TOP_N\x7cVINN 8.664e-15
* device instance $909 r0 *1 0,0 sky130_fd_pr__model__cap_mim
C$909 \$0$16 TOP_N\x7cVINN 8.664e-15
* device instance $910 r0 *1 0,0 sky130_fd_pr__model__cap_mim
C$910 \$0$7 TOP_P\x7cVINP 8.664e-15
* device instance $911 r0 *1 0,0 sky130_fd_pr__model__cap_mim
C$911 \$0$16 TOP_N\x7cVINN 8.664e-15
* device instance $912 r0 *1 0,0 sky130_fd_pr__model__cap_mim
C$912 \$0$7 TOP_P\x7cVINP 8.664e-15
* device instance $913 r0 *1 0,0 sky130_fd_pr__model__cap_mim
C$913 \$0$16 TOP_N\x7cVINN 8.664e-15
* device instance $914 r0 *1 0,0 sky130_fd_pr__model__cap_mim
C$914 \$0$7 TOP_P\x7cVINP 8.664e-15
* device instance $915 r0 *1 0,0 sky130_fd_pr__model__cap_mim
C$915 \$0$16 TOP_N\x7cVINN 8.664e-15
* device instance $916 r0 *1 0,0 sky130_fd_pr__model__cap_mim
C$916 \$0$7 TOP_P\x7cVINP 8.664e-15
* device instance $917 r0 *1 0,0 sky130_fd_pr__model__cap_mim
C$917 \$0$8 TOP_P\x7cVINP 8.664e-15
* device instance $918 r0 *1 0,0 sky130_fd_pr__model__cap_mim
C$918 \$0$17 TOP_N\x7cVINN 8.664e-15
* device instance $919 r0 *1 0,0 sky130_fd_pr__model__cap_mim
C$919 \$0$8 TOP_P\x7cVINP 8.664e-15
* device instance $920 r0 *1 0,0 sky130_fd_pr__model__cap_mim
C$920 \$0$17 TOP_N\x7cVINN 8.664e-15
* device instance $921 r0 *1 0,0 sky130_fd_pr__model__cap_mim
C$921 \$0$8 TOP_P\x7cVINP 8.664e-15
* device instance $922 r0 *1 0,0 sky130_fd_pr__model__cap_mim
C$922 \$0$17 TOP_N\x7cVINN 8.664e-15
* device instance $923 r0 *1 0,0 sky130_fd_pr__model__cap_mim
C$923 \$0$8 TOP_P\x7cVINP 8.664e-15
* device instance $924 r0 *1 0,0 sky130_fd_pr__model__cap_mim
C$924 \$0$17 TOP_N\x7cVINN 8.664e-15
* device instance $925 r0 *1 0,0 sky130_fd_pr__model__cap_mim
C$925 \$0$17 TOP_N\x7cVINN 8.664e-15
* device instance $926 r0 *1 0,0 sky130_fd_pr__model__cap_mim
C$926 \$0$8 TOP_P\x7cVINP 8.664e-15
* device instance $927 r0 *1 0,0 sky130_fd_pr__model__cap_mim
C$927 \$0$17 TOP_N\x7cVINN 8.664e-15
* device instance $928 r0 *1 0,0 sky130_fd_pr__model__cap_mim
C$928 \$0$8 TOP_P\x7cVINP 8.664e-15
* device instance $929 r0 *1 0,0 sky130_fd_pr__model__cap_mim
C$929 \$0$17 TOP_N\x7cVINN 8.664e-15
* device instance $930 r0 *1 0,0 sky130_fd_pr__model__cap_mim
C$930 \$0$8 TOP_P\x7cVINP 8.664e-15
* device instance $931 r0 *1 0,0 sky130_fd_pr__model__cap_mim
C$931 \$0$17 TOP_N\x7cVINN 8.664e-15
* device instance $932 r0 *1 0,0 sky130_fd_pr__model__cap_mim
C$932 \$0$8 TOP_P\x7cVINP 8.664e-15
* device instance $933 r0 *1 0,0 sky130_fd_pr__model__cap_mim
C$933 \$0$5 TOP_P\x7cVINP 8.664e-15
* device instance $934 r0 *1 0,0 sky130_fd_pr__model__cap_mim
C$934 \$0$14 TOP_N\x7cVINN 8.664e-15
* device instance $935 r0 *1 0,0 sky130_fd_pr__model__cap_mim
C$935 \$0$5 TOP_P\x7cVINP 8.664e-15
* device instance $936 r0 *1 0,0 sky130_fd_pr__model__cap_mim
C$936 \$0$14 TOP_N\x7cVINN 8.664e-15
* device instance $937 r0 *1 0,0 sky130_fd_pr__model__cap_mim
C$937 \$0$5 TOP_P\x7cVINP 8.664e-15
* device instance $938 r0 *1 0,0 sky130_fd_pr__model__cap_mim
C$938 \$0$14 TOP_N\x7cVINN 8.664e-15
* device instance $939 r0 *1 0,0 sky130_fd_pr__model__cap_mim
C$939 \$0$5 TOP_P\x7cVINP 8.664e-15
* device instance $940 r0 *1 0,0 sky130_fd_pr__model__cap_mim
C$940 \$0$14 TOP_N\x7cVINN 8.664e-15
* device instance $941 r0 *1 0,0 sky130_fd_pr__model__cap_mim
C$941 \$0$14 TOP_N\x7cVINN 8.664e-15
* device instance $942 r0 *1 0,0 sky130_fd_pr__model__cap_mim
C$942 \$0$5 TOP_P\x7cVINP 8.664e-15
* device instance $943 r0 *1 0,0 sky130_fd_pr__model__cap_mim
C$943 \$0$14 TOP_N\x7cVINN 8.664e-15
* device instance $944 r0 *1 0,0 sky130_fd_pr__model__cap_mim
C$944 \$0$5 TOP_P\x7cVINP 8.664e-15
* device instance $945 r0 *1 0,0 sky130_fd_pr__model__cap_mim
C$945 \$0$14 TOP_N\x7cVINN 8.664e-15
* device instance $946 r0 *1 0,0 sky130_fd_pr__model__cap_mim
C$946 \$0$5 TOP_P\x7cVINP 8.664e-15
* device instance $947 r0 *1 0,0 sky130_fd_pr__model__cap_mim
C$947 \$0$14 TOP_N\x7cVINN 8.664e-15
* device instance $948 r0 *1 0,0 sky130_fd_pr__model__cap_mim
C$948 \$0$5 TOP_P\x7cVINP 8.664e-15
* device instance $949 r0 *1 0,0 sky130_fd_pr__model__cap_mim
C$949 \$0$8 TOP_P\x7cVINP 8.664e-15
* device instance $950 r0 *1 0,0 sky130_fd_pr__model__cap_mim
C$950 \$0$17 TOP_N\x7cVINN 8.664e-15
* device instance $951 r0 *1 0,0 sky130_fd_pr__model__cap_mim
C$951 \$0$8 TOP_P\x7cVINP 8.664e-15
* device instance $952 r0 *1 0,0 sky130_fd_pr__model__cap_mim
C$952 \$0$17 TOP_N\x7cVINN 8.664e-15
* device instance $953 r0 *1 0,0 sky130_fd_pr__model__cap_mim
C$953 \$0$8 TOP_P\x7cVINP 8.664e-15
* device instance $954 r0 *1 0,0 sky130_fd_pr__model__cap_mim
C$954 \$0$17 TOP_N\x7cVINN 8.664e-15
* device instance $955 r0 *1 0,0 sky130_fd_pr__model__cap_mim
C$955 \$0$8 TOP_P\x7cVINP 8.664e-15
* device instance $956 r0 *1 0,0 sky130_fd_pr__model__cap_mim
C$956 \$0$17 TOP_N\x7cVINN 8.664e-15
* device instance $957 r0 *1 0,0 sky130_fd_pr__model__cap_mim
C$957 \$0$17 TOP_N\x7cVINN 8.664e-15
* device instance $958 r0 *1 0,0 sky130_fd_pr__model__cap_mim
C$958 \$0$8 TOP_P\x7cVINP 8.664e-15
* device instance $959 r0 *1 0,0 sky130_fd_pr__model__cap_mim
C$959 \$0$17 TOP_N\x7cVINN 8.664e-15
* device instance $960 r0 *1 0,0 sky130_fd_pr__model__cap_mim
C$960 \$0$8 TOP_P\x7cVINP 8.664e-15
* device instance $961 r0 *1 0,0 sky130_fd_pr__model__cap_mim
C$961 \$0$17 TOP_N\x7cVINN 8.664e-15
* device instance $962 r0 *1 0,0 sky130_fd_pr__model__cap_mim
C$962 \$0$8 TOP_P\x7cVINP 8.664e-15
* device instance $963 r0 *1 0,0 sky130_fd_pr__model__cap_mim
C$963 \$0$17 TOP_N\x7cVINN 8.664e-15
* device instance $964 r0 *1 0,0 sky130_fd_pr__model__cap_mim
C$964 \$0$8 TOP_P\x7cVINP 8.664e-15
* device instance $965 r0 *1 0,0 sky130_fd_pr__model__cap_mim
C$965 \$0$7 TOP_P\x7cVINP 8.664e-15
* device instance $966 r0 *1 0,0 sky130_fd_pr__model__cap_mim
C$966 \$0$16 TOP_N\x7cVINN 8.664e-15
* device instance $967 r0 *1 0,0 sky130_fd_pr__model__cap_mim
C$967 \$0$7 TOP_P\x7cVINP 8.664e-15
* device instance $968 r0 *1 0,0 sky130_fd_pr__model__cap_mim
C$968 \$0$16 TOP_N\x7cVINN 8.664e-15
* device instance $969 r0 *1 0,0 sky130_fd_pr__model__cap_mim
C$969 \$0$7 TOP_P\x7cVINP 8.664e-15
* device instance $970 r0 *1 0,0 sky130_fd_pr__model__cap_mim
C$970 \$0$16 TOP_N\x7cVINN 8.664e-15
* device instance $971 r0 *1 0,0 sky130_fd_pr__model__cap_mim
C$971 \$0$7 TOP_P\x7cVINP 8.664e-15
* device instance $972 r0 *1 0,0 sky130_fd_pr__model__cap_mim
C$972 \$0$16 TOP_N\x7cVINN 8.664e-15
* device instance $973 r0 *1 0,0 sky130_fd_pr__model__cap_mim
C$973 \$0$16 TOP_N\x7cVINN 8.664e-15
* device instance $974 r0 *1 0,0 sky130_fd_pr__model__cap_mim
C$974 \$0$7 TOP_P\x7cVINP 8.664e-15
* device instance $975 r0 *1 0,0 sky130_fd_pr__model__cap_mim
C$975 \$0$16 TOP_N\x7cVINN 8.664e-15
* device instance $976 r0 *1 0,0 sky130_fd_pr__model__cap_mim
C$976 \$0$7 TOP_P\x7cVINP 8.664e-15
* device instance $977 r0 *1 0,0 sky130_fd_pr__model__cap_mim
C$977 \$0$16 TOP_N\x7cVINN 8.664e-15
* device instance $978 r0 *1 0,0 sky130_fd_pr__model__cap_mim
C$978 \$0$7 TOP_P\x7cVINP 8.664e-15
* device instance $979 r0 *1 0,0 sky130_fd_pr__model__cap_mim
C$979 \$0$16 TOP_N\x7cVINN 8.664e-15
* device instance $980 r0 *1 0,0 sky130_fd_pr__model__cap_mim
C$980 \$0$7 TOP_P\x7cVINP 8.664e-15
* device instance $981 r0 *1 0,0 sky130_fd_pr__model__cap_mim
C$981 \$0$8 TOP_P\x7cVINP 8.664e-15
* device instance $982 r0 *1 0,0 sky130_fd_pr__model__cap_mim
C$982 \$0$17 TOP_N\x7cVINN 8.664e-15
* device instance $983 r0 *1 0,0 sky130_fd_pr__model__cap_mim
C$983 \$0$8 TOP_P\x7cVINP 8.664e-15
* device instance $984 r0 *1 0,0 sky130_fd_pr__model__cap_mim
C$984 \$0$17 TOP_N\x7cVINN 8.664e-15
* device instance $985 r0 *1 0,0 sky130_fd_pr__model__cap_mim
C$985 \$0$8 TOP_P\x7cVINP 8.664e-15
* device instance $986 r0 *1 0,0 sky130_fd_pr__model__cap_mim
C$986 \$0$17 TOP_N\x7cVINN 8.664e-15
* device instance $987 r0 *1 0,0 sky130_fd_pr__model__cap_mim
C$987 \$0$8 TOP_P\x7cVINP 8.664e-15
* device instance $988 r0 *1 0,0 sky130_fd_pr__model__cap_mim
C$988 \$0$17 TOP_N\x7cVINN 8.664e-15
* device instance $989 r0 *1 0,0 sky130_fd_pr__model__cap_mim
C$989 \$0$17 TOP_N\x7cVINN 8.664e-15
* device instance $990 r0 *1 0,0 sky130_fd_pr__model__cap_mim
C$990 \$0$8 TOP_P\x7cVINP 8.664e-15
* device instance $991 r0 *1 0,0 sky130_fd_pr__model__cap_mim
C$991 \$0$17 TOP_N\x7cVINN 8.664e-15
* device instance $992 r0 *1 0,0 sky130_fd_pr__model__cap_mim
C$992 \$0$8 TOP_P\x7cVINP 8.664e-15
* device instance $993 r0 *1 0,0 sky130_fd_pr__model__cap_mim
C$993 \$0$17 TOP_N\x7cVINN 8.664e-15
* device instance $994 r0 *1 0,0 sky130_fd_pr__model__cap_mim
C$994 \$0$8 TOP_P\x7cVINP 8.664e-15
* device instance $995 r0 *1 0,0 sky130_fd_pr__model__cap_mim
C$995 \$0$17 TOP_N\x7cVINN 8.664e-15
* device instance $996 r0 *1 0,0 sky130_fd_pr__model__cap_mim
C$996 \$0$8 TOP_P\x7cVINP 8.664e-15
* device instance $997 r0 *1 0,0 sky130_fd_pr__model__cap_mim
C$997 \$0$6 TOP_P\x7cVINP 8.664e-15
* device instance $998 r0 *1 0,0 sky130_fd_pr__model__cap_mim
C$998 \$0$15 TOP_N\x7cVINN 8.664e-15
* device instance $999 r0 *1 0,0 sky130_fd_pr__model__cap_mim
C$999 \$0$6 TOP_P\x7cVINP 8.664e-15
* device instance $1000 r0 *1 0,0 sky130_fd_pr__model__cap_mim
C$1000 \$0$15 TOP_N\x7cVINN 8.664e-15
* device instance $1001 r0 *1 0,0 sky130_fd_pr__model__cap_mim
C$1001 \$0$6 TOP_P\x7cVINP 8.664e-15
* device instance $1002 r0 *1 0,0 sky130_fd_pr__model__cap_mim
C$1002 \$0$15 TOP_N\x7cVINN 8.664e-15
* device instance $1003 r0 *1 0,0 sky130_fd_pr__model__cap_mim
C$1003 \$0$6 TOP_P\x7cVINP 8.664e-15
* device instance $1004 r0 *1 0,0 sky130_fd_pr__model__cap_mim
C$1004 \$0$15 TOP_N\x7cVINN 8.664e-15
* device instance $1005 r0 *1 0,0 sky130_fd_pr__model__cap_mim
C$1005 \$0$15 TOP_N\x7cVINN 8.664e-15
* device instance $1006 r0 *1 0,0 sky130_fd_pr__model__cap_mim
C$1006 \$0$6 TOP_P\x7cVINP 8.664e-15
* device instance $1007 r0 *1 0,0 sky130_fd_pr__model__cap_mim
C$1007 \$0$15 TOP_N\x7cVINN 8.664e-15
* device instance $1008 r0 *1 0,0 sky130_fd_pr__model__cap_mim
C$1008 \$0$6 TOP_P\x7cVINP 8.664e-15
* device instance $1009 r0 *1 0,0 sky130_fd_pr__model__cap_mim
C$1009 \$0$15 TOP_N\x7cVINN 8.664e-15
* device instance $1010 r0 *1 0,0 sky130_fd_pr__model__cap_mim
C$1010 \$0$6 TOP_P\x7cVINP 8.664e-15
* device instance $1011 r0 *1 0,0 sky130_fd_pr__model__cap_mim
C$1011 \$0$15 TOP_N\x7cVINN 8.664e-15
* device instance $1012 r0 *1 0,0 sky130_fd_pr__model__cap_mim
C$1012 \$0$6 TOP_P\x7cVINP 8.664e-15
* device instance $1013 r0 *1 0,0 sky130_fd_pr__model__cap_mim
C$1013 \$0$8 TOP_P\x7cVINP 8.664e-15
* device instance $1014 r0 *1 0,0 sky130_fd_pr__model__cap_mim
C$1014 \$0$17 TOP_N\x7cVINN 8.664e-15
* device instance $1015 r0 *1 0,0 sky130_fd_pr__model__cap_mim
C$1015 \$0$8 TOP_P\x7cVINP 8.664e-15
* device instance $1016 r0 *1 0,0 sky130_fd_pr__model__cap_mim
C$1016 \$0$17 TOP_N\x7cVINN 8.664e-15
* device instance $1017 r0 *1 0,0 sky130_fd_pr__model__cap_mim
C$1017 \$0$8 TOP_P\x7cVINP 8.664e-15
* device instance $1018 r0 *1 0,0 sky130_fd_pr__model__cap_mim
C$1018 \$0$17 TOP_N\x7cVINN 8.664e-15
* device instance $1019 r0 *1 0,0 sky130_fd_pr__model__cap_mim
C$1019 \$0$8 TOP_P\x7cVINP 8.664e-15
* device instance $1020 r0 *1 0,0 sky130_fd_pr__model__cap_mim
C$1020 \$0$17 TOP_N\x7cVINN 8.664e-15
* device instance $1021 r0 *1 0,0 sky130_fd_pr__model__cap_mim
C$1021 \$0$17 TOP_N\x7cVINN 8.664e-15
* device instance $1022 r0 *1 0,0 sky130_fd_pr__model__cap_mim
C$1022 \$0$8 TOP_P\x7cVINP 8.664e-15
* device instance $1023 r0 *1 0,0 sky130_fd_pr__model__cap_mim
C$1023 \$0$17 TOP_N\x7cVINN 8.664e-15
* device instance $1024 r0 *1 0,0 sky130_fd_pr__model__cap_mim
C$1024 \$0$8 TOP_P\x7cVINP 8.664e-15
* device instance $1025 r0 *1 0,0 sky130_fd_pr__model__cap_mim
C$1025 \$0$17 TOP_N\x7cVINN 8.664e-15
* device instance $1026 r0 *1 0,0 sky130_fd_pr__model__cap_mim
C$1026 \$0$8 TOP_P\x7cVINP 8.664e-15
* device instance $1027 r0 *1 0,0 sky130_fd_pr__model__cap_mim
C$1027 \$0$17 TOP_N\x7cVINN 8.664e-15
* device instance $1028 r0 *1 0,0 sky130_fd_pr__model__cap_mim
C$1028 \$0$8 TOP_P\x7cVINP 8.664e-15
* device instance $1029 r0 *1 0,0 sky130_fd_pr__model__cap_mim
C$1029 \$0$7 TOP_P\x7cVINP 8.664e-15
* device instance $1030 r0 *1 0,0 sky130_fd_pr__model__cap_mim
C$1030 \$0$16 TOP_N\x7cVINN 8.664e-15
* device instance $1031 r0 *1 0,0 sky130_fd_pr__model__cap_mim
C$1031 \$0$7 TOP_P\x7cVINP 8.664e-15
* device instance $1032 r0 *1 0,0 sky130_fd_pr__model__cap_mim
C$1032 \$0$16 TOP_N\x7cVINN 8.664e-15
* device instance $1033 r0 *1 0,0 sky130_fd_pr__model__cap_mim
C$1033 \$0$7 TOP_P\x7cVINP 8.664e-15
* device instance $1034 r0 *1 0,0 sky130_fd_pr__model__cap_mim
C$1034 \$0$16 TOP_N\x7cVINN 8.664e-15
* device instance $1035 r0 *1 0,0 sky130_fd_pr__model__cap_mim
C$1035 \$0$7 TOP_P\x7cVINP 8.664e-15
* device instance $1036 r0 *1 0,0 sky130_fd_pr__model__cap_mim
C$1036 \$0$16 TOP_N\x7cVINN 8.664e-15
* device instance $1037 r0 *1 0,0 sky130_fd_pr__model__cap_mim
C$1037 \$0$16 TOP_N\x7cVINN 8.664e-15
* device instance $1038 r0 *1 0,0 sky130_fd_pr__model__cap_mim
C$1038 \$0$7 TOP_P\x7cVINP 8.664e-15
* device instance $1039 r0 *1 0,0 sky130_fd_pr__model__cap_mim
C$1039 \$0$16 TOP_N\x7cVINN 8.664e-15
* device instance $1040 r0 *1 0,0 sky130_fd_pr__model__cap_mim
C$1040 \$0$7 TOP_P\x7cVINP 8.664e-15
* device instance $1041 r0 *1 0,0 sky130_fd_pr__model__cap_mim
C$1041 \$0$16 TOP_N\x7cVINN 8.664e-15
* device instance $1042 r0 *1 0,0 sky130_fd_pr__model__cap_mim
C$1042 \$0$7 TOP_P\x7cVINP 8.664e-15
* device instance $1043 r0 *1 0,0 sky130_fd_pr__model__cap_mim
C$1043 \$0$16 TOP_N\x7cVINN 8.664e-15
* device instance $1044 r0 *1 0,0 sky130_fd_pr__model__cap_mim
C$1044 \$0$7 TOP_P\x7cVINP 8.664e-15
* device instance $1045 r0 *1 0,0 sky130_fd_pr__model__cap_mim
C$1045 \$0$8 TOP_P\x7cVINP 8.664e-15
* device instance $1046 r0 *1 0,0 sky130_fd_pr__model__cap_mim
C$1046 \$0$17 TOP_N\x7cVINN 8.664e-15
* device instance $1047 r0 *1 0,0 sky130_fd_pr__model__cap_mim
C$1047 \$0$8 TOP_P\x7cVINP 8.664e-15
* device instance $1048 r0 *1 0,0 sky130_fd_pr__model__cap_mim
C$1048 \$0$17 TOP_N\x7cVINN 8.664e-15
* device instance $1049 r0 *1 0,0 sky130_fd_pr__model__cap_mim
C$1049 \$0$8 TOP_P\x7cVINP 8.664e-15
* device instance $1050 r0 *1 0,0 sky130_fd_pr__model__cap_mim
C$1050 \$0$17 TOP_N\x7cVINN 8.664e-15
* device instance $1051 r0 *1 0,0 sky130_fd_pr__model__cap_mim
C$1051 \$0$8 TOP_P\x7cVINP 8.664e-15
* device instance $1052 r0 *1 0,0 sky130_fd_pr__model__cap_mim
C$1052 \$0$17 TOP_N\x7cVINN 8.664e-15
* device instance $1053 r0 *1 0,0 sky130_fd_pr__model__cap_mim
C$1053 \$0$17 TOP_N\x7cVINN 8.664e-15
* device instance $1054 r0 *1 0,0 sky130_fd_pr__model__cap_mim
C$1054 \$0$8 TOP_P\x7cVINP 8.664e-15
* device instance $1055 r0 *1 0,0 sky130_fd_pr__model__cap_mim
C$1055 \$0$17 TOP_N\x7cVINN 8.664e-15
* device instance $1056 r0 *1 0,0 sky130_fd_pr__model__cap_mim
C$1056 \$0$8 TOP_P\x7cVINP 8.664e-15
* device instance $1057 r0 *1 0,0 sky130_fd_pr__model__cap_mim
C$1057 \$0$17 TOP_N\x7cVINN 8.664e-15
* device instance $1058 r0 *1 0,0 sky130_fd_pr__model__cap_mim
C$1058 \$0$8 TOP_P\x7cVINP 8.664e-15
* device instance $1059 r0 *1 0,0 sky130_fd_pr__model__cap_mim
C$1059 \$0$17 TOP_N\x7cVINN 8.664e-15
* device instance $1060 r0 *1 0,0 sky130_fd_pr__model__cap_mim
C$1060 \$0$8 TOP_P\x7cVINP 8.664e-15
.ENDS cdac_array__cdac_array
